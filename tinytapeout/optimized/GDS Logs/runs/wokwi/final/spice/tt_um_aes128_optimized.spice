* NGSPICE file created from tt_um_aes128_optimized.ext - technology: sky130A

* Black-box entry subcircuit for sky130_fd_sc_hd__decap_3 abstract view
.subckt sky130_fd_sc_hd__decap_3 VGND VNB VPB VPWR
.ends

* Black-box entry subcircuit for sky130_fd_sc_hd__tapvpwrvgnd_1 abstract view
.subckt sky130_fd_sc_hd__tapvpwrvgnd_1 VGND VPWR
.ends

* Black-box entry subcircuit for sky130_fd_sc_hd__a22o_2 abstract view
.subckt sky130_fd_sc_hd__a22o_2 A1 A2 B1 B2 VGND VNB VPB VPWR X
.ends

* Black-box entry subcircuit for sky130_fd_sc_hd__and3_2 abstract view
.subckt sky130_fd_sc_hd__and3_2 A B C VGND VNB VPB VPWR X
.ends

* Black-box entry subcircuit for sky130_fd_sc_hd__dfrtp_2 abstract view
.subckt sky130_fd_sc_hd__dfrtp_2 CLK D RESET_B VGND VNB VPB VPWR Q
.ends

* Black-box entry subcircuit for sky130_fd_sc_hd__fill_2 abstract view
.subckt sky130_fd_sc_hd__fill_2 VGND VNB VPB VPWR
.ends

* Black-box entry subcircuit for sky130_fd_sc_hd__fill_1 abstract view
.subckt sky130_fd_sc_hd__fill_1 VGND VNB VPB VPWR
.ends

* Black-box entry subcircuit for sky130_fd_sc_hd__a221o_2 abstract view
.subckt sky130_fd_sc_hd__a221o_2 A1 A2 B1 B2 C1 VGND VNB VPB VPWR X
.ends

* Black-box entry subcircuit for sky130_fd_sc_hd__mux2_1 abstract view
.subckt sky130_fd_sc_hd__mux2_1 A0 A1 S VGND VNB VPB VPWR X
.ends

* Black-box entry subcircuit for sky130_fd_sc_hd__or4_2 abstract view
.subckt sky130_fd_sc_hd__or4_2 A B C D VGND VNB VPB VPWR X
.ends

* Black-box entry subcircuit for sky130_fd_sc_hd__a2bb2o_2 abstract view
.subckt sky130_fd_sc_hd__a2bb2o_2 A1_N A2_N B1 B2 VGND VNB VPB VPWR X
.ends

* Black-box entry subcircuit for sky130_fd_sc_hd__a32o_2 abstract view
.subckt sky130_fd_sc_hd__a32o_2 A1 A2 A3 B1 B2 VGND VNB VPB VPWR X
.ends

* Black-box entry subcircuit for sky130_fd_sc_hd__clkdlybuf4s25_1 abstract view
.subckt sky130_fd_sc_hd__clkdlybuf4s25_1 A VGND VNB VPB VPWR X
.ends

* Black-box entry subcircuit for sky130_fd_sc_hd__dlygate4sd3_1 abstract view
.subckt sky130_fd_sc_hd__dlygate4sd3_1 A VGND VNB VPB VPWR X
.ends

* Black-box entry subcircuit for sky130_fd_sc_hd__buf_4 abstract view
.subckt sky130_fd_sc_hd__buf_4 A VGND VNB VPB VPWR X
.ends

* Black-box entry subcircuit for sky130_fd_sc_hd__or2_2 abstract view
.subckt sky130_fd_sc_hd__or2_2 A B VGND VNB VPB VPWR X
.ends

* Black-box entry subcircuit for sky130_fd_sc_hd__a211o_2 abstract view
.subckt sky130_fd_sc_hd__a211o_2 A1 A2 B1 C1 VGND VNB VPB VPWR X
.ends

* Black-box entry subcircuit for sky130_fd_sc_hd__o22a_2 abstract view
.subckt sky130_fd_sc_hd__o22a_2 A1 A2 B1 B2 VGND VNB VPB VPWR X
.ends

* Black-box entry subcircuit for sky130_fd_sc_hd__nand2_2 abstract view
.subckt sky130_fd_sc_hd__nand2_2 A B VGND VNB VPB VPWR Y
.ends

* Black-box entry subcircuit for sky130_fd_sc_hd__a21o_2 abstract view
.subckt sky130_fd_sc_hd__a21o_2 A1 A2 B1 VGND VNB VPB VPWR X
.ends

* Black-box entry subcircuit for sky130_fd_sc_hd__a31o_2 abstract view
.subckt sky130_fd_sc_hd__a31o_2 A1 A2 A3 B1 VGND VNB VPB VPWR X
.ends

* Black-box entry subcircuit for sky130_fd_sc_hd__inv_2 abstract view
.subckt sky130_fd_sc_hd__inv_2 A VGND VNB VPB VPWR Y
.ends

* Black-box entry subcircuit for sky130_fd_sc_hd__xnor2_2 abstract view
.subckt sky130_fd_sc_hd__xnor2_2 A B VGND VNB VPB VPWR Y
.ends

* Black-box entry subcircuit for sky130_fd_sc_hd__nor2_2 abstract view
.subckt sky130_fd_sc_hd__nor2_2 A B VGND VNB VPB VPWR Y
.ends

* Black-box entry subcircuit for sky130_fd_sc_hd__o221a_2 abstract view
.subckt sky130_fd_sc_hd__o221a_2 A1 A2 B1 B2 C1 VGND VNB VPB VPWR X
.ends

* Black-box entry subcircuit for sky130_fd_sc_hd__o21a_2 abstract view
.subckt sky130_fd_sc_hd__o21a_2 A1 A2 B1 VGND VNB VPB VPWR X
.ends

* Black-box entry subcircuit for sky130_fd_sc_hd__nand3_2 abstract view
.subckt sky130_fd_sc_hd__nand3_2 A B C VGND VNB VPB VPWR Y
.ends

* Black-box entry subcircuit for sky130_fd_sc_hd__o211a_2 abstract view
.subckt sky130_fd_sc_hd__o211a_2 A1 A2 B1 C1 VGND VNB VPB VPWR X
.ends

* Black-box entry subcircuit for sky130_fd_sc_hd__xor2_2 abstract view
.subckt sky130_fd_sc_hd__xor2_2 A B VGND VNB VPB VPWR X
.ends

* Black-box entry subcircuit for sky130_fd_sc_hd__clkbuf_8 abstract view
.subckt sky130_fd_sc_hd__clkbuf_8 A VGND VNB VPB VPWR X
.ends

* Black-box entry subcircuit for sky130_fd_sc_hd__a21bo_2 abstract view
.subckt sky130_fd_sc_hd__a21bo_2 A1 A2 B1_N VGND VNB VPB VPWR X
.ends

* Black-box entry subcircuit for sky130_fd_sc_hd__a21oi_2 abstract view
.subckt sky130_fd_sc_hd__a21oi_2 A1 A2 B1 VGND VNB VPB VPWR Y
.ends

* Black-box entry subcircuit for sky130_fd_sc_hd__and2b_2 abstract view
.subckt sky130_fd_sc_hd__and2b_2 A_N B VGND VNB VPB VPWR X
.ends

* Black-box entry subcircuit for sky130_fd_sc_hd__clkbuf_4 abstract view
.subckt sky130_fd_sc_hd__clkbuf_4 A VGND VNB VPB VPWR X
.ends

* Black-box entry subcircuit for sky130_fd_sc_hd__clkbuf_16 abstract view
.subckt sky130_fd_sc_hd__clkbuf_16 A VGND VNB VPB VPWR X
.ends

* Black-box entry subcircuit for sky130_fd_sc_hd__o211ai_2 abstract view
.subckt sky130_fd_sc_hd__o211ai_2 A1 A2 B1 C1 VGND VNB VPB VPWR Y
.ends

* Black-box entry subcircuit for sky130_fd_sc_hd__buf_2 abstract view
.subckt sky130_fd_sc_hd__buf_2 A VGND VNB VPB VPWR X
.ends

* Black-box entry subcircuit for sky130_fd_sc_hd__diode_2 abstract view
.subckt sky130_fd_sc_hd__diode_2 DIODE VGND VNB VPB VPWR
.ends

* Black-box entry subcircuit for sky130_fd_sc_hd__or3_2 abstract view
.subckt sky130_fd_sc_hd__or3_2 A B C VGND VNB VPB VPWR X
.ends

* Black-box entry subcircuit for sky130_fd_sc_hd__o2bb2a_2 abstract view
.subckt sky130_fd_sc_hd__o2bb2a_2 A1_N A2_N B1 B2 VGND VNB VPB VPWR X
.ends

* Black-box entry subcircuit for sky130_fd_sc_hd__o2111a_2 abstract view
.subckt sky130_fd_sc_hd__o2111a_2 A1 A2 B1 C1 D1 VGND VNB VPB VPWR X
.ends

* Black-box entry subcircuit for sky130_fd_sc_hd__or3b_2 abstract view
.subckt sky130_fd_sc_hd__or3b_2 A B C_N VGND VNB VPB VPWR X
.ends

* Black-box entry subcircuit for sky130_fd_sc_hd__clkbuf_2 abstract view
.subckt sky130_fd_sc_hd__clkbuf_2 A VGND VNB VPB VPWR X
.ends

* Black-box entry subcircuit for sky130_fd_sc_hd__a41o_2 abstract view
.subckt sky130_fd_sc_hd__a41o_2 A1 A2 A3 A4 B1 VGND VNB VPB VPWR X
.ends

* Black-box entry subcircuit for sky130_fd_sc_hd__a22oi_2 abstract view
.subckt sky130_fd_sc_hd__a22oi_2 A1 A2 B1 B2 VGND VNB VPB VPWR Y
.ends

* Black-box entry subcircuit for sky130_fd_sc_hd__and4_2 abstract view
.subckt sky130_fd_sc_hd__and4_2 A B C D VGND VNB VPB VPWR X
.ends

* Black-box entry subcircuit for sky130_fd_sc_hd__nand4_2 abstract view
.subckt sky130_fd_sc_hd__nand4_2 A B C D VGND VNB VPB VPWR Y
.ends

* Black-box entry subcircuit for sky130_fd_sc_hd__o21ai_2 abstract view
.subckt sky130_fd_sc_hd__o21ai_2 A1 A2 B1 VGND VNB VPB VPWR Y
.ends

* Black-box entry subcircuit for sky130_fd_sc_hd__mux4_2 abstract view
.subckt sky130_fd_sc_hd__mux4_2 A0 A1 A2 A3 S0 S1 VGND VNB VPB VPWR X
.ends

* Black-box entry subcircuit for sky130_fd_sc_hd__and3b_2 abstract view
.subckt sky130_fd_sc_hd__and3b_2 A_N B C VGND VNB VPB VPWR X
.ends

* Black-box entry subcircuit for sky130_fd_sc_hd__and2_2 abstract view
.subckt sky130_fd_sc_hd__and2_2 A B VGND VNB VPB VPWR X
.ends

* Black-box entry subcircuit for sky130_fd_sc_hd__a31oi_2 abstract view
.subckt sky130_fd_sc_hd__a31oi_2 A1 A2 A3 B1 VGND VNB VPB VPWR Y
.ends

* Black-box entry subcircuit for sky130_fd_sc_hd__o32a_2 abstract view
.subckt sky130_fd_sc_hd__o32a_2 A1 A2 A3 B1 B2 VGND VNB VPB VPWR X
.ends

* Black-box entry subcircuit for sky130_fd_sc_hd__a21oi_4 abstract view
.subckt sky130_fd_sc_hd__a21oi_4 A1 A2 B1 VGND VNB VPB VPWR Y
.ends

* Black-box entry subcircuit for sky130_fd_sc_hd__bufinv_16 abstract view
.subckt sky130_fd_sc_hd__bufinv_16 A VGND VNB VPB VPWR Y
.ends

* Black-box entry subcircuit for sky130_fd_sc_hd__nand3b_2 abstract view
.subckt sky130_fd_sc_hd__nand3b_2 A_N B C VGND VNB VPB VPWR Y
.ends

* Black-box entry subcircuit for sky130_fd_sc_hd__nor2_4 abstract view
.subckt sky130_fd_sc_hd__nor2_4 A B VGND VNB VPB VPWR Y
.ends

* Black-box entry subcircuit for sky130_fd_sc_hd__or4b_2 abstract view
.subckt sky130_fd_sc_hd__or4b_2 A B C D_N VGND VNB VPB VPWR X
.ends

* Black-box entry subcircuit for sky130_fd_sc_hd__o2111ai_2 abstract view
.subckt sky130_fd_sc_hd__o2111ai_2 A1 A2 B1 C1 D1 VGND VNB VPB VPWR Y
.ends

* Black-box entry subcircuit for sky130_fd_sc_hd__nor3_2 abstract view
.subckt sky130_fd_sc_hd__nor3_2 A B C VGND VNB VPB VPWR Y
.ends

* Black-box entry subcircuit for sky130_fd_sc_hd__and4b_2 abstract view
.subckt sky130_fd_sc_hd__and4b_2 A_N B C D VGND VNB VPB VPWR X
.ends

* Black-box entry subcircuit for sky130_fd_sc_hd__buf_6 abstract view
.subckt sky130_fd_sc_hd__buf_6 A VGND VNB VPB VPWR X
.ends

* Black-box entry subcircuit for sky130_fd_sc_hd__nand2b_2 abstract view
.subckt sky130_fd_sc_hd__nand2b_2 A_N B VGND VNB VPB VPWR Y
.ends

* Black-box entry subcircuit for sky130_fd_sc_hd__conb_1 abstract view
.subckt sky130_fd_sc_hd__conb_1 VGND VNB VPB VPWR HI LO
.ends

* Black-box entry subcircuit for sky130_fd_sc_hd__buf_8 abstract view
.subckt sky130_fd_sc_hd__buf_8 A VGND VNB VPB VPWR X
.ends

* Black-box entry subcircuit for sky130_fd_sc_hd__buf_1 abstract view
.subckt sky130_fd_sc_hd__buf_1 A VGND VNB VPB VPWR X
.ends

* Black-box entry subcircuit for sky130_fd_sc_hd__clkinv_4 abstract view
.subckt sky130_fd_sc_hd__clkinv_4 A VGND VNB VPB VPWR Y
.ends

* Black-box entry subcircuit for sky130_fd_sc_hd__o21ba_2 abstract view
.subckt sky130_fd_sc_hd__o21ba_2 A1 A2 B1_N VGND VNB VPB VPWR X
.ends

* Black-box entry subcircuit for sky130_fd_sc_hd__a211oi_2 abstract view
.subckt sky130_fd_sc_hd__a211oi_2 A1 A2 B1 C1 VGND VNB VPB VPWR Y
.ends

* Black-box entry subcircuit for sky130_fd_sc_hd__or4bb_2 abstract view
.subckt sky130_fd_sc_hd__or4bb_2 A B C_N D_N VGND VNB VPB VPWR X
.ends

* Black-box entry subcircuit for sky130_fd_sc_hd__and4bb_2 abstract view
.subckt sky130_fd_sc_hd__and4bb_2 A_N B_N C D VGND VNB VPB VPWR X
.ends

* Black-box entry subcircuit for sky130_fd_sc_hd__xnor2_4 abstract view
.subckt sky130_fd_sc_hd__xnor2_4 A B VGND VNB VPB VPWR Y
.ends

* Black-box entry subcircuit for sky130_fd_sc_hd__a311oi_2 abstract view
.subckt sky130_fd_sc_hd__a311oi_2 A1 A2 A3 B1 C1 VGND VNB VPB VPWR Y
.ends

* Black-box entry subcircuit for sky130_fd_sc_hd__o22ai_2 abstract view
.subckt sky130_fd_sc_hd__o22ai_2 A1 A2 B1 B2 VGND VNB VPB VPWR Y
.ends

* Black-box entry subcircuit for sky130_fd_sc_hd__nor3_4 abstract view
.subckt sky130_fd_sc_hd__nor3_4 A B C VGND VNB VPB VPWR Y
.ends

* Black-box entry subcircuit for sky130_fd_sc_hd__dfstp_2 abstract view
.subckt sky130_fd_sc_hd__dfstp_2 CLK D SET_B VGND VNB VPB VPWR Q
.ends

* Black-box entry subcircuit for sky130_fd_sc_hd__nor4_2 abstract view
.subckt sky130_fd_sc_hd__nor4_2 A B C D VGND VNB VPB VPWR Y
.ends

.subckt tt_um_aes128_optimized VGND VPWR clk ena rst_n ui_in[0] ui_in[1] ui_in[2]
+ ui_in[3] ui_in[4] ui_in[5] ui_in[6] ui_in[7] uio_in[0] uio_in[1] uio_in[2] uio_in[3]
+ uio_in[4] uio_in[5] uio_in[6] uio_in[7] uio_oe[0] uio_oe[1] uio_oe[2] uio_oe[3]
+ uio_oe[4] uio_oe[5] uio_oe[6] uio_oe[7] uio_out[0] uio_out[1] uio_out[2] uio_out[3]
+ uio_out[4] uio_out[5] uio_out[6] uio_out[7] uo_out[0] uo_out[1] uo_out[2] uo_out[3]
+ uo_out[4] uo_out[5] uo_out[6] uo_out[7]
XFILLER_80_1254 VGND VGND VPWR VPWR sky130_fd_sc_hd__decap_3
XTAP_TAPCELL_ROW_52_1564 VGND VPWR sky130_fd_sc_hd__tapvpwrvgnd_1
XFILLER_80_1276 VGND VGND VPWR VPWR sky130_fd_sc_hd__decap_3
XFILLER_45_1396 VGND VGND VPWR VPWR sky130_fd_sc_hd__decap_3
XFILLER_80_1298 VGND VGND VPWR VPWR sky130_fd_sc_hd__decap_3
X_3155_ _6081_/A _7029_/Q _7037_/Q _3207_/B2 VGND VGND VPWR VPWR _3155_/X sky130_fd_sc_hd__a22o_2
XFILLER_27_439 VGND VGND VPWR VPWR sky130_fd_sc_hd__decap_3
XFILLER_39_299 VGND VGND VPWR VPWR sky130_fd_sc_hd__decap_3
X_3086_ _5506_/A _4428_/A _5512_/A VGND VGND VPWR VPWR _7085_/D sky130_fd_sc_hd__and3_2
XFILLER_36_951 VGND VGND VPWR VPWR sky130_fd_sc_hd__decap_3
XTAP_TAPCELL_ROW_65_1903 VGND VPWR sky130_fd_sc_hd__tapvpwrvgnd_1
XFILLER_70_718 VGND VGND VPWR VPWR sky130_fd_sc_hd__decap_3
X_6914_ _7050_/CLK _6914_/D wire652/X VGND VGND VPWR VPWR _6914_/Q sky130_fd_sc_hd__dfrtp_2
XFILLER_78_1161 VGND VGND VPWR VPWR sky130_fd_sc_hd__decap_3
XFILLER_51_921 VGND VGND VPWR VPWR sky130_fd_sc_hd__decap_3
XFILLER_78_1194 VGND VGND VPWR VPWR sky130_fd_sc_hd__decap_3
XTAP_TAPCELL_ROW_18_670 VGND VPWR sky130_fd_sc_hd__tapvpwrvgnd_1
XTAP_TAPCELL_ROW_18_681 VGND VPWR sky130_fd_sc_hd__tapvpwrvgnd_1
X_6845_ _7034_/CLK _6845_/D fanout685/X VGND VGND VPWR VPWR _6845_/Q sky130_fd_sc_hd__dfrtp_2
XFILLER_35_1009 VGND VGND VPWR VPWR sky130_fd_sc_hd__decap_3
XFILLER_52_29 VGND VGND VPWR VPWR sky130_fd_sc_hd__fill_2
XFILLER_17_1410 VGND VGND VPWR VPWR sky130_fd_sc_hd__decap_3
X_6776_ _7064_/CLK _6776_/D load_slew720/X VGND VGND VPWR VPWR _6776_/Q sky130_fd_sc_hd__dfrtp_2
XFILLER_22_166 VGND VGND VPWR VPWR sky130_fd_sc_hd__decap_3
XFILLER_50_475 VGND VGND VPWR VPWR sky130_fd_sc_hd__fill_1
XFILLER_51_998 VGND VGND VPWR VPWR sky130_fd_sc_hd__decap_3
XFILLER_52_1312 VGND VGND VPWR VPWR sky130_fd_sc_hd__decap_3
XFILLER_17_1443 VGND VGND VPWR VPWR sky130_fd_sc_hd__decap_3
XFILLER_52_1323 VGND VGND VPWR VPWR sky130_fd_sc_hd__decap_3
X_3988_ _3346_/X _4583_/B2 _4584_/A2 _6870_/Q _4092_/C1 VGND VGND VPWR VPWR _3988_/X
+ sky130_fd_sc_hd__a221o_2
X_5727_ _5902_/A0 _5727_/A1 _5730_/S VGND VGND VPWR VPWR _6774_/D sky130_fd_sc_hd__mux2_1
XFILLER_13_1307 VGND VGND VPWR VPWR sky130_fd_sc_hd__decap_3
XFILLER_52_1356 VGND VGND VPWR VPWR sky130_fd_sc_hd__decap_3
X_5658_ _7068_/Q _5658_/B _5731_/B _5703_/B VGND VGND VPWR VPWR _5665_/S sky130_fd_sc_hd__or4_2
XTAP_TAPCELL_ROW_59_1729 VGND VPWR sky130_fd_sc_hd__tapvpwrvgnd_1
X_4609_ _4738_/A _4190_/X _4658_/S _6544_/Q VGND VGND VPWR VPWR _4609_/X sky130_fd_sc_hd__a2bb2o_2
XFILLER_50_1091 VGND VGND VPWR VPWR sky130_fd_sc_hd__fill_1
X_5589_ _5577_/A _5589_/A2 _5589_/A3 _5592_/B1 _5589_/B2 VGND VGND VPWR VPWR _6662_/D
+ sky130_fd_sc_hd__a32o_2
XFILLER_2_505 VGND VGND VPWR VPWR sky130_fd_sc_hd__fill_1
XFILLER_2_527 VGND VGND VPWR VPWR sky130_fd_sc_hd__decap_3
XFILLER_77_15 VGND VGND VPWR VPWR sky130_fd_sc_hd__decap_3
XFILLER_46_1149 VGND VGND VPWR VPWR sky130_fd_sc_hd__decap_3
Xfanout820 fanout847/X VGND VGND VPWR VPWR fanout820/X sky130_fd_sc_hd__clkdlybuf4s25_1
XFILLER_77_48 VGND VGND VPWR VPWR sky130_fd_sc_hd__decap_3
XTAP_TAPCELL_ROW_5_321 VGND VPWR sky130_fd_sc_hd__tapvpwrvgnd_1
XFILLER_24_1403 VGND VGND VPWR VPWR sky130_fd_sc_hd__decap_3
XFILLER_63_1452 VGND VGND VPWR VPWR sky130_fd_sc_hd__decap_3
Xfanout842 fanout844/X VGND VGND VPWR VPWR fanout842/X sky130_fd_sc_hd__clkdlybuf4s25_1
XTAP_TAPCELL_ROW_5_332 VGND VPWR sky130_fd_sc_hd__tapvpwrvgnd_1
XFILLER_63_1463 VGND VGND VPWR VPWR sky130_fd_sc_hd__decap_3
XTAP_TAPCELL_ROW_5_343 VGND VPWR sky130_fd_sc_hd__tapvpwrvgnd_1
XFILLER_58_531 VGND VGND VPWR VPWR sky130_fd_sc_hd__fill_1
XFILLER_24_1447 VGND VGND VPWR VPWR sky130_fd_sc_hd__decap_3
XFILLER_19_918 VGND VGND VPWR VPWR sky130_fd_sc_hd__decap_3
XFILLER_46_704 VGND VGND VPWR VPWR sky130_fd_sc_hd__decap_3
Xhold1040 _6109_/Q VGND VGND VPWR VPWR _5956_/A0 sky130_fd_sc_hd__dlygate4sd3_1
XFILLER_18_406 VGND VGND VPWR VPWR sky130_fd_sc_hd__decap_3
Xhold1051 _6163_/Q VGND VGND VPWR VPWR _6010_/A0 sky130_fd_sc_hd__dlygate4sd3_1
XFILLER_58_586 VGND VGND VPWR VPWR sky130_fd_sc_hd__fill_2
Xhold1062 _5977_/X VGND VGND VPWR VPWR _6981_/D sky130_fd_sc_hd__dlygate4sd3_1
XFILLER_58_597 VGND VGND VPWR VPWR sky130_fd_sc_hd__fill_2
Xhold1073 _6699_/Q VGND VGND VPWR VPWR _5642_/A1 sky130_fd_sc_hd__dlygate4sd3_1
XFILLER_45_225 VGND VGND VPWR VPWR sky130_fd_sc_hd__decap_3
XFILLER_2_1232 VGND VGND VPWR VPWR sky130_fd_sc_hd__decap_3
XTAP_TAPCELL_ROW_29_946 VGND VPWR sky130_fd_sc_hd__tapvpwrvgnd_1
XFILLER_45_236 VGND VGND VPWR VPWR sky130_fd_sc_hd__decap_3
Xhold1084 _6155_/Q VGND VGND VPWR VPWR _6002_/A0 sky130_fd_sc_hd__dlygate4sd3_1
XTAP_TAPCELL_ROW_29_957 VGND VPWR sky130_fd_sc_hd__tapvpwrvgnd_1
Xhold1095 _6626_/Q VGND VGND VPWR VPWR _5543_/B1 sky130_fd_sc_hd__dlygate4sd3_1
XFILLER_27_951 VGND VGND VPWR VPWR sky130_fd_sc_hd__fill_1
XFILLER_2_1276 VGND VGND VPWR VPWR sky130_fd_sc_hd__decap_3
XTAP_TAPCELL_ROW_16_607 VGND VPWR sky130_fd_sc_hd__tapvpwrvgnd_1
XFILLER_61_729 VGND VGND VPWR VPWR sky130_fd_sc_hd__decap_3
XTAP_TAPCELL_ROW_16_618 VGND VPWR sky130_fd_sc_hd__tapvpwrvgnd_1
XTAP_TAPCELL_ROW_16_629 VGND VPWR sky130_fd_sc_hd__tapvpwrvgnd_1
XFILLER_57_1245 VGND VGND VPWR VPWR sky130_fd_sc_hd__decap_3
XFILLER_26_494 VGND VGND VPWR VPWR sky130_fd_sc_hd__decap_3
XFILLER_14_645 VGND VGND VPWR VPWR sky130_fd_sc_hd__decap_3
XFILLER_18_1229 VGND VGND VPWR VPWR sky130_fd_sc_hd__decap_3
XFILLER_41_442 VGND VGND VPWR VPWR sky130_fd_sc_hd__decap_3
XFILLER_57_1278 VGND VGND VPWR VPWR sky130_fd_sc_hd__decap_3
XFILLER_57_1289 VGND VGND VPWR VPWR sky130_fd_sc_hd__decap_3
XFILLER_70_1412 VGND VGND VPWR VPWR sky130_fd_sc_hd__decap_3
XFILLER_70_1456 VGND VGND VPWR VPWR sky130_fd_sc_hd__decap_3
XFILLER_31_1407 VGND VGND VPWR VPWR sky130_fd_sc_hd__decap_3
XFILLER_10_862 VGND VGND VPWR VPWR sky130_fd_sc_hd__decap_3
XFILLER_54_9 VGND VGND VPWR VPWR sky130_fd_sc_hd__decap_3
XFILLER_68_1341 VGND VGND VPWR VPWR sky130_fd_sc_hd__decap_3
XFILLER_29_1325 VGND VGND VPWR VPWR sky130_fd_sc_hd__decap_3
XFILLER_64_1205 VGND VGND VPWR VPWR sky130_fd_sc_hd__decap_3
XFILLER_68_1385 VGND VGND VPWR VPWR sky130_fd_sc_hd__decap_3
XFILLER_9_1419 VGND VGND VPWR VPWR sky130_fd_sc_hd__decap_3
XFILLER_3_12 VGND VGND VPWR VPWR sky130_fd_sc_hd__decap_3
XFILLER_64_1238 VGND VGND VPWR VPWR sky130_fd_sc_hd__decap_3
XFILLER_29_1369 VGND VGND VPWR VPWR sky130_fd_sc_hd__decap_3
XFILLER_68_306 VGND VGND VPWR VPWR sky130_fd_sc_hd__fill_2
XFILLER_69_829 VGND VGND VPWR VPWR sky130_fd_sc_hd__decap_3
XFILLER_3_45 VGND VGND VPWR VPWR sky130_fd_sc_hd__decap_3
XFILLER_7_1110 VGND VGND VPWR VPWR sky130_fd_sc_hd__decap_3
XFILLER_7_1121 VGND VGND VPWR VPWR sky130_fd_sc_hd__decap_3
XFILLER_3_78 VGND VGND VPWR VPWR sky130_fd_sc_hd__decap_3
XFILLER_27_1071 VGND VGND VPWR VPWR sky130_fd_sc_hd__decap_3
XTAP_TAPCELL_ROW_69_2003 VGND VPWR sky130_fd_sc_hd__tapvpwrvgnd_1
XFILLER_77_862 VGND VGND VPWR VPWR sky130_fd_sc_hd__decap_3
XFILLER_7_1154 VGND VGND VPWR VPWR sky130_fd_sc_hd__decap_3
XFILLER_67_81 VGND VGND VPWR VPWR sky130_fd_sc_hd__fill_1
XFILLER_3_1018 VGND VGND VPWR VPWR sky130_fd_sc_hd__decap_3
XFILLER_7_1198 VGND VGND VPWR VPWR sky130_fd_sc_hd__decap_3
XFILLER_18_940 VGND VGND VPWR VPWR sky130_fd_sc_hd__decap_3
Xwire29 wire29/A VGND VGND VPWR VPWR uo_out[5] sky130_fd_sc_hd__buf_4
XFILLER_40_1282 VGND VGND VPWR VPWR sky130_fd_sc_hd__decap_3
XFILLER_52_707 VGND VGND VPWR VPWR sky130_fd_sc_hd__decap_3
XFILLER_75_1301 VGND VGND VPWR VPWR sky130_fd_sc_hd__decap_3
XFILLER_24_409 VGND VGND VPWR VPWR sky130_fd_sc_hd__decap_3
X_4960_ _6384_/Q _5222_/B VGND VGND VPWR VPWR _4960_/X sky130_fd_sc_hd__or2_2
XFILLER_18_984 VGND VGND VPWR VPWR sky130_fd_sc_hd__decap_3
XFILLER_45_781 VGND VGND VPWR VPWR sky130_fd_sc_hd__decap_3
XFILLER_75_1334 VGND VGND VPWR VPWR sky130_fd_sc_hd__decap_3
XFILLER_51_228 VGND VGND VPWR VPWR sky130_fd_sc_hd__decap_3
XFILLER_75_1345 VGND VGND VPWR VPWR sky130_fd_sc_hd__decap_3
X_3911_ _3284_/X _4765_/B2 _4766_/A2 _6839_/Q _4092_/C1 VGND VGND VPWR VPWR _3911_/X
+ sky130_fd_sc_hd__a221o_2
XFILLER_17_494 VGND VGND VPWR VPWR sky130_fd_sc_hd__decap_3
X_4891_ _6928_/Q _4898_/A2 _4891_/B1 _4890_/X VGND VGND VPWR VPWR _4891_/X sky130_fd_sc_hd__a211o_2
XFILLER_44_291 VGND VGND VPWR VPWR sky130_fd_sc_hd__decap_3
XFILLER_75_1378 VGND VGND VPWR VPWR sky130_fd_sc_hd__decap_3
XFILLER_36_1329 VGND VGND VPWR VPWR sky130_fd_sc_hd__decap_3
X_6630_ _6819_/CLK _6630_/D wire764/X VGND VGND VPWR VPWR _6630_/Q sky130_fd_sc_hd__dfrtp_2
X_3842_ _6339_/Q _4829_/A _3840_/X _3841_/X VGND VGND VPWR VPWR _4140_/A sky130_fd_sc_hd__o22a_2
XFILLER_60_773 VGND VGND VPWR VPWR sky130_fd_sc_hd__decap_3
XFILLER_20_637 VGND VGND VPWR VPWR sky130_fd_sc_hd__decap_3
X_6561_ _6900_/CLK _6561_/D fanout787/X VGND VGND VPWR VPWR _6561_/Q sky130_fd_sc_hd__dfrtp_2
X_3773_ _6224_/Q _3960_/B _3921_/B1 _6216_/Q _3921_/C1 VGND VGND VPWR VPWR _3773_/X
+ sky130_fd_sc_hd__a221o_2
XTAP_TAPCELL_ROW_41_1254 VGND VPWR sky130_fd_sc_hd__tapvpwrvgnd_1
XTAP_TAPCELL_ROW_41_1265 VGND VPWR sky130_fd_sc_hd__tapvpwrvgnd_1
X_5512_ _5512_/A _5512_/B VGND VGND VPWR VPWR _5514_/B sky130_fd_sc_hd__nand2_2
XTAP_TAPCELL_ROW_41_1276 VGND VPWR sky130_fd_sc_hd__tapvpwrvgnd_1
X_6492_ _7022_/CLK _6492_/D load_slew751/X VGND VGND VPWR VPWR _6492_/Q sky130_fd_sc_hd__dfrtp_2
X_5443_ _5443_/A1 _5479_/A2 _4690_/X VGND VGND VPWR VPWR _6555_/D sky130_fd_sc_hd__a21o_2
XFILLER_69_1138 VGND VGND VPWR VPWR sky130_fd_sc_hd__decap_3
XFILLER_12_1362 VGND VGND VPWR VPWR sky130_fd_sc_hd__decap_3
XFILLER_12_1373 VGND VGND VPWR VPWR sky130_fd_sc_hd__decap_3
X_5374_ _5374_/A1 _5464_/A2 _4253_/X VGND VGND VPWR VPWR _6486_/D sky130_fd_sc_hd__a21o_2
XTAP_TAPCELL_ROW_54_1604 VGND VPWR sky130_fd_sc_hd__tapvpwrvgnd_1
XFILLER_47_1425 VGND VGND VPWR VPWR sky130_fd_sc_hd__decap_3
XTAP_TAPCELL_ROW_54_1615 VGND VPWR sky130_fd_sc_hd__tapvpwrvgnd_1
X_4325_ _6493_/Q _4267_/X _4324_/X wire154/X _4880_/C1 VGND VGND VPWR VPWR _4325_/X
+ sky130_fd_sc_hd__a221o_2
Xfanout138 _4900_/X VGND VGND VPWR VPWR _5353_/S sky130_fd_sc_hd__clkdlybuf4s25_1
X_7044_ _7052_/CLK _7044_/D load_slew805/X VGND VGND VPWR VPWR _7044_/Q sky130_fd_sc_hd__dfrtp_2
XFILLER_80_1040 VGND VGND VPWR VPWR sky130_fd_sc_hd__decap_3
X_4256_ _6262_/Q wire52/X _4253_/X _4255_/X VGND VGND VPWR VPWR _6262_/D sky130_fd_sc_hd__o22a_2
XFILLER_68_851 VGND VGND VPWR VPWR sky130_fd_sc_hd__decap_3
XFILLER_74_309 VGND VGND VPWR VPWR sky130_fd_sc_hd__decap_3
XFILLER_28_704 VGND VGND VPWR VPWR sky130_fd_sc_hd__decap_3
X_3207_ _3212_/A1 _7032_/Q _7040_/Q _3207_/B2 VGND VGND VPWR VPWR _3207_/X sky130_fd_sc_hd__a22o_2
X_4187_ _6817_/Q _4781_/A2 _4606_/B1 _4186_/X VGND VGND VPWR VPWR _4187_/X sky130_fd_sc_hd__a211o_2
XFILLER_68_895 VGND VGND VPWR VPWR sky130_fd_sc_hd__decap_3
XFILLER_41_1068 VGND VGND VPWR VPWR sky130_fd_sc_hd__decap_3
X_3138_ _3202_/A _3134_/X _3137_/X _3131_/X VGND VGND VPWR VPWR _3138_/X sky130_fd_sc_hd__a31o_2
XFILLER_55_567 VGND VGND VPWR VPWR sky130_fd_sc_hd__decap_3
X_3069_ _6365_/Q VGND VGND VPWR VPWR _3069_/Y sky130_fd_sc_hd__inv_2
XFILLER_24_910 VGND VGND VPWR VPWR sky130_fd_sc_hd__decap_3
XFILLER_42_206 VGND VGND VPWR VPWR sky130_fd_sc_hd__decap_3
XFILLER_36_781 VGND VGND VPWR VPWR sky130_fd_sc_hd__decap_3
XFILLER_42_228 VGND VGND VPWR VPWR sky130_fd_sc_hd__decap_3
XFILLER_63_39 VGND VGND VPWR VPWR sky130_fd_sc_hd__decap_3
XFILLER_24_965 VGND VGND VPWR VPWR sky130_fd_sc_hd__decap_3
XFILLER_54_1418 VGND VGND VPWR VPWR sky130_fd_sc_hd__decap_3
XFILLER_51_751 VGND VGND VPWR VPWR sky130_fd_sc_hd__decap_3
XFILLER_54_1429 VGND VGND VPWR VPWR sky130_fd_sc_hd__decap_3
XFILLER_24_987 VGND VGND VPWR VPWR sky130_fd_sc_hd__decap_3
X_6828_ _7015_/CLK _6828_/D load_slew801/X VGND VGND VPWR VPWR _6828_/Q sky130_fd_sc_hd__dfrtp_2
XFILLER_11_637 VGND VGND VPWR VPWR sky130_fd_sc_hd__decap_3
XFILLER_10_103 VGND VGND VPWR VPWR sky130_fd_sc_hd__decap_3
XFILLER_52_1120 VGND VGND VPWR VPWR sky130_fd_sc_hd__fill_2
XFILLER_17_1251 VGND VGND VPWR VPWR sky130_fd_sc_hd__decap_3
X_6759_ _6991_/CLK _6759_/D wire796/X VGND VGND VPWR VPWR _6759_/Q sky130_fd_sc_hd__dfrtp_2
XFILLER_17_1284 VGND VGND VPWR VPWR sky130_fd_sc_hd__decap_3
XFILLER_12_21 VGND VGND VPWR VPWR sky130_fd_sc_hd__decap_3
XFILLER_17_1295 VGND VGND VPWR VPWR sky130_fd_sc_hd__decap_3
XFILLER_52_1197 VGND VGND VPWR VPWR sky130_fd_sc_hd__decap_3
XFILLER_3_803 VGND VGND VPWR VPWR sky130_fd_sc_hd__decap_3
XFILLER_30_1462 VGND VGND VPWR VPWR sky130_fd_sc_hd__decap_3
XFILLER_3_836 VGND VGND VPWR VPWR sky130_fd_sc_hd__decap_3
XFILLER_3_847 VGND VGND VPWR VPWR sky130_fd_sc_hd__decap_3
XFILLER_2_357 VGND VGND VPWR VPWR sky130_fd_sc_hd__decap_3
XFILLER_2_368 VGND VGND VPWR VPWR sky130_fd_sc_hd__decap_3
XFILLER_78_648 VGND VGND VPWR VPWR sky130_fd_sc_hd__fill_1
XFILLER_24_1200 VGND VGND VPWR VPWR sky130_fd_sc_hd__decap_3
XFILLER_8_1441 VGND VGND VPWR VPWR sky130_fd_sc_hd__decap_3
XFILLER_63_1260 VGND VGND VPWR VPWR sky130_fd_sc_hd__decap_3
XFILLER_28_1391 VGND VGND VPWR VPWR sky130_fd_sc_hd__decap_3
Xfanout661 fanout665/X VGND VGND VPWR VPWR fanout661/X sky130_fd_sc_hd__clkdlybuf4s25_1
Xfanout672 fanout682/X VGND VGND VPWR VPWR fanout672/X sky130_fd_sc_hd__clkdlybuf4s25_1
XFILLER_19_704 VGND VGND VPWR VPWR sky130_fd_sc_hd__decap_3
XFILLER_24_1244 VGND VGND VPWR VPWR sky130_fd_sc_hd__decap_3
Xfanout683 fanout698/X VGND VGND VPWR VPWR fanout683/X sky130_fd_sc_hd__clkdlybuf4s25_1
XFILLER_74_810 VGND VGND VPWR VPWR sky130_fd_sc_hd__fill_2
XFILLER_4_1338 VGND VGND VPWR VPWR sky130_fd_sc_hd__decap_3
XFILLER_24_1288 VGND VGND VPWR VPWR sky130_fd_sc_hd__decap_3
XFILLER_18_236 VGND VGND VPWR VPWR sky130_fd_sc_hd__decap_3
XFILLER_46_545 VGND VGND VPWR VPWR sky130_fd_sc_hd__decap_3
XFILLER_59_1307 VGND VGND VPWR VPWR sky130_fd_sc_hd__decap_3
XFILLER_2_1040 VGND VGND VPWR VPWR sky130_fd_sc_hd__decap_3
XFILLER_46_567 VGND VGND VPWR VPWR sky130_fd_sc_hd__decap_3
XFILLER_2_1073 VGND VGND VPWR VPWR sky130_fd_sc_hd__decap_3
XFILLER_14_464 VGND VGND VPWR VPWR sky130_fd_sc_hd__decap_3
XFILLER_42_773 VGND VGND VPWR VPWR sky130_fd_sc_hd__decap_3
XFILLER_18_1037 VGND VGND VPWR VPWR sky130_fd_sc_hd__decap_3
XFILLER_41_261 VGND VGND VPWR VPWR sky130_fd_sc_hd__fill_1
XFILLER_14_486 VGND VGND VPWR VPWR sky130_fd_sc_hd__decap_3
XFILLER_70_1220 VGND VGND VPWR VPWR sky130_fd_sc_hd__decap_3
XFILLER_35_1340 VGND VGND VPWR VPWR sky130_fd_sc_hd__decap_3
XFILLER_35_1351 VGND VGND VPWR VPWR sky130_fd_sc_hd__decap_3
XFILLER_70_1253 VGND VGND VPWR VPWR sky130_fd_sc_hd__decap_3
XFILLER_70_1264 VGND VGND VPWR VPWR sky130_fd_sc_hd__decap_3
XFILLER_35_1384 VGND VGND VPWR VPWR sky130_fd_sc_hd__decap_3
XFILLER_10_670 VGND VGND VPWR VPWR sky130_fd_sc_hd__decap_3
XFILLER_70_1297 VGND VGND VPWR VPWR sky130_fd_sc_hd__decap_3
XFILLER_31_1248 VGND VGND VPWR VPWR sky130_fd_sc_hd__decap_3
XFILLER_5_151 VGND VGND VPWR VPWR sky130_fd_sc_hd__fill_2
XFILLER_52_6 VGND VGND VPWR VPWR sky130_fd_sc_hd__decap_3
XFILLER_5_184 VGND VGND VPWR VPWR sky130_fd_sc_hd__decap_3
XFILLER_29_1111 VGND VGND VPWR VPWR sky130_fd_sc_hd__fill_1
XFILLER_68_1160 VGND VGND VPWR VPWR sky130_fd_sc_hd__decap_3
XFILLER_68_1193 VGND VGND VPWR VPWR sky130_fd_sc_hd__decap_3
XFILLER_9_1216 VGND VGND VPWR VPWR sky130_fd_sc_hd__decap_3
XFILLER_64_1035 VGND VGND VPWR VPWR sky130_fd_sc_hd__fill_1
XFILLER_29_1166 VGND VGND VPWR VPWR sky130_fd_sc_hd__fill_1
XFILLER_78_80 VGND VGND VPWR VPWR sky130_fd_sc_hd__decap_3
X_4110_ _4270_/A _4258_/B VGND VGND VPWR VPWR _4111_/B sky130_fd_sc_hd__xnor2_2
X_5090_ _5276_/A _5091_/B _5278_/A2 VGND VGND VPWR VPWR _5090_/X sky130_fd_sc_hd__a21o_2
XFILLER_42_1300 VGND VGND VPWR VPWR sky130_fd_sc_hd__decap_3
XFILLER_56_309 VGND VGND VPWR VPWR sky130_fd_sc_hd__decap_3
X_4041_ wire69/X _4645_/A VGND VGND VPWR VPWR _4041_/Y sky130_fd_sc_hd__nor2_2
XTAP_TAPCELL_ROW_34_1080 VGND VPWR sky130_fd_sc_hd__tapvpwrvgnd_1
XFILLER_42_1344 VGND VGND VPWR VPWR sky130_fd_sc_hd__decap_3
XFILLER_37_501 VGND VGND VPWR VPWR sky130_fd_sc_hd__decap_3
XTAP_TAPCELL_ROW_34_1091 VGND VPWR sky130_fd_sc_hd__tapvpwrvgnd_1
XFILLER_42_1388 VGND VGND VPWR VPWR sky130_fd_sc_hd__decap_3
XFILLER_77_1407 VGND VGND VPWR VPWR sky130_fd_sc_hd__decap_3
XFILLER_37_589 VGND VGND VPWR VPWR sky130_fd_sc_hd__decap_3
XFILLER_24_206 VGND VGND VPWR VPWR sky130_fd_sc_hd__decap_3
X_5992_ hold919/X _6996_/Q _6031_/S VGND VGND VPWR VPWR _5992_/X sky130_fd_sc_hd__mux2_1
XFILLER_80_835 VGND VGND VPWR VPWR sky130_fd_sc_hd__decap_3
XTAP_TAPCELL_ROW_47_1430 VGND VPWR sky130_fd_sc_hd__tapvpwrvgnd_1
X_4943_ _6349_/Q _4942_/X _4943_/S VGND VGND VPWR VPWR _6349_/D sky130_fd_sc_hd__mux2_1
XFILLER_75_1142 VGND VGND VPWR VPWR sky130_fd_sc_hd__decap_3
XFILLER_75_1175 VGND VGND VPWR VPWR sky130_fd_sc_hd__fill_1
XTAP_TAPCELL_ROW_43_1316 VGND VPWR sky130_fd_sc_hd__tapvpwrvgnd_1
XFILLER_75_1186 VGND VGND VPWR VPWR sky130_fd_sc_hd__decap_3
X_4874_ _4874_/A1 _4871_/X _4872_/Y _4873_/X _4874_/C1 VGND VGND VPWR VPWR _4874_/X
+ sky130_fd_sc_hd__o221a_2
XTAP_TAPCELL_ROW_43_1327 VGND VPWR sky130_fd_sc_hd__tapvpwrvgnd_1
X_6613_ _6617_/CLK _6613_/D load_slew732/X VGND VGND VPWR VPWR _6613_/Q sky130_fd_sc_hd__dfrtp_2
XFILLER_32_283 VGND VGND VPWR VPWR sky130_fd_sc_hd__decap_3
XFILLER_53_1440 VGND VGND VPWR VPWR sky130_fd_sc_hd__decap_3
X_3825_ _3827_/B _3827_/C VGND VGND VPWR VPWR _3938_/A sky130_fd_sc_hd__nand2_2
XFILLER_20_434 VGND VGND VPWR VPWR sky130_fd_sc_hd__decap_3
XFILLER_21_968 VGND VGND VPWR VPWR sky130_fd_sc_hd__fill_2
XFILLER_14_1424 VGND VGND VPWR VPWR sky130_fd_sc_hd__decap_3
XFILLER_14_1435 VGND VGND VPWR VPWR sky130_fd_sc_hd__decap_3
X_6544_ _6888_/CLK _6544_/D load_slew705/X VGND VGND VPWR VPWR _6544_/Q sky130_fd_sc_hd__dfrtp_2
X_3756_ _3757_/A _3757_/B _3884_/A VGND VGND VPWR VPWR _3758_/A sky130_fd_sc_hd__a21o_2
XTAP_TAPCELL_ROW_31_996 VGND VPWR sky130_fd_sc_hd__tapvpwrvgnd_1
XFILLER_14_1468 VGND VGND VPWR VPWR sky130_fd_sc_hd__fill_1
X_6475_ _7040_/CLK _6475_/D fanout716/X VGND VGND VPWR VPWR _6475_/Q sky130_fd_sc_hd__dfrtp_2
X_3687_ wire26/X _3687_/B VGND VGND VPWR VPWR _3687_/Y sky130_fd_sc_hd__nand2_2
X_5426_ _5426_/A1 _5461_/A2 _4566_/X VGND VGND VPWR VPWR _6538_/D sky130_fd_sc_hd__a21o_2
XFILLER_12_1192 VGND VGND VPWR VPWR sky130_fd_sc_hd__decap_3
XFILLER_0_806 VGND VGND VPWR VPWR sky130_fd_sc_hd__decap_3
XFILLER_47_1233 VGND VGND VPWR VPWR sky130_fd_sc_hd__decap_3
X_5357_ _6471_/Q _5356_/X _5357_/S VGND VGND VPWR VPWR _6471_/D sky130_fd_sc_hd__mux2_1
XFILLER_0_828 VGND VGND VPWR VPWR sky130_fd_sc_hd__decap_3
XFILLER_47_1266 VGND VGND VPWR VPWR sky130_fd_sc_hd__decap_3
X_4308_ _4885_/B1 _4301_/X _4307_/X VGND VGND VPWR VPWR _4308_/X sky130_fd_sc_hd__o21a_2
XPHY_EDGE_ROW_58_Left_139 VGND VGND VPWR VPWR sky130_fd_sc_hd__decap_3
XFILLER_59_125 VGND VGND VPWR VPWR sky130_fd_sc_hd__decap_3
X_5288_ _5354_/S _5288_/B VGND VGND VPWR VPWR _5288_/Y sky130_fd_sc_hd__nand2_2
XFILLER_60_1400 VGND VGND VPWR VPWR sky130_fd_sc_hd__decap_3
X_7027_ _7027_/CLK _7027_/D load_slew845/X VGND VGND VPWR VPWR _7027_/Q sky130_fd_sc_hd__dfrtp_2
XFILLER_47_309 VGND VGND VPWR VPWR sky130_fd_sc_hd__fill_2
XFILLER_59_169 VGND VGND VPWR VPWR sky130_fd_sc_hd__fill_1
X_4239_ _4586_/B _6485_/Q _4257_/S VGND VGND VPWR VPWR _4239_/X sky130_fd_sc_hd__mux2_1
XFILLER_56_810 VGND VGND VPWR VPWR sky130_fd_sc_hd__fill_2
XFILLER_60_1444 VGND VGND VPWR VPWR sky130_fd_sc_hd__decap_3
XFILLER_74_117 VGND VGND VPWR VPWR sky130_fd_sc_hd__decap_3
XFILLER_56_821 VGND VGND VPWR VPWR sky130_fd_sc_hd__decap_3
XFILLER_68_681 VGND VGND VPWR VPWR sky130_fd_sc_hd__fill_2
XFILLER_21_1428 VGND VGND VPWR VPWR sky130_fd_sc_hd__decap_3
XFILLER_74_27 VGND VGND VPWR VPWR sky130_fd_sc_hd__fill_1
XFILLER_74_38 VGND VGND VPWR VPWR sky130_fd_sc_hd__decap_3
XFILLER_56_865 VGND VGND VPWR VPWR sky130_fd_sc_hd__decap_3
XFILLER_16_718 VGND VGND VPWR VPWR sky130_fd_sc_hd__decap_3
XFILLER_3_1360 VGND VGND VPWR VPWR sky130_fd_sc_hd__decap_3
XFILLER_70_312 VGND VGND VPWR VPWR sky130_fd_sc_hd__decap_3
XFILLER_3_1393 VGND VGND VPWR VPWR sky130_fd_sc_hd__decap_3
XFILLER_43_537 VGND VGND VPWR VPWR sky130_fd_sc_hd__decap_3
XFILLER_19_1313 VGND VGND VPWR VPWR sky130_fd_sc_hd__decap_3
XFILLER_58_1362 VGND VGND VPWR VPWR sky130_fd_sc_hd__decap_3
XFILLER_58_1373 VGND VGND VPWR VPWR sky130_fd_sc_hd__decap_3
XFILLER_54_1226 VGND VGND VPWR VPWR sky130_fd_sc_hd__decap_3
XPHY_EDGE_ROW_67_Left_148 VGND VGND VPWR VPWR sky130_fd_sc_hd__decap_3
XFILLER_19_1357 VGND VGND VPWR VPWR sky130_fd_sc_hd__decap_3
XFILLER_24_795 VGND VGND VPWR VPWR sky130_fd_sc_hd__fill_2
XFILLER_12_946 VGND VGND VPWR VPWR sky130_fd_sc_hd__decap_3
XFILLER_54_1259 VGND VGND VPWR VPWR sky130_fd_sc_hd__fill_1
XFILLER_11_434 VGND VGND VPWR VPWR sky130_fd_sc_hd__decap_3
XFILLER_7_405 VGND VGND VPWR VPWR sky130_fd_sc_hd__decap_3
XFILLER_7_449 VGND VGND VPWR VPWR sky130_fd_sc_hd__decap_3
XFILLER_3_600 VGND VGND VPWR VPWR sky130_fd_sc_hd__decap_3
XFILLER_30_1270 VGND VGND VPWR VPWR sky130_fd_sc_hd__decap_3
XFILLER_2_121 VGND VGND VPWR VPWR sky130_fd_sc_hd__decap_3
XFILLER_3_655 VGND VGND VPWR VPWR sky130_fd_sc_hd__decap_3
XFILLER_65_1322 VGND VGND VPWR VPWR sky130_fd_sc_hd__decap_3
XPHY_EDGE_ROW_76_Left_157 VGND VGND VPWR VPWR sky130_fd_sc_hd__decap_3
XFILLER_3_688 VGND VGND VPWR VPWR sky130_fd_sc_hd__decap_3
XFILLER_2_165 VGND VGND VPWR VPWR sky130_fd_sc_hd__decap_3
XFILLER_26_1306 VGND VGND VPWR VPWR sky130_fd_sc_hd__decap_3
XFILLER_26_1317 VGND VGND VPWR VPWR sky130_fd_sc_hd__decap_3
XFILLER_65_1366 VGND VGND VPWR VPWR sky130_fd_sc_hd__decap_3
XFILLER_61_1219 VGND VGND VPWR VPWR sky130_fd_sc_hd__decap_3
XFILLER_65_1399 VGND VGND VPWR VPWR sky130_fd_sc_hd__fill_1
XFILLER_38_309 VGND VGND VPWR VPWR sky130_fd_sc_hd__decap_3
XFILLER_24_1030 VGND VGND VPWR VPWR sky130_fd_sc_hd__decap_3
XFILLER_4_1102 VGND VGND VPWR VPWR sky130_fd_sc_hd__decap_3
XFILLER_19_501 VGND VGND VPWR VPWR sky130_fd_sc_hd__decap_3
XFILLER_8_1282 VGND VGND VPWR VPWR sky130_fd_sc_hd__decap_3
Xfanout480 _4381_/C1 VGND VGND VPWR VPWR _3486_/B sky130_fd_sc_hd__clkdlybuf4s25_1
XFILLER_47_821 VGND VGND VPWR VPWR sky130_fd_sc_hd__decap_3
XFILLER_59_681 VGND VGND VPWR VPWR sky130_fd_sc_hd__decap_3
XFILLER_65_128 VGND VGND VPWR VPWR sky130_fd_sc_hd__decap_3
XFILLER_4_1135 VGND VGND VPWR VPWR sky130_fd_sc_hd__decap_3
XFILLER_48_94 VGND VGND VPWR VPWR sky130_fd_sc_hd__decap_3
XFILLER_19_545 VGND VGND VPWR VPWR sky130_fd_sc_hd__decap_3
XFILLER_0_24 VGND VGND VPWR VPWR sky130_fd_sc_hd__decap_3
XFILLER_0_35 VGND VGND VPWR VPWR sky130_fd_sc_hd__decap_3
XFILLER_4_1179 VGND VGND VPWR VPWR sky130_fd_sc_hd__decap_3
XFILLER_19_567 VGND VGND VPWR VPWR sky130_fd_sc_hd__decap_3
XFILLER_80_109 VGND VGND VPWR VPWR sky130_fd_sc_hd__decap_3
XFILLER_0_57 VGND VGND VPWR VPWR sky130_fd_sc_hd__decap_3
XFILLER_47_887 VGND VGND VPWR VPWR sky130_fd_sc_hd__fill_2
XFILLER_74_684 VGND VGND VPWR VPWR sky130_fd_sc_hd__decap_3
XFILLER_34_515 VGND VGND VPWR VPWR sky130_fd_sc_hd__decap_3
XFILLER_73_172 VGND VGND VPWR VPWR sky130_fd_sc_hd__decap_3
XFILLER_46_397 VGND VGND VPWR VPWR sky130_fd_sc_hd__decap_3
XFILLER_61_334 VGND VGND VPWR VPWR sky130_fd_sc_hd__fill_2
XFILLER_62_857 VGND VGND VPWR VPWR sky130_fd_sc_hd__decap_3
XFILLER_64_71 VGND VGND VPWR VPWR sky130_fd_sc_hd__fill_1
XFILLER_76_1462 VGND VGND VPWR VPWR sky130_fd_sc_hd__decap_3
XFILLER_37_1413 VGND VGND VPWR VPWR sky130_fd_sc_hd__decap_3
XFILLER_15_762 VGND VGND VPWR VPWR sky130_fd_sc_hd__decap_3
XFILLER_72_1315 VGND VGND VPWR VPWR sky130_fd_sc_hd__fill_1
XFILLER_21_209 VGND VGND VPWR VPWR sky130_fd_sc_hd__decap_3
XFILLER_72_1326 VGND VGND VPWR VPWR sky130_fd_sc_hd__decap_3
XFILLER_14_250 VGND VGND VPWR VPWR sky130_fd_sc_hd__fill_2
XFILLER_37_1446 VGND VGND VPWR VPWR sky130_fd_sc_hd__decap_3
XFILLER_14_261 VGND VGND VPWR VPWR sky130_fd_sc_hd__decap_3
XFILLER_9_33 VGND VGND VPWR VPWR sky130_fd_sc_hd__decap_3
XFILLER_37_1457 VGND VGND VPWR VPWR sky130_fd_sc_hd__decap_3
XFILLER_72_1359 VGND VGND VPWR VPWR sky130_fd_sc_hd__decap_3
XFILLER_80_70 VGND VGND VPWR VPWR sky130_fd_sc_hd__decap_3
X_3610_ _3636_/A _3644_/B _3644_/C VGND VGND VPWR VPWR _3665_/B sky130_fd_sc_hd__nand3_2
XFILLER_30_787 VGND VGND VPWR VPWR sky130_fd_sc_hd__decap_3
XFILLER_31_1012 VGND VGND VPWR VPWR sky130_fd_sc_hd__fill_1
XFILLER_70_1061 VGND VGND VPWR VPWR sky130_fd_sc_hd__decap_3
X_4590_ _4586_/X _4587_/X _4589_/Y _4558_/A VGND VGND VPWR VPWR _4590_/X sky130_fd_sc_hd__o211a_2
XFILLER_7_961 VGND VGND VPWR VPWR sky130_fd_sc_hd__decap_3
X_3541_ _6219_/Q _3631_/A2 _3630_/C1 _6251_/Q _3540_/X VGND VGND VPWR VPWR _3541_/X
+ sky130_fd_sc_hd__a221o_2
XFILLER_7_972 VGND VGND VPWR VPWR sky130_fd_sc_hd__decap_3
Xhold906 _6050_/X VGND VGND VPWR VPWR _7054_/D sky130_fd_sc_hd__dlygate4sd3_1
Xhold917 _6087_/Q VGND VGND VPWR VPWR hold917/X sky130_fd_sc_hd__dlygate4sd3_1
Xhold928 _6034_/X VGND VGND VPWR VPWR _7038_/D sky130_fd_sc_hd__dlygate4sd3_1
X_6260_ _6990_/CLK _6260_/D fanout750/X VGND VGND VPWR VPWR _6260_/Q sky130_fd_sc_hd__dfrtp_2
XFILLER_50_3 VGND VGND VPWR VPWR sky130_fd_sc_hd__decap_3
Xhold939 _6148_/Q VGND VGND VPWR VPWR hold939/X sky130_fd_sc_hd__dlygate4sd3_1
X_3472_ _6243_/Q _6467_/Q VGND VGND VPWR VPWR _3472_/X sky130_fd_sc_hd__xor2_2
Xclkbuf_3_1_0_clk clkbuf_0_clk/X VGND VGND VPWR VPWR clkbuf_3_1_0_clk/X sky130_fd_sc_hd__clkbuf_8
X_5211_ _6750_/Q _5210_/A _5335_/S _5210_/Y VGND VGND VPWR VPWR _5211_/X sky130_fd_sc_hd__o211a_2
X_6191_ _7050_/CLK _6191_/D load_slew645/X VGND VGND VPWR VPWR _6191_/Q sky130_fd_sc_hd__dfrtp_2
XTAP_TAPCELL_ROW_36_1131 VGND VPWR sky130_fd_sc_hd__tapvpwrvgnd_1
XTAP_TAPCELL_ROW_36_1142 VGND VPWR sky130_fd_sc_hd__tapvpwrvgnd_1
XFILLER_44_1406 VGND VGND VPWR VPWR sky130_fd_sc_hd__decap_3
Xload_slew831 fanout830/X VGND VGND VPWR VPWR load_slew831/X sky130_fd_sc_hd__buf_4
X_5142_ _6718_/Q _5210_/A VGND VGND VPWR VPWR _5142_/X sky130_fd_sc_hd__or2_2
XFILLER_69_434 VGND VGND VPWR VPWR sky130_fd_sc_hd__decap_3
XTAP_TAPCELL_ROW_32_1028 VGND VPWR sky130_fd_sc_hd__tapvpwrvgnd_1
XTAP_TAPCELL_ROW_32_1039 VGND VPWR sky130_fd_sc_hd__tapvpwrvgnd_1
XFILLER_42_1130 VGND VGND VPWR VPWR sky130_fd_sc_hd__decap_3
X_5073_ _6400_/Q _5270_/B VGND VGND VPWR VPWR _5075_/B sky130_fd_sc_hd__xor2_2
X_4024_ _6562_/Q _4588_/B _4123_/B2 VGND VGND VPWR VPWR _4024_/X sky130_fd_sc_hd__a21bo_2
XFILLER_77_1204 VGND VGND VPWR VPWR sky130_fd_sc_hd__decap_3
XFILLER_38_887 VGND VGND VPWR VPWR sky130_fd_sc_hd__fill_2
XFILLER_64_150 VGND VGND VPWR VPWR sky130_fd_sc_hd__fill_1
XFILLER_80_610 VGND VGND VPWR VPWR sky130_fd_sc_hd__decap_3
XFILLER_20_1450 VGND VGND VPWR VPWR sky130_fd_sc_hd__decap_3
XFILLER_77_1248 VGND VGND VPWR VPWR sky130_fd_sc_hd__decap_3
X_5975_ _5975_/A0 _5975_/A1 _5975_/S VGND VGND VPWR VPWR _6979_/D sky130_fd_sc_hd__mux2_1
XFILLER_52_345 VGND VGND VPWR VPWR sky130_fd_sc_hd__fill_2
XFILLER_80_676 VGND VGND VPWR VPWR sky130_fd_sc_hd__decap_3
XFILLER_40_507 VGND VGND VPWR VPWR sky130_fd_sc_hd__decap_3
X_4926_ _6379_/Q _5207_/B _5075_/A VGND VGND VPWR VPWR _4926_/Y sky130_fd_sc_hd__a21oi_2
XFILLER_21_721 VGND VGND VPWR VPWR sky130_fd_sc_hd__decap_3
XFILLER_21_732 VGND VGND VPWR VPWR sky130_fd_sc_hd__decap_3
X_4857_ _4487_/A _4502_/X _4842_/X _6586_/Q _4859_/C1 VGND VGND VPWR VPWR _4860_/B
+ sky130_fd_sc_hd__a221o_2
XFILLER_21_754 VGND VGND VPWR VPWR sky130_fd_sc_hd__decap_3
XFILLER_60_29 VGND VGND VPWR VPWR sky130_fd_sc_hd__fill_2
XFILLER_14_1232 VGND VGND VPWR VPWR sky130_fd_sc_hd__decap_3
X_3808_ _3927_/A_N _6233_/Q VGND VGND VPWR VPWR _3808_/X sky130_fd_sc_hd__and2b_2
XFILLER_53_1281 VGND VGND VPWR VPWR sky130_fd_sc_hd__decap_3
XFILLER_20_286 VGND VGND VPWR VPWR sky130_fd_sc_hd__decap_3
X_4788_ _4788_/A _4788_/B _4788_/C VGND VGND VPWR VPWR _4788_/X sky130_fd_sc_hd__and3_2
XFILLER_53_1292 VGND VGND VPWR VPWR sky130_fd_sc_hd__decap_3
XFILLER_5_909 VGND VGND VPWR VPWR sky130_fd_sc_hd__decap_3
XFILLER_14_1276 VGND VGND VPWR VPWR sky130_fd_sc_hd__decap_3
X_6527_ _6865_/CLK _6527_/D wire712/X VGND VGND VPWR VPWR _6527_/Q sky130_fd_sc_hd__dfrtp_2
X_3739_ _3739_/A _4112_/A VGND VGND VPWR VPWR _3740_/B sky130_fd_sc_hd__xor2_2
XFILLER_10_1129 VGND VGND VPWR VPWR sky130_fd_sc_hd__decap_3
X_6458_ _7052_/CLK _6458_/D fanout804/X VGND VGND VPWR VPWR _6458_/Q sky130_fd_sc_hd__dfrtp_2
XFILLER_49_1328 VGND VGND VPWR VPWR sky130_fd_sc_hd__decap_3
XFILLER_69_27 VGND VGND VPWR VPWR sky130_fd_sc_hd__decap_3
X_5409_ _5409_/A1 _5465_/A2 _4498_/X VGND VGND VPWR VPWR _6521_/D sky130_fd_sc_hd__a21o_2
X_6389_ _6991_/CLK _6389_/D wire796/X VGND VGND VPWR VPWR _6389_/Q sky130_fd_sc_hd__dfrtp_2
XFILLER_0_669 VGND VGND VPWR VPWR sky130_fd_sc_hd__decap_3
XFILLER_5_1422 VGND VGND VPWR VPWR sky130_fd_sc_hd__decap_3
XFILLER_60_1241 VGND VGND VPWR VPWR sky130_fd_sc_hd__decap_3
XFILLER_25_1372 VGND VGND VPWR VPWR sky130_fd_sc_hd__decap_3
XFILLER_5_1455 VGND VGND VPWR VPWR sky130_fd_sc_hd__fill_1
XFILLER_5_1466 VGND VGND VPWR VPWR sky130_fd_sc_hd__decap_3
XFILLER_21_1236 VGND VGND VPWR VPWR sky130_fd_sc_hd__decap_3
XFILLER_56_651 VGND VGND VPWR VPWR sky130_fd_sc_hd__decap_3
XFILLER_60_1285 VGND VGND VPWR VPWR sky130_fd_sc_hd__decap_3
XFILLER_29_876 VGND VGND VPWR VPWR sky130_fd_sc_hd__decap_3
XFILLER_1_1319 VGND VGND VPWR VPWR sky130_fd_sc_hd__decap_3
XFILLER_16_515 VGND VGND VPWR VPWR sky130_fd_sc_hd__decap_3
XFILLER_21_1269 VGND VGND VPWR VPWR sky130_fd_sc_hd__decap_3
XFILLER_44_824 VGND VGND VPWR VPWR sky130_fd_sc_hd__decap_3
XFILLER_18_97 VGND VGND VPWR VPWR sky130_fd_sc_hd__fill_2
XFILLER_28_397 VGND VGND VPWR VPWR sky130_fd_sc_hd__decap_3
XFILLER_55_183 VGND VGND VPWR VPWR sky130_fd_sc_hd__decap_3
XFILLER_70_131 VGND VGND VPWR VPWR sky130_fd_sc_hd__decap_3
XFILLER_71_676 VGND VGND VPWR VPWR sky130_fd_sc_hd__decap_3
XFILLER_19_1121 VGND VGND VPWR VPWR sky130_fd_sc_hd__decap_3
XFILLER_43_378 VGND VGND VPWR VPWR sky130_fd_sc_hd__fill_1
XFILLER_54_1012 VGND VGND VPWR VPWR sky130_fd_sc_hd__decap_3
XFILLER_70_164 VGND VGND VPWR VPWR sky130_fd_sc_hd__decap_3
XFILLER_58_1181 VGND VGND VPWR VPWR sky130_fd_sc_hd__decap_3
XFILLER_70_175 VGND VGND VPWR VPWR sky130_fd_sc_hd__decap_3
XFILLER_24_592 VGND VGND VPWR VPWR sky130_fd_sc_hd__decap_3
XFILLER_12_743 VGND VGND VPWR VPWR sky130_fd_sc_hd__fill_1
XFILLER_15_1007 VGND VGND VPWR VPWR sky130_fd_sc_hd__fill_1
XFILLER_12_754 VGND VGND VPWR VPWR sky130_fd_sc_hd__fill_2
XFILLER_54_1089 VGND VGND VPWR VPWR sky130_fd_sc_hd__decap_3
XTAP_TAPCELL_ROW_22_760 VGND VPWR sky130_fd_sc_hd__tapvpwrvgnd_1
XFILLER_71_1381 VGND VGND VPWR VPWR sky130_fd_sc_hd__decap_3
XTAP_TAPCELL_ROW_22_771 VGND VPWR sky130_fd_sc_hd__tapvpwrvgnd_1
XFILLER_32_1332 VGND VGND VPWR VPWR sky130_fd_sc_hd__decap_3
Xwire133 _5337_/S VGND VGND VPWR VPWR _5321_/S sky130_fd_sc_hd__clkbuf_4
XTAP_TAPCELL_ROW_22_782 VGND VPWR sky130_fd_sc_hd__tapvpwrvgnd_1
XFILLER_32_1365 VGND VGND VPWR VPWR sky130_fd_sc_hd__decap_3
XFILLER_32_1376 VGND VGND VPWR VPWR sky130_fd_sc_hd__decap_3
Xwire177 _3243_/S VGND VGND VPWR VPWR _3435_/S sky130_fd_sc_hd__clkbuf_4
XFILLER_67_1428 VGND VGND VPWR VPWR sky130_fd_sc_hd__decap_3
XFILLER_3_441 VGND VGND VPWR VPWR sky130_fd_sc_hd__decap_3
XFILLER_3_452 VGND VGND VPWR VPWR sky130_fd_sc_hd__decap_3
XFILLER_79_710 VGND VGND VPWR VPWR sky130_fd_sc_hd__decap_3
XTAP_TAPCELL_ROW_72_2065 VGND VPWR sky130_fd_sc_hd__tapvpwrvgnd_1
XFILLER_3_474 VGND VGND VPWR VPWR sky130_fd_sc_hd__decap_3
XTAP_TAPCELL_ROW_72_2076 VGND VPWR sky130_fd_sc_hd__tapvpwrvgnd_1
Xload_slew116 _5153_/A2 VGND VGND VPWR VPWR _5254_/A2 sky130_fd_sc_hd__clkbuf_4
XFILLER_79_732 VGND VGND VPWR VPWR sky130_fd_sc_hd__decap_3
Xclkbuf_4_2__f_clk clkbuf_3_1_0_clk/X VGND VGND VPWR VPWR clkbuf_leaf_3_clk/A sky130_fd_sc_hd__clkbuf_16
XFILLER_59_60 VGND VGND VPWR VPWR sky130_fd_sc_hd__fill_1
XFILLER_6_1208 VGND VGND VPWR VPWR sky130_fd_sc_hd__decap_3
XFILLER_61_1038 VGND VGND VPWR VPWR sky130_fd_sc_hd__decap_3
XFILLER_67_927 VGND VGND VPWR VPWR sky130_fd_sc_hd__decap_3
XFILLER_67_949 VGND VGND VPWR VPWR sky130_fd_sc_hd__decap_3
XFILLER_15_6 VGND VGND VPWR VPWR sky130_fd_sc_hd__decap_3
XFILLER_19_364 VGND VGND VPWR VPWR sky130_fd_sc_hd__fill_1
XFILLER_47_673 VGND VGND VPWR VPWR sky130_fd_sc_hd__decap_3
Xload_slew41 _4883_/B1 VGND VGND VPWR VPWR _4855_/B1 sky130_fd_sc_hd__buf_4
XFILLER_34_323 VGND VGND VPWR VPWR sky130_fd_sc_hd__decap_3
XFILLER_62_643 VGND VGND VPWR VPWR sky130_fd_sc_hd__fill_1
XFILLER_62_654 VGND VGND VPWR VPWR sky130_fd_sc_hd__fill_1
XFILLER_35_879 VGND VGND VPWR VPWR sky130_fd_sc_hd__fill_1
XFILLER_34_356 VGND VGND VPWR VPWR sky130_fd_sc_hd__decap_3
XFILLER_62_676 VGND VGND VPWR VPWR sky130_fd_sc_hd__decap_3
XFILLER_76_1270 VGND VGND VPWR VPWR sky130_fd_sc_hd__decap_3
XFILLER_50_827 VGND VGND VPWR VPWR sky130_fd_sc_hd__fill_2
X_5760_ _5789_/C _5760_/A1 _5766_/S VGND VGND VPWR VPWR _6803_/D sky130_fd_sc_hd__mux2_1
XFILLER_15_570 VGND VGND VPWR VPWR sky130_fd_sc_hd__decap_3
XFILLER_72_1123 VGND VGND VPWR VPWR sky130_fd_sc_hd__decap_3
XFILLER_43_890 VGND VGND VPWR VPWR sky130_fd_sc_hd__decap_3
XFILLER_61_186 VGND VGND VPWR VPWR sky130_fd_sc_hd__decap_3
XFILLER_37_1254 VGND VGND VPWR VPWR sky130_fd_sc_hd__decap_3
X_4711_ _6558_/Q _4710_/A _4888_/C1 VGND VGND VPWR VPWR _4711_/X sky130_fd_sc_hd__a21bo_2
X_5691_ _5691_/A0 wire608/A _5693_/S VGND VGND VPWR VPWR _6743_/D sky130_fd_sc_hd__mux2_1
XFILLER_72_1167 VGND VGND VPWR VPWR sky130_fd_sc_hd__decap_3
XTAP_TAPCELL_ROW_20_708 VGND VPWR sky130_fd_sc_hd__tapvpwrvgnd_1
XFILLER_37_1287 VGND VGND VPWR VPWR sky130_fd_sc_hd__fill_1
XFILLER_37_1298 VGND VGND VPWR VPWR sky130_fd_sc_hd__decap_3
XTAP_TAPCELL_ROW_20_719 VGND VPWR sky130_fd_sc_hd__tapvpwrvgnd_1
X_4642_ _6886_/Q wire295/X _4640_/X _4641_/X VGND VGND VPWR VPWR _4642_/X sky130_fd_sc_hd__a211o_2
XFILLER_50_1421 VGND VGND VPWR VPWR sky130_fd_sc_hd__decap_3
XFILLER_50_1432 VGND VGND VPWR VPWR sky130_fd_sc_hd__decap_3
XTAP_TAPCELL_ROW_61_1780 VGND VPWR sky130_fd_sc_hd__tapvpwrvgnd_1
XTAP_TAPCELL_ROW_61_1791 VGND VPWR sky130_fd_sc_hd__tapvpwrvgnd_1
XFILLER_11_1416 VGND VGND VPWR VPWR sky130_fd_sc_hd__decap_3
XFILLER_50_1465 VGND VGND VPWR VPWR sky130_fd_sc_hd__decap_3
X_4573_ _4572_/B _4747_/B _4572_/Y _4771_/C1 VGND VGND VPWR VPWR _4574_/C sky130_fd_sc_hd__o211ai_2
XFILLER_11_1449 VGND VGND VPWR VPWR sky130_fd_sc_hd__decap_3
X_6312_ _7016_/CLK _6312_/D load_slew662/X VGND VGND VPWR VPWR _6312_/Q sky130_fd_sc_hd__dfrtp_2
XFILLER_7_791 VGND VGND VPWR VPWR sky130_fd_sc_hd__decap_3
X_3524_ _6648_/Q _4723_/C _3523_/X _5606_/A1 VGND VGND VPWR VPWR _3524_/X sky130_fd_sc_hd__o211a_2
XFILLER_6_290 VGND VGND VPWR VPWR sky130_fd_sc_hd__decap_3
X_6243_ _7032_/CLK _6243_/D load_slew696/X VGND VGND VPWR VPWR _6243_/Q sky130_fd_sc_hd__dfrtp_2
X_3455_ hold973/X _3454_/X _3455_/S VGND VGND VPWR VPWR _6201_/D sky130_fd_sc_hd__mux2_1
XFILLER_48_1350 VGND VGND VPWR VPWR sky130_fd_sc_hd__decap_3
X_6174_ _6990_/CLK _6174_/D load_slew748/X VGND VGND VPWR VPWR _6174_/Q sky130_fd_sc_hd__dfrtp_2
X_3386_ _6312_/Q _6424_/Q VGND VGND VPWR VPWR _3386_/X sky130_fd_sc_hd__xor2_2
XFILLER_48_1394 VGND VGND VPWR VPWR sky130_fd_sc_hd__decap_3
Xload_slew650 fanout649/X VGND VGND VPWR VPWR load_slew650/X sky130_fd_sc_hd__clkbuf_4
X_5125_ _6374_/Q _5122_/X _5124_/X _5271_/B1 VGND VGND VPWR VPWR _6374_/D sky130_fd_sc_hd__a22o_2
XFILLER_44_1258 VGND VGND VPWR VPWR sky130_fd_sc_hd__fill_2
Xhold1403 _6504_/Q VGND VGND VPWR VPWR _5392_/A1 sky130_fd_sc_hd__dlygate4sd3_1
Xhold1414 _6492_/Q VGND VGND VPWR VPWR _5380_/A1 sky130_fd_sc_hd__dlygate4sd3_1
XFILLER_58_949 VGND VGND VPWR VPWR sky130_fd_sc_hd__fill_1
Xhold1425 _6472_/Q VGND VGND VPWR VPWR _5360_/A1 sky130_fd_sc_hd__dlygate4sd3_1
Xhold1436 _6821_/Q VGND VGND VPWR VPWR _5794_/A1 sky130_fd_sc_hd__dlygate4sd3_1
Xload_slew694 fanout693/X VGND VGND VPWR VPWR load_slew694/X sky130_fd_sc_hd__buf_2
Xhold1447 _6490_/Q VGND VGND VPWR VPWR _5378_/A1 sky130_fd_sc_hd__dlygate4sd3_1
X_5056_ _6462_/Q _6680_/Q VGND VGND VPWR VPWR _5057_/B sky130_fd_sc_hd__xor2_2
XFILLER_73_919 VGND VGND VPWR VPWR sky130_fd_sc_hd__decap_3
Xhold1458 _6498_/Q VGND VGND VPWR VPWR _5386_/A1 sky130_fd_sc_hd__dlygate4sd3_1
Xhold1469 _6531_/Q VGND VGND VPWR VPWR _5419_/A1 sky130_fd_sc_hd__dlygate4sd3_1
X_4007_ _6231_/Q _4105_/A2 _4005_/X _4006_/X VGND VGND VPWR VPWR _6231_/D sky130_fd_sc_hd__o22a_2
XFILLER_26_813 VGND VGND VPWR VPWR sky130_fd_sc_hd__decap_3
XFILLER_25_301 VGND VGND VPWR VPWR sky130_fd_sc_hd__decap_3
XFILLER_65_470 VGND VGND VPWR VPWR sky130_fd_sc_hd__decap_3
XFILLER_66_993 VGND VGND VPWR VPWR sky130_fd_sc_hd__decap_3
XFILLER_77_1023 VGND VGND VPWR VPWR sky130_fd_sc_hd__fill_1
XFILLER_37_172 VGND VGND VPWR VPWR sky130_fd_sc_hd__decap_3
XFILLER_38_695 VGND VGND VPWR VPWR sky130_fd_sc_hd__decap_3
XTAP_TAPCELL_ROW_68_1956 VGND VPWR sky130_fd_sc_hd__tapvpwrvgnd_1
XTAP_TAPCELL_ROW_68_1967 VGND VPWR sky130_fd_sc_hd__tapvpwrvgnd_1
XFILLER_0_1341 VGND VGND VPWR VPWR sky130_fd_sc_hd__decap_3
XTAP_TAPCELL_ROW_68_1978 VGND VPWR sky130_fd_sc_hd__tapvpwrvgnd_1
XFILLER_20_1291 VGND VGND VPWR VPWR sky130_fd_sc_hd__decap_3
XFILLER_0_1363 VGND VGND VPWR VPWR sky130_fd_sc_hd__decap_3
XFILLER_25_367 VGND VGND VPWR VPWR sky130_fd_sc_hd__decap_3
XFILLER_41_816 VGND VGND VPWR VPWR sky130_fd_sc_hd__decap_3
XFILLER_77_1089 VGND VGND VPWR VPWR sky130_fd_sc_hd__decap_3
XFILLER_55_1310 VGND VGND VPWR VPWR sky130_fd_sc_hd__decap_3
XFILLER_0_1385 VGND VGND VPWR VPWR sky130_fd_sc_hd__decap_3
XFILLER_40_315 VGND VGND VPWR VPWR sky130_fd_sc_hd__decap_3
X_5958_ _5958_/A0 _6962_/Q _5998_/S VGND VGND VPWR VPWR _5958_/X sky130_fd_sc_hd__mux2_1
XFILLER_71_39 VGND VGND VPWR VPWR sky130_fd_sc_hd__decap_3
XFILLER_52_197 VGND VGND VPWR VPWR sky130_fd_sc_hd__fill_1
XFILLER_55_1343 VGND VGND VPWR VPWR sky130_fd_sc_hd__fill_1
XFILLER_55_1354 VGND VGND VPWR VPWR sky130_fd_sc_hd__decap_3
X_4909_ _6441_/Q _6659_/Q VGND VGND VPWR VPWR _4910_/B sky130_fd_sc_hd__xor2_2
XFILLER_16_1338 VGND VGND VPWR VPWR sky130_fd_sc_hd__decap_3
XFILLER_55_1387 VGND VGND VPWR VPWR sky130_fd_sc_hd__decap_3
X_5889_ _5889_/A0 _5889_/A1 _5896_/S VGND VGND VPWR VPWR _6898_/D sky130_fd_sc_hd__mux2_1
XFILLER_51_1229 VGND VGND VPWR VPWR sky130_fd_sc_hd__decap_3
XFILLER_14_1040 VGND VGND VPWR VPWR sky130_fd_sc_hd__decap_3
XFILLER_20_21 VGND VGND VPWR VPWR sky130_fd_sc_hd__decap_3
XFILLER_49_1114 VGND VGND VPWR VPWR sky130_fd_sc_hd__decap_3
XFILLER_1_912 VGND VGND VPWR VPWR sky130_fd_sc_hd__decap_3
XFILLER_49_1158 VGND VGND VPWR VPWR sky130_fd_sc_hd__decap_3
XFILLER_27_1401 VGND VGND VPWR VPWR sky130_fd_sc_hd__decap_3
XFILLER_66_1450 VGND VGND VPWR VPWR sky130_fd_sc_hd__decap_3
XFILLER_0_411 VGND VGND VPWR VPWR sky130_fd_sc_hd__decap_3
XFILLER_1_945 VGND VGND VPWR VPWR sky130_fd_sc_hd__decap_3
XFILLER_62_1303 VGND VGND VPWR VPWR sky130_fd_sc_hd__decap_3
XFILLER_1_956 VGND VGND VPWR VPWR sky130_fd_sc_hd__decap_3
XFILLER_0_433 VGND VGND VPWR VPWR sky130_fd_sc_hd__decap_3
XFILLER_27_1434 VGND VGND VPWR VPWR sky130_fd_sc_hd__decap_3
XFILLER_0_455 VGND VGND VPWR VPWR sky130_fd_sc_hd__decap_3
XFILLER_49_916 VGND VGND VPWR VPWR sky130_fd_sc_hd__decap_3
XFILLER_76_713 VGND VGND VPWR VPWR sky130_fd_sc_hd__decap_3
XFILLER_1_989 VGND VGND VPWR VPWR sky130_fd_sc_hd__decap_3
XFILLER_62_1347 VGND VGND VPWR VPWR sky130_fd_sc_hd__decap_3
XFILLER_0_477 VGND VGND VPWR VPWR sky130_fd_sc_hd__decap_3
XFILLER_48_448 VGND VGND VPWR VPWR sky130_fd_sc_hd__fill_2
XFILLER_48_459 VGND VGND VPWR VPWR sky130_fd_sc_hd__decap_3
XFILLER_29_640 VGND VGND VPWR VPWR sky130_fd_sc_hd__decap_3
XFILLER_5_1263 VGND VGND VPWR VPWR sky130_fd_sc_hd__decap_3
XFILLER_60_1082 VGND VGND VPWR VPWR sky130_fd_sc_hd__fill_1
XTAP_TAPCELL_ROW_3_271 VGND VPWR sky130_fd_sc_hd__tapvpwrvgnd_1
XFILLER_1_1116 VGND VGND VPWR VPWR sky130_fd_sc_hd__decap_3
XFILLER_29_673 VGND VGND VPWR VPWR sky130_fd_sc_hd__fill_2
XFILLER_60_1093 VGND VGND VPWR VPWR sky130_fd_sc_hd__decap_3
XTAP_TAPCELL_ROW_3_282 VGND VPWR sky130_fd_sc_hd__tapvpwrvgnd_1
XFILLER_1_1127 VGND VGND VPWR VPWR sky130_fd_sc_hd__decap_3
XFILLER_57_993 VGND VGND VPWR VPWR sky130_fd_sc_hd__decap_3
XFILLER_16_312 VGND VGND VPWR VPWR sky130_fd_sc_hd__decap_3
XFILLER_21_1077 VGND VGND VPWR VPWR sky130_fd_sc_hd__fill_2
Xclkbuf_4_10__f_clk clkbuf_3_5_0_clk/X VGND VGND VPWR VPWR clkbuf_leaf_67_clk/A sky130_fd_sc_hd__clkbuf_16
XFILLER_44_632 VGND VGND VPWR VPWR sky130_fd_sc_hd__fill_1
XTAP_TAPCELL_ROW_80_2301 VGND VPWR sky130_fd_sc_hd__tapvpwrvgnd_1
XFILLER_72_963 VGND VGND VPWR VPWR sky130_fd_sc_hd__decap_3
XFILLER_71_440 VGND VGND VPWR VPWR sky130_fd_sc_hd__decap_3
XTAP_TAPCELL_ROW_80_2312 VGND VPWR sky130_fd_sc_hd__tapvpwrvgnd_1
XFILLER_43_142 VGND VGND VPWR VPWR sky130_fd_sc_hd__decap_3
XFILLER_73_1410 VGND VGND VPWR VPWR sky130_fd_sc_hd__decap_3
XFILLER_43_164 VGND VGND VPWR VPWR sky130_fd_sc_hd__decap_3
XFILLER_16_389 VGND VGND VPWR VPWR sky130_fd_sc_hd__decap_3
XTAP_TAPCELL_ROW_27_896 VGND VPWR sky130_fd_sc_hd__tapvpwrvgnd_1
XFILLER_73_1443 VGND VGND VPWR VPWR sky130_fd_sc_hd__decap_3
XFILLER_31_337 VGND VGND VPWR VPWR sky130_fd_sc_hd__fill_1
XTAP_TAPCELL_ROW_14_557 VGND VPWR sky130_fd_sc_hd__tapvpwrvgnd_1
XFILLER_34_1427 VGND VGND VPWR VPWR sky130_fd_sc_hd__fill_1
XTAP_TAPCELL_ROW_14_568 VGND VPWR sky130_fd_sc_hd__tapvpwrvgnd_1
XFILLER_34_1438 VGND VGND VPWR VPWR sky130_fd_sc_hd__decap_3
XFILLER_8_533 VGND VGND VPWR VPWR sky130_fd_sc_hd__decap_3
XTAP_TAPCELL_ROW_78_2230 VGND VPWR sky130_fd_sc_hd__tapvpwrvgnd_1
XFILLER_12_595 VGND VGND VPWR VPWR sky130_fd_sc_hd__decap_3
XTAP_TAPCELL_ROW_78_2241 VGND VPWR sky130_fd_sc_hd__tapvpwrvgnd_1
XFILLER_8_566 VGND VGND VPWR VPWR sky130_fd_sc_hd__decap_3
XFILLER_6_12 VGND VGND VPWR VPWR sky130_fd_sc_hd__decap_3
XTAP_TAPCELL_ROW_74_2116 VGND VPWR sky130_fd_sc_hd__tapvpwrvgnd_1
XFILLER_32_1184 VGND VGND VPWR VPWR sky130_fd_sc_hd__decap_3
XTAP_TAPCELL_ROW_74_2127 VGND VPWR sky130_fd_sc_hd__tapvpwrvgnd_1
XANTENNA_5 _3092_/Y VGND VGND VPWR VPWR sky130_fd_sc_hd__diode_2
XFILLER_67_1225 VGND VGND VPWR VPWR sky130_fd_sc_hd__decap_3
XFILLER_67_1236 VGND VGND VPWR VPWR sky130_fd_sc_hd__decap_3
XFILLER_67_1269 VGND VGND VPWR VPWR sky130_fd_sc_hd__decap_3
XFILLER_4_794 VGND VGND VPWR VPWR sky130_fd_sc_hd__decap_3
X_3240_ _6255_/Q _6351_/Q VGND VGND VPWR VPWR _3240_/X sky130_fd_sc_hd__xor2_2
XFILLER_80_1425 VGND VGND VPWR VPWR sky130_fd_sc_hd__decap_3
XFILLER_80_1447 VGND VGND VPWR VPWR sky130_fd_sc_hd__decap_3
X_3171_ _3180_/A1 _3169_/X _3170_/X _3220_/C1 VGND VGND VPWR VPWR _3175_/B sky130_fd_sc_hd__a211o_2
XFILLER_13_3 VGND VGND VPWR VPWR sky130_fd_sc_hd__decap_3
XFILLER_55_919 VGND VGND VPWR VPWR sky130_fd_sc_hd__decap_3
XFILLER_66_256 VGND VGND VPWR VPWR sky130_fd_sc_hd__decap_3
XTAP_TAPCELL_ROW_1_219 VGND VPWR sky130_fd_sc_hd__tapvpwrvgnd_1
XTAP_TAPCELL_ROW_50_1492 VGND VPWR sky130_fd_sc_hd__tapvpwrvgnd_1
X_6930_ _7095_/CLK _6930_/D fanout697/X VGND VGND VPWR VPWR _6930_/Q sky130_fd_sc_hd__dfrtp_2
XFILLER_48_993 VGND VGND VPWR VPWR sky130_fd_sc_hd__decap_3
XFILLER_78_1332 VGND VGND VPWR VPWR sky130_fd_sc_hd__decap_3
XFILLER_19_172 VGND VGND VPWR VPWR sky130_fd_sc_hd__fill_2
XFILLER_19_194 VGND VGND VPWR VPWR sky130_fd_sc_hd__decap_3
XFILLER_78_1365 VGND VGND VPWR VPWR sky130_fd_sc_hd__decap_3
XFILLER_35_654 VGND VGND VPWR VPWR sky130_fd_sc_hd__fill_1
XFILLER_39_1316 VGND VGND VPWR VPWR sky130_fd_sc_hd__decap_3
XFILLER_78_1376 VGND VGND VPWR VPWR sky130_fd_sc_hd__decap_3
X_6861_ clkload9/A _6861_/D fanout642/X VGND VGND VPWR VPWR _6861_/Q sky130_fd_sc_hd__dfrtp_2
XFILLER_74_1229 VGND VGND VPWR VPWR sky130_fd_sc_hd__decap_3
XFILLER_35_676 VGND VGND VPWR VPWR sky130_fd_sc_hd__decap_3
XFILLER_23_827 VGND VGND VPWR VPWR sky130_fd_sc_hd__decap_3
X_5812_ _5913_/A0 _5812_/A1 _5813_/S VGND VGND VPWR VPWR _6832_/D sky130_fd_sc_hd__mux2_1
X_6792_ _7048_/CLK _6792_/D wire655/X VGND VGND VPWR VPWR _6792_/Q sky130_fd_sc_hd__dfrtp_2
XTAP_TAPCELL_ROW_63_1831 VGND VPWR sky130_fd_sc_hd__tapvpwrvgnd_1
XFILLER_62_495 VGND VGND VPWR VPWR sky130_fd_sc_hd__decap_3
XFILLER_34_197 VGND VGND VPWR VPWR sky130_fd_sc_hd__decap_3
XFILLER_37_1040 VGND VGND VPWR VPWR sky130_fd_sc_hd__decap_3
XTAP_TAPCELL_ROW_63_1842 VGND VPWR sky130_fd_sc_hd__tapvpwrvgnd_1
X_5743_ _5918_/A1 _5743_/A1 _5748_/S VGND VGND VPWR VPWR _6788_/D sky130_fd_sc_hd__mux2_1
XFILLER_50_679 VGND VGND VPWR VPWR sky130_fd_sc_hd__fill_1
XFILLER_37_1073 VGND VGND VPWR VPWR sky130_fd_sc_hd__fill_2
XFILLER_31_882 VGND VGND VPWR VPWR sky130_fd_sc_hd__decap_3
X_5674_ hold899/X _5913_/A0 _5674_/S VGND VGND VPWR VPWR _6728_/D sky130_fd_sc_hd__mux2_1
XFILLER_15_1360 VGND VGND VPWR VPWR sky130_fd_sc_hd__decap_3
XFILLER_50_1240 VGND VGND VPWR VPWR sky130_fd_sc_hd__decap_3
X_4625_ _6546_/Q _4624_/A _4647_/A1 VGND VGND VPWR VPWR _4625_/X sky130_fd_sc_hd__a21bo_2
XFILLER_11_1213 VGND VGND VPWR VPWR sky130_fd_sc_hd__decap_3
XFILLER_15_1393 VGND VGND VPWR VPWR sky130_fd_sc_hd__decap_3
XFILLER_50_1273 VGND VGND VPWR VPWR sky130_fd_sc_hd__decap_3
XFILLER_11_1257 VGND VGND VPWR VPWR sky130_fd_sc_hd__decap_3
X_4556_ _6537_/Q _4588_/B VGND VGND VPWR VPWR _4556_/Y sky130_fd_sc_hd__nand2_2
X_3507_ _4428_/A _3505_/X _3506_/X _3501_/X VGND VGND VPWR VPWR _3507_/X sky130_fd_sc_hd__a22o_2
XFILLER_1_208 VGND VGND VPWR VPWR sky130_fd_sc_hd__decap_3
XFILLER_46_1309 VGND VGND VPWR VPWR sky130_fd_sc_hd__decap_3
X_4487_ _4487_/A _4842_/B _4842_/C VGND VGND VPWR VPWR _4487_/X sky130_fd_sc_hd__or3_2
XTAP_TAPCELL_ROW_57_1679 VGND VPWR sky130_fd_sc_hd__tapvpwrvgnd_1
X_6226_ _6900_/CLK _6226_/D fanout828/X VGND VGND VPWR VPWR _6226_/Q sky130_fd_sc_hd__dfrtp_2
X_3438_ _6330_/Q _6450_/Q VGND VGND VPWR VPWR _3438_/X sky130_fd_sc_hd__xor2_2
XFILLER_44_1011 VGND VGND VPWR VPWR sky130_fd_sc_hd__decap_3
X_6157_ _6912_/CLK _6157_/D wire687/X VGND VGND VPWR VPWR _6157_/Q sky130_fd_sc_hd__dfrtp_2
X_3369_ hold982/X _3368_/X _3385_/S VGND VGND VPWR VPWR _6158_/D sky130_fd_sc_hd__mux2_1
Xhold1200 _6813_/Q VGND VGND VPWR VPWR _5778_/A0 sky130_fd_sc_hd__dlygate4sd3_1
XFILLER_58_735 VGND VGND VPWR VPWR sky130_fd_sc_hd__fill_2
Xhold1211 _6621_/Q VGND VGND VPWR VPWR _5538_/B1 sky130_fd_sc_hd__dlygate4sd3_1
XFILLER_58_746 VGND VGND VPWR VPWR sky130_fd_sc_hd__fill_2
X_5108_ _6372_/Q _5107_/X _5107_/A _6710_/Q VGND VGND VPWR VPWR _5108_/X sky130_fd_sc_hd__a2bb2o_2
Xhold1222 _6926_/Q VGND VGND VPWR VPWR _5920_/A0 sky130_fd_sc_hd__dlygate4sd3_1
XFILLER_44_1088 VGND VGND VPWR VPWR sky130_fd_sc_hd__decap_3
Xload_slew491 _5567_/A VGND VGND VPWR VPWR _5607_/A1 sky130_fd_sc_hd__clkbuf_4
Xhold1233 _6866_/Q VGND VGND VPWR VPWR _5851_/A0 sky130_fd_sc_hd__dlygate4sd3_1
XFILLER_22_1320 VGND VGND VPWR VPWR sky130_fd_sc_hd__decap_3
Xhold1244 _6834_/Q VGND VGND VPWR VPWR _5815_/A0 sky130_fd_sc_hd__dlygate4sd3_1
X_6088_ _7036_/CLK _6088_/D load_slew843/X VGND VGND VPWR VPWR _6088_/Q sky130_fd_sc_hd__dfrtp_2
XFILLER_79_1118 VGND VGND VPWR VPWR sky130_fd_sc_hd__fill_2
XFILLER_2_1403 VGND VGND VPWR VPWR sky130_fd_sc_hd__decap_3
Xhold1255 _6847_/Q VGND VGND VPWR VPWR _5829_/A1 sky130_fd_sc_hd__dlygate4sd3_1
Xhold1266 _6898_/Q VGND VGND VPWR VPWR _5889_/A1 sky130_fd_sc_hd__dlygate4sd3_1
XFILLER_22_1353 VGND VGND VPWR VPWR sky130_fd_sc_hd__decap_3
XFILLER_57_278 VGND VGND VPWR VPWR sky130_fd_sc_hd__fill_2
X_5039_ _5037_/X _5038_/Y _5257_/A2 VGND VGND VPWR VPWR _5041_/S sky130_fd_sc_hd__a21oi_2
Xhold1277 _6053_/X VGND VGND VPWR VPWR _7057_/D sky130_fd_sc_hd__dlygate4sd3_1
XFILLER_57_289 VGND VGND VPWR VPWR sky130_fd_sc_hd__fill_2
Xhold1288 _6129_/Q VGND VGND VPWR VPWR _3311_/A0 sky130_fd_sc_hd__dlygate4sd3_1
Xhold1299 _6930_/Q VGND VGND VPWR VPWR _5925_/A1 sky130_fd_sc_hd__dlygate4sd3_1
XFILLER_2_1447 VGND VGND VPWR VPWR sky130_fd_sc_hd__decap_3
XFILLER_22_1397 VGND VGND VPWR VPWR sky130_fd_sc_hd__decap_3
XFILLER_72_259 VGND VGND VPWR VPWR sky130_fd_sc_hd__decap_3
XFILLER_26_654 VGND VGND VPWR VPWR sky130_fd_sc_hd__decap_3
XFILLER_57_1416 VGND VGND VPWR VPWR sky130_fd_sc_hd__decap_3
XFILLER_14_816 VGND VGND VPWR VPWR sky130_fd_sc_hd__decap_3
XFILLER_57_1449 VGND VGND VPWR VPWR sky130_fd_sc_hd__decap_3
XTAP_TAPCELL_ROW_24_822 VGND VPWR sky130_fd_sc_hd__tapvpwrvgnd_1
XFILLER_53_495 VGND VGND VPWR VPWR sky130_fd_sc_hd__fill_1
XTAP_TAPCELL_ROW_24_833 VGND VPWR sky130_fd_sc_hd__tapvpwrvgnd_1
XFILLER_51_1004 VGND VGND VPWR VPWR sky130_fd_sc_hd__decap_3
XFILLER_33_1460 VGND VGND VPWR VPWR sky130_fd_sc_hd__decap_3
XFILLER_5_514 VGND VGND VPWR VPWR sky130_fd_sc_hd__decap_3
XFILLER_64_1409 VGND VGND VPWR VPWR sky130_fd_sc_hd__decap_3
XFILLER_1_753 VGND VGND VPWR VPWR sky130_fd_sc_hd__decap_3
XFILLER_27_1242 VGND VGND VPWR VPWR sky130_fd_sc_hd__decap_3
XFILLER_66_1291 VGND VGND VPWR VPWR sky130_fd_sc_hd__decap_3
XFILLER_62_1133 VGND VGND VPWR VPWR sky130_fd_sc_hd__decap_3
XFILLER_7_1325 VGND VGND VPWR VPWR sky130_fd_sc_hd__decap_3
XTAP_TAPCELL_ROW_8_396 VGND VPWR sky130_fd_sc_hd__tapvpwrvgnd_1
XFILLER_49_724 VGND VGND VPWR VPWR sky130_fd_sc_hd__decap_3
XFILLER_0_274 VGND VGND VPWR VPWR sky130_fd_sc_hd__decap_3
XFILLER_1_797 VGND VGND VPWR VPWR sky130_fd_sc_hd__decap_3
XFILLER_27_1275 VGND VGND VPWR VPWR sky130_fd_sc_hd__decap_3
XFILLER_48_212 VGND VGND VPWR VPWR sky130_fd_sc_hd__decap_3
XFILLER_49_735 VGND VGND VPWR VPWR sky130_fd_sc_hd__decap_3
XFILLER_23_1117 VGND VGND VPWR VPWR sky130_fd_sc_hd__decap_3
XFILLER_48_223 VGND VGND VPWR VPWR sky130_fd_sc_hd__decap_3
XFILLER_62_1166 VGND VGND VPWR VPWR sky130_fd_sc_hd__fill_1
XFILLER_0_296 VGND VGND VPWR VPWR sky130_fd_sc_hd__decap_3
XFILLER_7_1369 VGND VGND VPWR VPWR sky130_fd_sc_hd__decap_3
XFILLER_49_768 VGND VGND VPWR VPWR sky130_fd_sc_hd__decap_3
XFILLER_76_565 VGND VGND VPWR VPWR sky130_fd_sc_hd__fill_2
XFILLER_48_256 VGND VGND VPWR VPWR sky130_fd_sc_hd__decap_3
XFILLER_62_1199 VGND VGND VPWR VPWR sky130_fd_sc_hd__decap_3
XFILLER_40_1453 VGND VGND VPWR VPWR sky130_fd_sc_hd__decap_3
XFILLER_17_610 VGND VGND VPWR VPWR sky130_fd_sc_hd__decap_3
XFILLER_29_492 VGND VGND VPWR VPWR sky130_fd_sc_hd__decap_3
XFILLER_16_120 VGND VGND VPWR VPWR sky130_fd_sc_hd__decap_3
XFILLER_72_760 VGND VGND VPWR VPWR sky130_fd_sc_hd__decap_3
XFILLER_44_462 VGND VGND VPWR VPWR sky130_fd_sc_hd__decap_3
XFILLER_17_687 VGND VGND VPWR VPWR sky130_fd_sc_hd__decap_3
XFILLER_71_281 VGND VGND VPWR VPWR sky130_fd_sc_hd__decap_3
XFILLER_16_197 VGND VGND VPWR VPWR sky130_fd_sc_hd__decap_3
XFILLER_72_71 VGND VGND VPWR VPWR sky130_fd_sc_hd__fill_1
XFILLER_31_134 VGND VGND VPWR VPWR sky130_fd_sc_hd__decap_3
XFILLER_32_657 VGND VGND VPWR VPWR sky130_fd_sc_hd__decap_3
XFILLER_73_1251 VGND VGND VPWR VPWR sky130_fd_sc_hd__decap_3
XFILLER_38_1371 VGND VGND VPWR VPWR sky130_fd_sc_hd__fill_1
XFILLER_60_977 VGND VGND VPWR VPWR sky130_fd_sc_hd__decap_3
XFILLER_31_156 VGND VGND VPWR VPWR sky130_fd_sc_hd__fill_1
XFILLER_38_1382 VGND VGND VPWR VPWR sky130_fd_sc_hd__decap_3
XFILLER_73_1284 VGND VGND VPWR VPWR sky130_fd_sc_hd__decap_3
XFILLER_73_1295 VGND VGND VPWR VPWR sky130_fd_sc_hd__decap_3
XFILLER_34_1257 VGND VGND VPWR VPWR sky130_fd_sc_hd__decap_3
XFILLER_9_853 VGND VGND VPWR VPWR sky130_fd_sc_hd__decap_3
XFILLER_8_330 VGND VGND VPWR VPWR sky130_fd_sc_hd__decap_3
XFILLER_34_1279 VGND VGND VPWR VPWR sky130_fd_sc_hd__decap_3
XFILLER_9_886 VGND VGND VPWR VPWR sky130_fd_sc_hd__decap_3
XFILLER_9_897 VGND VGND VPWR VPWR sky130_fd_sc_hd__decap_3
XFILLER_8_363 VGND VGND VPWR VPWR sky130_fd_sc_hd__fill_1
X_4410_ _6277_/Q _4593_/A2 _4407_/X _4409_/X VGND VGND VPWR VPWR _6277_/D sky130_fd_sc_hd__o22a_2
X_5390_ _5390_/A1 _5480_/A2 _3935_/X VGND VGND VPWR VPWR _6502_/D sky130_fd_sc_hd__a21o_2
X_4341_ _6342_/Q _4832_/A2 _3270_/X _4713_/B2 VGND VGND VPWR VPWR _4341_/X sky130_fd_sc_hd__a22o_2
X_7060_ _7060_/CLK _7060_/D load_slew782/X VGND VGND VPWR VPWR _7060_/Q sky130_fd_sc_hd__dfrtp_2
X_4272_ _4338_/A _4844_/B _4268_/X _4787_/C1 VGND VGND VPWR VPWR _4272_/X sky130_fd_sc_hd__o2bb2a_2
Xfanout309 _3108_/Y VGND VGND VPWR VPWR _3223_/A1 sky130_fd_sc_hd__clkdlybuf4s25_1
XFILLER_80_1211 VGND VGND VPWR VPWR sky130_fd_sc_hd__decap_3
XFILLER_45_1331 VGND VGND VPWR VPWR sky130_fd_sc_hd__decap_3
X_6011_ _6011_/A0 _6011_/A1 _6051_/S VGND VGND VPWR VPWR _7015_/D sky130_fd_sc_hd__mux2_1
XFILLER_80_1233 VGND VGND VPWR VPWR sky130_fd_sc_hd__decap_3
X_3223_ _3223_/A1 _3221_/X _3222_/X _3223_/C1 VGND VGND VPWR VPWR _3223_/X sky130_fd_sc_hd__a211o_2
XFILLER_39_201 VGND VGND VPWR VPWR sky130_fd_sc_hd__decap_3
XTAP_TAPCELL_ROW_52_1543 VGND VPWR sky130_fd_sc_hd__tapvpwrvgnd_1
XTAP_TAPCELL_ROW_52_1554 VGND VPWR sky130_fd_sc_hd__tapvpwrvgnd_1
XFILLER_45_1375 VGND VGND VPWR VPWR sky130_fd_sc_hd__decap_3
XTAP_TAPCELL_ROW_52_1565 VGND VPWR sky130_fd_sc_hd__tapvpwrvgnd_1
XFILLER_39_234 VGND VGND VPWR VPWR sky130_fd_sc_hd__decap_3
X_3154_ _7045_/Q _7053_/Q _3200_/S VGND VGND VPWR VPWR _3154_/X sky130_fd_sc_hd__mux2_1
XFILLER_41_1239 VGND VGND VPWR VPWR sky130_fd_sc_hd__decap_3
XFILLER_39_278 VGND VGND VPWR VPWR sky130_fd_sc_hd__fill_2
X_3085_ _4428_/A _5512_/A VGND VGND VPWR VPWR _3085_/Y sky130_fd_sc_hd__nand2_2
XFILLER_54_237 VGND VGND VPWR VPWR sky130_fd_sc_hd__decap_3
X_6913_ _6913_/CLK _6913_/D fanout730/X VGND VGND VPWR VPWR _6913_/Q sky130_fd_sc_hd__dfrtp_2
XFILLER_35_440 VGND VGND VPWR VPWR sky130_fd_sc_hd__decap_3
XFILLER_78_1173 VGND VGND VPWR VPWR sky130_fd_sc_hd__decap_3
XTAP_TAPCELL_ROW_18_660 VGND VPWR sky130_fd_sc_hd__tapvpwrvgnd_1
XFILLER_74_1026 VGND VGND VPWR VPWR sky130_fd_sc_hd__fill_2
XTAP_TAPCELL_ROW_18_671 VGND VPWR sky130_fd_sc_hd__tapvpwrvgnd_1
XFILLER_74_1037 VGND VGND VPWR VPWR sky130_fd_sc_hd__decap_3
X_6844_ _6987_/CLK _6844_/D load_slew834/X VGND VGND VPWR VPWR _6844_/Q sky130_fd_sc_hd__dfrtp_2
XFILLER_23_657 VGND VGND VPWR VPWR sky130_fd_sc_hd__decap_3
XFILLER_51_977 VGND VGND VPWR VPWR sky130_fd_sc_hd__fill_1
XFILLER_17_1422 VGND VGND VPWR VPWR sky130_fd_sc_hd__decap_3
X_6775_ _6900_/CLK _6775_/D load_slew825/X VGND VGND VPWR VPWR _6775_/Q sky130_fd_sc_hd__dfrtp_2
X_3987_ _3486_/B _3984_/X _3985_/Y _3986_/X _4582_/A VGND VGND VPWR VPWR _3987_/X
+ sky130_fd_sc_hd__o221a_2
XFILLER_10_329 VGND VGND VPWR VPWR sky130_fd_sc_hd__decap_3
XFILLER_17_1455 VGND VGND VPWR VPWR sky130_fd_sc_hd__fill_1
XFILLER_52_1335 VGND VGND VPWR VPWR sky130_fd_sc_hd__decap_3
X_5726_ _5901_/A0 _5726_/A1 _5730_/S VGND VGND VPWR VPWR _6773_/D sky130_fd_sc_hd__mux2_1
XFILLER_17_1466 VGND VGND VPWR VPWR sky130_fd_sc_hd__decap_3
XFILLER_31_690 VGND VGND VPWR VPWR sky130_fd_sc_hd__fill_1
XFILLER_13_1319 VGND VGND VPWR VPWR sky130_fd_sc_hd__decap_3
XFILLER_52_1368 VGND VGND VPWR VPWR sky130_fd_sc_hd__decap_3
XFILLER_52_1379 VGND VGND VPWR VPWR sky130_fd_sc_hd__decap_3
X_5657_ _5657_/A0 _5932_/A0 _5657_/S VGND VGND VPWR VPWR _6713_/D sky130_fd_sc_hd__mux2_1
X_4608_ _4783_/A _4608_/B _4783_/C VGND VGND VPWR VPWR _4658_/S sky130_fd_sc_hd__or3_2
X_5588_ _5606_/A1 _5591_/A2 _5588_/A3 _5592_/B1 _5588_/B2 VGND VGND VPWR VPWR _6661_/D
+ sky130_fd_sc_hd__a32o_2
XFILLER_11_1087 VGND VGND VPWR VPWR sky130_fd_sc_hd__decap_3
X_4539_ _6294_/Q wire52/X _4536_/X _4538_/X VGND VGND VPWR VPWR _6294_/D sky130_fd_sc_hd__o22a_2
XFILLER_77_27 VGND VGND VPWR VPWR sky130_fd_sc_hd__decap_3
Xfanout821 fanout823/X VGND VGND VPWR VPWR fanout821/X sky130_fd_sc_hd__clkdlybuf4s25_1
XFILLER_63_1431 VGND VGND VPWR VPWR sky130_fd_sc_hd__decap_3
Xfanout832 fanout847/X VGND VGND VPWR VPWR fanout832/X sky130_fd_sc_hd__clkdlybuf4s25_1
X_6209_ _7060_/CLK _6209_/D load_slew782/X VGND VGND VPWR VPWR _6209_/Q sky130_fd_sc_hd__dfrtp_2
XTAP_TAPCELL_ROW_5_322 VGND VPWR sky130_fd_sc_hd__tapvpwrvgnd_1
XFILLER_24_1415 VGND VGND VPWR VPWR sky130_fd_sc_hd__decap_3
XFILLER_58_510 VGND VGND VPWR VPWR sky130_fd_sc_hd__decap_3
XTAP_TAPCELL_ROW_5_333 VGND VPWR sky130_fd_sc_hd__tapvpwrvgnd_1
XFILLER_24_1459 VGND VGND VPWR VPWR sky130_fd_sc_hd__decap_3
Xhold1030 _7003_/Q VGND VGND VPWR VPWR _5999_/A1 sky130_fd_sc_hd__dlygate4sd3_1
Xhold1041 _6708_/Q VGND VGND VPWR VPWR _5652_/A0 sky130_fd_sc_hd__dlygate4sd3_1
XFILLER_46_716 VGND VGND VPWR VPWR sky130_fd_sc_hd__decap_3
XFILLER_2_1200 VGND VGND VPWR VPWR sky130_fd_sc_hd__decap_3
XFILLER_18_418 VGND VGND VPWR VPWR sky130_fd_sc_hd__fill_2
Xhold1052 _7042_/Q VGND VGND VPWR VPWR _6038_/A1 sky130_fd_sc_hd__dlygate4sd3_1
XFILLER_2_1211 VGND VGND VPWR VPWR sky130_fd_sc_hd__decap_3
Xhold1063 _6159_/Q VGND VGND VPWR VPWR _6006_/A0 sky130_fd_sc_hd__dlygate4sd3_1
Xhold1074 _6814_/Q VGND VGND VPWR VPWR _5779_/A0 sky130_fd_sc_hd__dlygate4sd3_1
Xhold1085 _6713_/Q VGND VGND VPWR VPWR _5657_/A0 sky130_fd_sc_hd__dlygate4sd3_1
XFILLER_6_1391 VGND VGND VPWR VPWR sky130_fd_sc_hd__decap_3
XFILLER_27_930 VGND VGND VPWR VPWR sky130_fd_sc_hd__decap_3
XTAP_TAPCELL_ROW_29_947 VGND VPWR sky130_fd_sc_hd__tapvpwrvgnd_1
Xhold1096 _6709_/Q VGND VGND VPWR VPWR _5653_/A0 sky130_fd_sc_hd__dlygate4sd3_1
XFILLER_2_1244 VGND VGND VPWR VPWR sky130_fd_sc_hd__decap_3
XTAP_TAPCELL_ROW_29_958 VGND VPWR sky130_fd_sc_hd__tapvpwrvgnd_1
XFILLER_61_719 VGND VGND VPWR VPWR sky130_fd_sc_hd__decap_3
XTAP_TAPCELL_ROW_16_608 VGND VPWR sky130_fd_sc_hd__tapvpwrvgnd_1
XFILLER_26_451 VGND VGND VPWR VPWR sky130_fd_sc_hd__decap_3
XFILLER_14_602 VGND VGND VPWR VPWR sky130_fd_sc_hd__decap_3
XFILLER_2_1288 VGND VGND VPWR VPWR sky130_fd_sc_hd__decap_3
XTAP_TAPCELL_ROW_16_619 VGND VPWR sky130_fd_sc_hd__tapvpwrvgnd_1
XFILLER_60_229 VGND VGND VPWR VPWR sky130_fd_sc_hd__fill_2
XFILLER_18_1208 VGND VGND VPWR VPWR sky130_fd_sc_hd__decap_3
XFILLER_53_281 VGND VGND VPWR VPWR sky130_fd_sc_hd__fill_1
XFILLER_57_1257 VGND VGND VPWR VPWR sky130_fd_sc_hd__decap_3
XFILLER_42_955 VGND VGND VPWR VPWR sky130_fd_sc_hd__decap_3
XFILLER_14_657 VGND VGND VPWR VPWR sky130_fd_sc_hd__decap_3
XFILLER_13_145 VGND VGND VPWR VPWR sky130_fd_sc_hd__decap_3
XFILLER_42_988 VGND VGND VPWR VPWR sky130_fd_sc_hd__fill_2
XFILLER_9_116 VGND VGND VPWR VPWR sky130_fd_sc_hd__fill_2
XFILLER_41_476 VGND VGND VPWR VPWR sky130_fd_sc_hd__decap_3
XFILLER_70_1424 VGND VGND VPWR VPWR sky130_fd_sc_hd__decap_3
XFILLER_13_178 VGND VGND VPWR VPWR sky130_fd_sc_hd__decap_3
XFILLER_70_1435 VGND VGND VPWR VPWR sky130_fd_sc_hd__decap_3
XFILLER_9_127 VGND VGND VPWR VPWR sky130_fd_sc_hd__decap_3
XFILLER_42_52 VGND VGND VPWR VPWR sky130_fd_sc_hd__decap_3
XFILLER_10_830 VGND VGND VPWR VPWR sky130_fd_sc_hd__decap_3
XFILLER_22_690 VGND VGND VPWR VPWR sky130_fd_sc_hd__fill_2
XFILLER_70_1468 VGND VGND VPWR VPWR sky130_fd_sc_hd__fill_1
XFILLER_31_1419 VGND VGND VPWR VPWR sky130_fd_sc_hd__decap_3
XFILLER_6_801 VGND VGND VPWR VPWR sky130_fd_sc_hd__decap_3
XFILLER_42_85 VGND VGND VPWR VPWR sky130_fd_sc_hd__decap_3
XFILLER_6_845 VGND VGND VPWR VPWR sky130_fd_sc_hd__fill_2
XFILLER_68_1320 VGND VGND VPWR VPWR sky130_fd_sc_hd__decap_3
XFILLER_29_1304 VGND VGND VPWR VPWR sky130_fd_sc_hd__decap_3
XFILLER_68_1353 VGND VGND VPWR VPWR sky130_fd_sc_hd__decap_3
XFILLER_5_399 VGND VGND VPWR VPWR sky130_fd_sc_hd__decap_3
XFILLER_47_9 VGND VGND VPWR VPWR sky130_fd_sc_hd__decap_3
XFILLER_29_1337 VGND VGND VPWR VPWR sky130_fd_sc_hd__decap_3
XFILLER_64_1217 VGND VGND VPWR VPWR sky130_fd_sc_hd__decap_3
XFILLER_29_1348 VGND VGND VPWR VPWR sky130_fd_sc_hd__decap_3
XFILLER_68_1397 VGND VGND VPWR VPWR sky130_fd_sc_hd__decap_3
XFILLER_3_24 VGND VGND VPWR VPWR sky130_fd_sc_hd__decap_3
XFILLER_1_561 VGND VGND VPWR VPWR sky130_fd_sc_hd__decap_3
XFILLER_3_57 VGND VGND VPWR VPWR sky130_fd_sc_hd__decap_3
XFILLER_7_1133 VGND VGND VPWR VPWR sky130_fd_sc_hd__decap_3
XFILLER_49_532 VGND VGND VPWR VPWR sky130_fd_sc_hd__decap_3
XTAP_TAPCELL_ROW_69_2004 VGND VPWR sky130_fd_sc_hd__tapvpwrvgnd_1
XFILLER_67_60 VGND VGND VPWR VPWR sky130_fd_sc_hd__decap_3
XFILLER_7_1166 VGND VGND VPWR VPWR sky130_fd_sc_hd__decap_3
XFILLER_77_874 VGND VGND VPWR VPWR sky130_fd_sc_hd__fill_1
XFILLER_37_705 VGND VGND VPWR VPWR sky130_fd_sc_hd__decap_3
XFILLER_7_1177 VGND VGND VPWR VPWR sky130_fd_sc_hd__decap_3
XFILLER_76_373 VGND VGND VPWR VPWR sky130_fd_sc_hd__decap_3
XFILLER_49_598 VGND VGND VPWR VPWR sky130_fd_sc_hd__decap_3
XFILLER_76_395 VGND VGND VPWR VPWR sky130_fd_sc_hd__decap_3
XFILLER_40_1261 VGND VGND VPWR VPWR sky130_fd_sc_hd__decap_3
XFILLER_79_1460 VGND VGND VPWR VPWR sky130_fd_sc_hd__decap_3
XFILLER_36_259 VGND VGND VPWR VPWR sky130_fd_sc_hd__decap_3
XFILLER_40_1294 VGND VGND VPWR VPWR sky130_fd_sc_hd__decap_3
XFILLER_45_760 VGND VGND VPWR VPWR sky130_fd_sc_hd__decap_3
XFILLER_75_1313 VGND VGND VPWR VPWR sky130_fd_sc_hd__decap_3
XFILLER_17_473 VGND VGND VPWR VPWR sky130_fd_sc_hd__decap_3
X_3910_ _3485_/B _3890_/X _3909_/X VGND VGND VPWR VPWR _3910_/X sky130_fd_sc_hd__o21a_2
X_4890_ _6318_/Q wire503/X _3462_/X wire383/X VGND VGND VPWR VPWR _4890_/X sky130_fd_sc_hd__a22o_2
XFILLER_75_1357 VGND VGND VPWR VPWR sky130_fd_sc_hd__decap_3
X_3841_ _6291_/Q _3960_/B _3921_/B1 _6267_/Q _3921_/C1 VGND VGND VPWR VPWR _3841_/X
+ sky130_fd_sc_hd__a221o_2
XFILLER_34_1010 VGND VGND VPWR VPWR sky130_fd_sc_hd__decap_3
XFILLER_38_1190 VGND VGND VPWR VPWR sky130_fd_sc_hd__fill_1
XFILLER_80_3 VGND VGND VPWR VPWR sky130_fd_sc_hd__decap_3
XFILLER_32_498 VGND VGND VPWR VPWR sky130_fd_sc_hd__decap_3
XTAP_TAPCELL_ROW_45_1380 VGND VPWR sky130_fd_sc_hd__tapvpwrvgnd_1
XFILLER_34_1043 VGND VGND VPWR VPWR sky130_fd_sc_hd__decap_3
X_3772_ _3960_/A _6232_/Q VGND VGND VPWR VPWR _3772_/X sky130_fd_sc_hd__and2b_2
X_6560_ _7090_/CLK _6560_/D fanout721/X VGND VGND VPWR VPWR _6560_/Q sky130_fd_sc_hd__dfrtp_2
XFILLER_9_661 VGND VGND VPWR VPWR sky130_fd_sc_hd__decap_3
XTAP_TAPCELL_ROW_41_1255 VGND VPWR sky130_fd_sc_hd__tapvpwrvgnd_1
X_5511_ _7083_/D _5511_/B VGND VGND VPWR VPWR _5513_/C sky130_fd_sc_hd__nand2_2
X_6491_ _6929_/CLK _6491_/D fanout703/X VGND VGND VPWR VPWR _6491_/Q sky130_fd_sc_hd__dfrtp_2
XTAP_TAPCELL_ROW_41_1266 VGND VPWR sky130_fd_sc_hd__tapvpwrvgnd_1
XTAP_TAPCELL_ROW_41_1277 VGND VPWR sky130_fd_sc_hd__tapvpwrvgnd_1
XFILLER_12_1341 VGND VGND VPWR VPWR sky130_fd_sc_hd__decap_3
X_5442_ _5442_/A1 _5477_/A2 _4683_/X VGND VGND VPWR VPWR _6554_/D sky130_fd_sc_hd__a21o_2
XFILLER_51_1390 VGND VGND VPWR VPWR sky130_fd_sc_hd__decap_3
XFILLER_8_193 VGND VGND VPWR VPWR sky130_fd_sc_hd__decap_3
XFILLER_12_1385 VGND VGND VPWR VPWR sky130_fd_sc_hd__decap_3
X_5373_ _5373_/A1 _5477_/A2 _4244_/X VGND VGND VPWR VPWR _6485_/D sky130_fd_sc_hd__a21o_2
XFILLER_47_1404 VGND VGND VPWR VPWR sky130_fd_sc_hd__decap_3
XTAP_TAPCELL_ROW_54_1605 VGND VPWR sky130_fd_sc_hd__tapvpwrvgnd_1
XTAP_TAPCELL_ROW_54_1616 VGND VPWR sky130_fd_sc_hd__tapvpwrvgnd_1
X_7112_ _7112_/A VGND VGND VPWR VPWR uio_out[7] sky130_fd_sc_hd__buf_2
X_4324_ _3889_/A _3889_/B _4562_/C _4842_/B _4394_/A VGND VGND VPWR VPWR _4324_/X
+ sky130_fd_sc_hd__o2111a_2
XFILLER_47_1437 VGND VGND VPWR VPWR sky130_fd_sc_hd__decap_3
Xfanout106 _5290_/A2 VGND VGND VPWR VPWR _5281_/A2 sky130_fd_sc_hd__clkdlybuf4s25_1
Xfanout117 fanout121/X VGND VGND VPWR VPWR _5263_/A2 sky130_fd_sc_hd__clkdlybuf4s25_1
X_7043_ _7051_/CLK _7043_/D load_slew815/X VGND VGND VPWR VPWR _7043_/Q sky130_fd_sc_hd__dfrtp_2
Xfanout128 _4900_/X VGND VGND VPWR VPWR _5357_/S sky130_fd_sc_hd__clkdlybuf4s25_1
X_4255_ _6824_/Q _4833_/A2 _4255_/B1 _4254_/X VGND VGND VPWR VPWR _4255_/X sky130_fd_sc_hd__a211o_2
Xfanout139 _4586_/C VGND VGND VPWR VPWR _4562_/C sky130_fd_sc_hd__clkdlybuf4s25_1
XFILLER_80_1052 VGND VGND VPWR VPWR sky130_fd_sc_hd__decap_3
XFILLER_41_1003 VGND VGND VPWR VPWR sky130_fd_sc_hd__decap_3
X_3206_ _7048_/Q _7056_/Q _3206_/S VGND VGND VPWR VPWR _3206_/X sky130_fd_sc_hd__mux2_1
XFILLER_45_1183 VGND VGND VPWR VPWR sky130_fd_sc_hd__decap_3
XFILLER_67_340 VGND VGND VPWR VPWR sky130_fd_sc_hd__decap_3
XFILLER_80_1074 VGND VGND VPWR VPWR sky130_fd_sc_hd__decap_3
X_4186_ _6279_/Q _5358_/D _3240_/X _4780_/B2 VGND VGND VPWR VPWR _4186_/X sky130_fd_sc_hd__a22o_2
XFILLER_80_1096 VGND VGND VPWR VPWR sky130_fd_sc_hd__decap_3
XFILLER_41_1047 VGND VGND VPWR VPWR sky130_fd_sc_hd__decap_3
X_3137_ _6939_/Q _3136_/A _3136_/Y _3205_/B1 VGND VGND VPWR VPWR _3137_/X sky130_fd_sc_hd__a211o_2
X_3068_ _6364_/Q VGND VGND VPWR VPWR _3068_/Y sky130_fd_sc_hd__inv_2
XFILLER_36_760 VGND VGND VPWR VPWR sky130_fd_sc_hd__decap_3
XFILLER_63_18 VGND VGND VPWR VPWR sky130_fd_sc_hd__fill_1
XFILLER_24_922 VGND VGND VPWR VPWR sky130_fd_sc_hd__fill_2
XFILLER_35_281 VGND VGND VPWR VPWR sky130_fd_sc_hd__decap_3
XFILLER_24_977 VGND VGND VPWR VPWR sky130_fd_sc_hd__decap_3
X_6827_ _6923_/CLK _6827_/D fanout802/X VGND VGND VPWR VPWR _6827_/Q sky130_fd_sc_hd__dfrtp_2
XFILLER_51_774 VGND VGND VPWR VPWR sky130_fd_sc_hd__decap_3
XFILLER_23_476 VGND VGND VPWR VPWR sky130_fd_sc_hd__fill_1
XFILLER_50_262 VGND VGND VPWR VPWR sky130_fd_sc_hd__fill_1
XFILLER_51_785 VGND VGND VPWR VPWR sky130_fd_sc_hd__decap_3
XFILLER_23_498 VGND VGND VPWR VPWR sky130_fd_sc_hd__decap_3
XFILLER_11_649 VGND VGND VPWR VPWR sky130_fd_sc_hd__decap_3
X_6758_ _6918_/CLK _6758_/D load_slew744/X VGND VGND VPWR VPWR _6758_/Q sky130_fd_sc_hd__dfrtp_2
Xwire507 wire507/A VGND VGND VPWR VPWR wire507/X sky130_fd_sc_hd__clkbuf_4
XFILLER_7_609 VGND VGND VPWR VPWR sky130_fd_sc_hd__decap_3
XFILLER_17_1263 VGND VGND VPWR VPWR sky130_fd_sc_hd__decap_3
XFILLER_13_1127 VGND VGND VPWR VPWR sky130_fd_sc_hd__decap_3
X_5709_ _5911_/A0 _5709_/A1 wire89/X VGND VGND VPWR VPWR _6758_/D sky130_fd_sc_hd__mux2_1
XFILLER_52_1176 VGND VGND VPWR VPWR sky130_fd_sc_hd__decap_3
X_6689_ _6913_/CLK _6689_/D fanout729/X VGND VGND VPWR VPWR _6689_/Q sky130_fd_sc_hd__dfrtp_2
XFILLER_30_1441 VGND VGND VPWR VPWR sky130_fd_sc_hd__decap_3
XFILLER_3_815 VGND VGND VPWR VPWR sky130_fd_sc_hd__decap_3
XFILLER_2_303 VGND VGND VPWR VPWR sky130_fd_sc_hd__decap_3
XFILLER_3_859 VGND VGND VPWR VPWR sky130_fd_sc_hd__decap_3
XFILLER_2_336 VGND VGND VPWR VPWR sky130_fd_sc_hd__decap_3
XFILLER_78_627 VGND VGND VPWR VPWR sky130_fd_sc_hd__decap_3
XFILLER_78_638 VGND VGND VPWR VPWR sky130_fd_sc_hd__decap_3
Xfanout640 fanout667/X VGND VGND VPWR VPWR wire641/A sky130_fd_sc_hd__clkdlybuf4s25_1
Xfanout651 fanout653/X VGND VGND VPWR VPWR wire652/A sky130_fd_sc_hd__clkdlybuf4s25_1
XFILLER_8_1453 VGND VGND VPWR VPWR sky130_fd_sc_hd__decap_3
XFILLER_63_1272 VGND VGND VPWR VPWR sky130_fd_sc_hd__decap_3
XFILLER_59_863 VGND VGND VPWR VPWR sky130_fd_sc_hd__decap_3
XFILLER_4_1306 VGND VGND VPWR VPWR sky130_fd_sc_hd__decap_3
Xfanout673 fanout675/X VGND VGND VPWR VPWR fanout673/X sky130_fd_sc_hd__clkdlybuf4s25_1
XFILLER_4_1317 VGND VGND VPWR VPWR sky130_fd_sc_hd__decap_3
XFILLER_58_351 VGND VGND VPWR VPWR sky130_fd_sc_hd__decap_3
Xfanout695 fanout697/X VGND VGND VPWR VPWR fanout695/X sky130_fd_sc_hd__clkdlybuf4s25_1
XFILLER_24_1256 VGND VGND VPWR VPWR sky130_fd_sc_hd__decap_3
XFILLER_46_502 VGND VGND VPWR VPWR sky130_fd_sc_hd__decap_3
XFILLER_74_822 VGND VGND VPWR VPWR sky130_fd_sc_hd__decap_3
XFILLER_19_727 VGND VGND VPWR VPWR sky130_fd_sc_hd__fill_1
XFILLER_24_1267 VGND VGND VPWR VPWR sky130_fd_sc_hd__decap_3
XFILLER_46_557 VGND VGND VPWR VPWR sky130_fd_sc_hd__fill_2
XFILLER_59_1319 VGND VGND VPWR VPWR sky130_fd_sc_hd__decap_3
XFILLER_73_365 VGND VGND VPWR VPWR sky130_fd_sc_hd__decap_3
XFILLER_2_1052 VGND VGND VPWR VPWR sky130_fd_sc_hd__decap_3
XFILLER_15_900 VGND VGND VPWR VPWR sky130_fd_sc_hd__decap_3
XFILLER_61_505 VGND VGND VPWR VPWR sky130_fd_sc_hd__fill_1
XFILLER_27_771 VGND VGND VPWR VPWR sky130_fd_sc_hd__fill_1
XFILLER_2_1085 VGND VGND VPWR VPWR sky130_fd_sc_hd__decap_3
XFILLER_2_1096 VGND VGND VPWR VPWR sky130_fd_sc_hd__decap_3
XFILLER_14_421 VGND VGND VPWR VPWR sky130_fd_sc_hd__decap_3
XFILLER_57_1065 VGND VGND VPWR VPWR sky130_fd_sc_hd__decap_3
XFILLER_41_240 VGND VGND VPWR VPWR sky130_fd_sc_hd__decap_3
XFILLER_30_914 VGND VGND VPWR VPWR sky130_fd_sc_hd__decap_3
XFILLER_30_947 VGND VGND VPWR VPWR sky130_fd_sc_hd__decap_3
XFILLER_70_1232 VGND VGND VPWR VPWR sky130_fd_sc_hd__decap_3
XFILLER_35_1363 VGND VGND VPWR VPWR sky130_fd_sc_hd__decap_3
XFILLER_70_1276 VGND VGND VPWR VPWR sky130_fd_sc_hd__decap_3
XFILLER_35_1396 VGND VGND VPWR VPWR sky130_fd_sc_hd__decap_3
XFILLER_6_620 VGND VGND VPWR VPWR sky130_fd_sc_hd__decap_3
XFILLER_10_693 VGND VGND VPWR VPWR sky130_fd_sc_hd__decap_3
XFILLER_6_653 VGND VGND VPWR VPWR sky130_fd_sc_hd__decap_3
XFILLER_68_1172 VGND VGND VPWR VPWR sky130_fd_sc_hd__decap_3
XFILLER_45_6 VGND VGND VPWR VPWR sky130_fd_sc_hd__decap_3
XFILLER_29_1145 VGND VGND VPWR VPWR sky130_fd_sc_hd__decap_3
XFILLER_9_1228 VGND VGND VPWR VPWR sky130_fd_sc_hd__decap_3
XFILLER_9_1239 VGND VGND VPWR VPWR sky130_fd_sc_hd__decap_3
XFILLER_25_1009 VGND VGND VPWR VPWR sky130_fd_sc_hd__decap_3
XFILLER_69_638 VGND VGND VPWR VPWR sky130_fd_sc_hd__fill_2
XFILLER_2_881 VGND VGND VPWR VPWR sky130_fd_sc_hd__decap_3
XFILLER_68_126 VGND VGND VPWR VPWR sky130_fd_sc_hd__decap_3
XFILLER_42_1312 VGND VGND VPWR VPWR sky130_fd_sc_hd__decap_3
XFILLER_1_391 VGND VGND VPWR VPWR sky130_fd_sc_hd__fill_1
XFILLER_42_1323 VGND VGND VPWR VPWR sky130_fd_sc_hd__decap_3
X_4040_ _4040_/A1 _4694_/B _4586_/B _4008_/Y _6565_/Q VGND VGND VPWR VPWR _4040_/X
+ sky130_fd_sc_hd__a32o_2
XFILLER_49_340 VGND VGND VPWR VPWR sky130_fd_sc_hd__fill_2
XTAP_TAPCELL_ROW_34_1081 VGND VPWR sky130_fd_sc_hd__tapvpwrvgnd_1
XFILLER_65_811 VGND VGND VPWR VPWR sky130_fd_sc_hd__decap_3
XTAP_TAPCELL_ROW_34_1092 VGND VPWR sky130_fd_sc_hd__tapvpwrvgnd_1
XFILLER_42_1356 VGND VGND VPWR VPWR sky130_fd_sc_hd__decap_3
XFILLER_37_557 VGND VGND VPWR VPWR sky130_fd_sc_hd__decap_3
XFILLER_77_1419 VGND VGND VPWR VPWR sky130_fd_sc_hd__decap_3
XFILLER_25_708 VGND VGND VPWR VPWR sky130_fd_sc_hd__decap_3
X_5991_ hold968/X _6995_/Q _6031_/S VGND VGND VPWR VPWR _5991_/X sky130_fd_sc_hd__mux2_1
XTAP_TAPCELL_ROW_47_1420 VGND VPWR sky130_fd_sc_hd__tapvpwrvgnd_1
XFILLER_64_387 VGND VGND VPWR VPWR sky130_fd_sc_hd__decap_3
XFILLER_80_847 VGND VGND VPWR VPWR sky130_fd_sc_hd__decap_3
XFILLER_75_1121 VGND VGND VPWR VPWR sky130_fd_sc_hd__decap_3
XTAP_TAPCELL_ROW_47_1431 VGND VPWR sky130_fd_sc_hd__tapvpwrvgnd_1
X_4942_ _6687_/Q _3053_/Y _5213_/A VGND VGND VPWR VPWR _4942_/X sky130_fd_sc_hd__mux2_1
XFILLER_17_281 VGND VGND VPWR VPWR sky130_fd_sc_hd__decap_3
XFILLER_75_1154 VGND VGND VPWR VPWR sky130_fd_sc_hd__decap_3
XTAP_TAPCELL_ROW_43_1306 VGND VPWR sky130_fd_sc_hd__tapvpwrvgnd_1
XTAP_TAPCELL_ROW_43_1317 VGND VPWR sky130_fd_sc_hd__tapvpwrvgnd_1
X_4873_ _6588_/Q _4872_/A _4874_/A1 VGND VGND VPWR VPWR _4873_/X sky130_fd_sc_hd__a21bo_2
XFILLER_75_1198 VGND VGND VPWR VPWR sky130_fd_sc_hd__decap_3
XFILLER_32_262 VGND VGND VPWR VPWR sky130_fd_sc_hd__decap_3
XTAP_TAPCELL_ROW_43_1328 VGND VPWR sky130_fd_sc_hd__tapvpwrvgnd_1
XFILLER_33_796 VGND VGND VPWR VPWR sky130_fd_sc_hd__decap_3
X_6612_ _6617_/CLK _6612_/D load_slew732/X VGND VGND VPWR VPWR _6612_/Q sky130_fd_sc_hd__dfrtp_2
XFILLER_20_424 VGND VGND VPWR VPWR sky130_fd_sc_hd__fill_2
X_3824_ _3821_/Y _3822_/X _3758_/A _3758_/B VGND VGND VPWR VPWR _3827_/C sky130_fd_sc_hd__o211ai_2
XFILLER_14_1403 VGND VGND VPWR VPWR sky130_fd_sc_hd__decap_3
XFILLER_53_1452 VGND VGND VPWR VPWR sky130_fd_sc_hd__decap_3
XFILLER_53_1463 VGND VGND VPWR VPWR sky130_fd_sc_hd__decap_3
X_3755_ _3755_/A _3755_/B VGND VGND VPWR VPWR _3884_/A sky130_fd_sc_hd__or2_2
X_6543_ _6913_/CLK _6543_/D load_slew726/X VGND VGND VPWR VPWR _6543_/Q sky130_fd_sc_hd__dfrtp_2
XFILLER_14_1447 VGND VGND VPWR VPWR sky130_fd_sc_hd__decap_3
XTAP_TAPCELL_ROW_31_997 VGND VPWR sky130_fd_sc_hd__tapvpwrvgnd_1
X_3686_ _3687_/B _3679_/X _3786_/C _3685_/X VGND VGND VPWR VPWR _3881_/B sky130_fd_sc_hd__a31o_2
X_6474_ _6847_/CLK _6474_/D load_slew778/X VGND VGND VPWR VPWR _6474_/Q sky130_fd_sc_hd__dfrtp_2
XFILLER_12_1171 VGND VGND VPWR VPWR sky130_fd_sc_hd__decap_3
XPHY_EDGE_ROW_12_Right_12 VGND VGND VPWR VPWR sky130_fd_sc_hd__decap_3
X_5425_ _5425_/A1 _5461_/A2 _4558_/X VGND VGND VPWR VPWR _6537_/D sky130_fd_sc_hd__a21o_2
X_5356_ _6809_/Q _5128_/B _5356_/S VGND VGND VPWR VPWR _5356_/X sky130_fd_sc_hd__mux2_1
XFILLER_47_1245 VGND VGND VPWR VPWR sky130_fd_sc_hd__decap_3
X_4307_ _6491_/Q _3483_/A _4831_/C1 _4306_/Y VGND VGND VPWR VPWR _4307_/X sky130_fd_sc_hd__o211a_2
XFILLER_47_1278 VGND VGND VPWR VPWR sky130_fd_sc_hd__decap_3
X_5287_ _6437_/Q _5287_/A2 _5286_/X VGND VGND VPWR VPWR _6437_/D sky130_fd_sc_hd__a21o_2
XFILLER_47_1289 VGND VGND VPWR VPWR sky130_fd_sc_hd__decap_3
XFILLER_60_1412 VGND VGND VPWR VPWR sky130_fd_sc_hd__decap_3
X_4238_ _6260_/Q wire60/X _4235_/X _4237_/X VGND VGND VPWR VPWR _6260_/D sky130_fd_sc_hd__o22a_2
X_7026_ _7037_/CLK _7026_/D load_slew692/X VGND VGND VPWR VPWR _7026_/Q sky130_fd_sc_hd__dfrtp_2
XFILLER_21_1407 VGND VGND VPWR VPWR sky130_fd_sc_hd__decap_3
XFILLER_60_1456 VGND VGND VPWR VPWR sky130_fd_sc_hd__decap_3
X_4169_ _6478_/Q _3915_/X _4169_/S VGND VGND VPWR VPWR _4169_/X sky130_fd_sc_hd__mux2_1
XPHY_EDGE_ROW_21_Right_21 VGND VGND VPWR VPWR sky130_fd_sc_hd__decap_3
XFILLER_3_1372 VGND VGND VPWR VPWR sky130_fd_sc_hd__decap_3
XFILLER_43_516 VGND VGND VPWR VPWR sky130_fd_sc_hd__decap_3
XFILLER_71_858 VGND VGND VPWR VPWR sky130_fd_sc_hd__decap_3
XFILLER_43_549 VGND VGND VPWR VPWR sky130_fd_sc_hd__decap_3
XFILLER_58_1341 VGND VGND VPWR VPWR sky130_fd_sc_hd__decap_3
XFILLER_24_752 VGND VGND VPWR VPWR sky130_fd_sc_hd__decap_3
XFILLER_12_903 VGND VGND VPWR VPWR sky130_fd_sc_hd__decap_3
XFILLER_19_1325 VGND VGND VPWR VPWR sky130_fd_sc_hd__decap_3
XFILLER_70_379 VGND VGND VPWR VPWR sky130_fd_sc_hd__decap_3
XFILLER_12_914 VGND VGND VPWR VPWR sky130_fd_sc_hd__fill_2
XFILLER_58_1385 VGND VGND VPWR VPWR sky130_fd_sc_hd__decap_3
XFILLER_12_925 VGND VGND VPWR VPWR sky130_fd_sc_hd__fill_1
XFILLER_54_1238 VGND VGND VPWR VPWR sky130_fd_sc_hd__decap_3
XFILLER_19_1369 VGND VGND VPWR VPWR sky130_fd_sc_hd__decap_3
XFILLER_12_958 VGND VGND VPWR VPWR sky130_fd_sc_hd__decap_3
XFILLER_8_907 VGND VGND VPWR VPWR sky130_fd_sc_hd__decap_3
XFILLER_11_446 VGND VGND VPWR VPWR sky130_fd_sc_hd__fill_2
XFILLER_23_54 VGND VGND VPWR VPWR sky130_fd_sc_hd__fill_2
XFILLER_11_468 VGND VGND VPWR VPWR sky130_fd_sc_hd__decap_3
XFILLER_7_417 VGND VGND VPWR VPWR sky130_fd_sc_hd__decap_3
XFILLER_17_1071 VGND VGND VPWR VPWR sky130_fd_sc_hd__fill_1
XPHY_EDGE_ROW_30_Right_30 VGND VGND VPWR VPWR sky130_fd_sc_hd__decap_3
XFILLER_3_612 VGND VGND VPWR VPWR sky130_fd_sc_hd__decap_3
XFILLER_3_623 VGND VGND VPWR VPWR sky130_fd_sc_hd__decap_3
XFILLER_30_1282 VGND VGND VPWR VPWR sky130_fd_sc_hd__decap_3
XFILLER_2_100 VGND VGND VPWR VPWR sky130_fd_sc_hd__decap_3
XFILLER_65_1301 VGND VGND VPWR VPWR sky130_fd_sc_hd__decap_3
XFILLER_79_903 VGND VGND VPWR VPWR sky130_fd_sc_hd__decap_3
XFILLER_2_133 VGND VGND VPWR VPWR sky130_fd_sc_hd__decap_3
XFILLER_3_667 VGND VGND VPWR VPWR sky130_fd_sc_hd__decap_3
XFILLER_2_144 VGND VGND VPWR VPWR sky130_fd_sc_hd__decap_3
XFILLER_65_1334 VGND VGND VPWR VPWR sky130_fd_sc_hd__decap_3
XFILLER_65_1345 VGND VGND VPWR VPWR sky130_fd_sc_hd__decap_3
XFILLER_78_402 VGND VGND VPWR VPWR sky130_fd_sc_hd__decap_3
XFILLER_79_936 VGND VGND VPWR VPWR sky130_fd_sc_hd__decap_3
XFILLER_2_177 VGND VGND VPWR VPWR sky130_fd_sc_hd__decap_3
XFILLER_26_1329 VGND VGND VPWR VPWR sky130_fd_sc_hd__decap_3
XFILLER_65_1378 VGND VGND VPWR VPWR sky130_fd_sc_hd__decap_3
XFILLER_78_457 VGND VGND VPWR VPWR sky130_fd_sc_hd__decap_3
XFILLER_8_1250 VGND VGND VPWR VPWR sky130_fd_sc_hd__decap_3
XFILLER_8_1261 VGND VGND VPWR VPWR sky130_fd_sc_hd__decap_3
XFILLER_48_51 VGND VGND VPWR VPWR sky130_fd_sc_hd__decap_3
XFILLER_47_800 VGND VGND VPWR VPWR sky130_fd_sc_hd__decap_3
XFILLER_63_1080 VGND VGND VPWR VPWR sky130_fd_sc_hd__decap_3
Xfanout470 _5358_/C VGND VGND VPWR VPWR _4779_/A1 sky130_fd_sc_hd__clkdlybuf4s25_1
Xfanout481 _4756_/A1 VGND VGND VPWR VPWR _4741_/C1 sky130_fd_sc_hd__clkdlybuf4s25_1
XFILLER_4_1114 VGND VGND VPWR VPWR sky130_fd_sc_hd__decap_3
XFILLER_8_1294 VGND VGND VPWR VPWR sky130_fd_sc_hd__decap_3
XFILLER_47_833 VGND VGND VPWR VPWR sky130_fd_sc_hd__fill_2
XFILLER_59_693 VGND VGND VPWR VPWR sky130_fd_sc_hd__fill_1
XFILLER_4_1147 VGND VGND VPWR VPWR sky130_fd_sc_hd__fill_1
Xclkbuf_leaf_85_clk clkbuf_leaf_2_clk/A VGND VGND VPWR VPWR _7048_/CLK sky130_fd_sc_hd__clkbuf_8
XFILLER_4_1158 VGND VGND VPWR VPWR sky130_fd_sc_hd__decap_3
XFILLER_19_557 VGND VGND VPWR VPWR sky130_fd_sc_hd__decap_3
XFILLER_0_47 VGND VGND VPWR VPWR sky130_fd_sc_hd__decap_3
XFILLER_46_365 VGND VGND VPWR VPWR sky130_fd_sc_hd__decap_3
XFILLER_0_69 VGND VGND VPWR VPWR sky130_fd_sc_hd__decap_3
XFILLER_46_376 VGND VGND VPWR VPWR sky130_fd_sc_hd__decap_3
XFILLER_76_1441 VGND VGND VPWR VPWR sky130_fd_sc_hd__decap_3
XFILLER_37_1425 VGND VGND VPWR VPWR sky130_fd_sc_hd__decap_3
XFILLER_9_12 VGND VGND VPWR VPWR sky130_fd_sc_hd__decap_3
XFILLER_15_774 VGND VGND VPWR VPWR sky130_fd_sc_hd__decap_3
XFILLER_72_1338 VGND VGND VPWR VPWR sky130_fd_sc_hd__decap_3
XFILLER_14_273 VGND VGND VPWR VPWR sky130_fd_sc_hd__decap_3
XFILLER_9_45 VGND VGND VPWR VPWR sky130_fd_sc_hd__decap_3
XFILLER_30_722 VGND VGND VPWR VPWR sky130_fd_sc_hd__decap_3
XFILLER_9_67 VGND VGND VPWR VPWR sky130_fd_sc_hd__decap_3
XFILLER_30_744 VGND VGND VPWR VPWR sky130_fd_sc_hd__decap_3
XFILLER_80_60 VGND VGND VPWR VPWR sky130_fd_sc_hd__fill_1
XFILLER_70_1040 VGND VGND VPWR VPWR sky130_fd_sc_hd__fill_2
XFILLER_9_89 VGND VGND VPWR VPWR sky130_fd_sc_hd__fill_1
XFILLER_80_82 VGND VGND VPWR VPWR sky130_fd_sc_hd__fill_2
XFILLER_30_799 VGND VGND VPWR VPWR sky130_fd_sc_hd__decap_3
XFILLER_31_1035 VGND VGND VPWR VPWR sky130_fd_sc_hd__decap_3
X_3540_ _6267_/Q _5594_/A1 _5603_/A1 _6259_/Q VGND VGND VPWR VPWR _3540_/X sky130_fd_sc_hd__a22o_2
XFILLER_31_1057 VGND VGND VPWR VPWR sky130_fd_sc_hd__decap_3
Xhold907 _6183_/Q VGND VGND VPWR VPWR hold907/X sky130_fd_sc_hd__dlygate4sd3_1
XFILLER_6_461 VGND VGND VPWR VPWR sky130_fd_sc_hd__decap_3
Xhold918 _5934_/X VGND VGND VPWR VPWR _6938_/D sky130_fd_sc_hd__dlygate4sd3_1
X_3471_ hold923/X _3470_/X _3477_/S VGND VGND VPWR VPWR _6209_/D sky130_fd_sc_hd__mux2_1
Xhold929 _6633_/Q VGND VGND VPWR VPWR hold929/X sky130_fd_sc_hd__dlygate4sd3_1
X_5210_ _5210_/A _5210_/B VGND VGND VPWR VPWR _5210_/Y sky130_fd_sc_hd__nand2_2
XFILLER_43_3 VGND VGND VPWR VPWR sky130_fd_sc_hd__decap_3
X_6190_ _7041_/CLK _6190_/D load_slew726/X VGND VGND VPWR VPWR _6190_/Q sky130_fd_sc_hd__dfrtp_2
XFILLER_9_1003 VGND VGND VPWR VPWR sky130_fd_sc_hd__decap_3
Xload_slew810 fanout809/X VGND VGND VPWR VPWR load_slew810/X sky130_fd_sc_hd__buf_2
XTAP_TAPCELL_ROW_36_1132 VGND VPWR sky130_fd_sc_hd__tapvpwrvgnd_1
XTAP_TAPCELL_ROW_36_1143 VGND VPWR sky130_fd_sc_hd__tapvpwrvgnd_1
X_5141_ _6379_/Q wire105/X _4929_/S _5140_/X VGND VGND VPWR VPWR _6379_/D sky130_fd_sc_hd__a22o_2
XFILLER_44_1418 VGND VGND VPWR VPWR sky130_fd_sc_hd__decap_3
XFILLER_44_1429 VGND VGND VPWR VPWR sky130_fd_sc_hd__decap_3
Xload_slew843 fanout842/X VGND VGND VPWR VPWR load_slew843/X sky130_fd_sc_hd__clkbuf_4
XFILLER_9_1058 VGND VGND VPWR VPWR sky130_fd_sc_hd__decap_3
XTAP_TAPCELL_ROW_32_1029 VGND VPWR sky130_fd_sc_hd__tapvpwrvgnd_1
X_5072_ _6432_/Q _5072_/B VGND VGND VPWR VPWR _5270_/B sky130_fd_sc_hd__xnor2_2
XFILLER_38_822 VGND VGND VPWR VPWR sky130_fd_sc_hd__decap_3
XFILLER_42_1142 VGND VGND VPWR VPWR sky130_fd_sc_hd__decap_3
X_4023_ _4071_/B _4588_/B VGND VGND VPWR VPWR _4023_/Y sky130_fd_sc_hd__nor2_2
XFILLER_49_181 VGND VGND VPWR VPWR sky130_fd_sc_hd__decap_3
Xclkbuf_leaf_76_clk clkload4/A VGND VGND VPWR VPWR _6990_/CLK sky130_fd_sc_hd__clkbuf_8
XFILLER_77_1216 VGND VGND VPWR VPWR sky130_fd_sc_hd__decap_3
XFILLER_25_505 VGND VGND VPWR VPWR sky130_fd_sc_hd__decap_3
XFILLER_20_1462 VGND VGND VPWR VPWR sky130_fd_sc_hd__decap_3
XFILLER_53_847 VGND VGND VPWR VPWR sky130_fd_sc_hd__decap_3
XFILLER_53_858 VGND VGND VPWR VPWR sky130_fd_sc_hd__decap_3
XFILLER_64_195 VGND VGND VPWR VPWR sky130_fd_sc_hd__fill_1
X_5974_ hold985/X _6978_/Q _6046_/S VGND VGND VPWR VPWR _5974_/X sky130_fd_sc_hd__mux2_1
XFILLER_53_869 VGND VGND VPWR VPWR sky130_fd_sc_hd__decap_3
XFILLER_52_368 VGND VGND VPWR VPWR sky130_fd_sc_hd__decap_3
X_4925_ _6379_/Q _5207_/B VGND VGND VPWR VPWR _4925_/X sky130_fd_sc_hd__or2_2
XFILLER_61_880 VGND VGND VPWR VPWR sky130_fd_sc_hd__fill_1
XFILLER_33_593 VGND VGND VPWR VPWR sky130_fd_sc_hd__fill_1
XFILLER_21_744 VGND VGND VPWR VPWR sky130_fd_sc_hd__decap_3
X_4856_ _6337_/Q wire63/X _4853_/X _4855_/X VGND VGND VPWR VPWR _6337_/D sky130_fd_sc_hd__o22a_2
XFILLER_21_766 VGND VGND VPWR VPWR sky130_fd_sc_hd__decap_3
XFILLER_14_1211 VGND VGND VPWR VPWR sky130_fd_sc_hd__decap_3
XFILLER_53_1260 VGND VGND VPWR VPWR sky130_fd_sc_hd__decap_3
XFILLER_18_1391 VGND VGND VPWR VPWR sky130_fd_sc_hd__decap_3
XFILLER_21_788 VGND VGND VPWR VPWR sky130_fd_sc_hd__fill_2
X_3807_ _6330_/Q _3807_/A2 _3805_/X _3806_/X VGND VGND VPWR VPWR _4292_/B sky130_fd_sc_hd__o22a_2
XFILLER_14_1244 VGND VGND VPWR VPWR sky130_fd_sc_hd__decap_3
X_4787_ _4786_/B _4610_/B _4786_/Y _4787_/C1 VGND VGND VPWR VPWR _4788_/C sky130_fd_sc_hd__o211ai_2
X_6526_ _6897_/CLK _6526_/D fanout703/X VGND VGND VPWR VPWR _6526_/Q sky130_fd_sc_hd__dfrtp_2
X_3738_ _4200_/A _4347_/A VGND VGND VPWR VPWR _4112_/A sky130_fd_sc_hd__xnor2_2
XFILLER_14_1288 VGND VGND VPWR VPWR sky130_fd_sc_hd__decap_3
XFILLER_4_409 VGND VGND VPWR VPWR sky130_fd_sc_hd__decap_3
XFILLER_49_1307 VGND VGND VPWR VPWR sky130_fd_sc_hd__decap_3
X_6457_ _7012_/CLK _6457_/D fanout809/X VGND VGND VPWR VPWR _6457_/Q sky130_fd_sc_hd__dfrtp_2
X_3669_ _3669_/A _3669_/B VGND VGND VPWR VPWR wire26/A sky130_fd_sc_hd__xnor2_2
XFILLER_69_39 VGND VGND VPWR VPWR sky130_fd_sc_hd__decap_3
X_5408_ _5408_/A1 _5464_/A2 _4491_/X VGND VGND VPWR VPWR _6520_/D sky130_fd_sc_hd__a21o_2
X_6388_ _6918_/CLK _6388_/D load_slew744/X VGND VGND VPWR VPWR _6388_/Q sky130_fd_sc_hd__dfrtp_2
XFILLER_0_604 VGND VGND VPWR VPWR sky130_fd_sc_hd__decap_3
X_5339_ _6462_/Q _5338_/X _5341_/S VGND VGND VPWR VPWR _6462_/D sky130_fd_sc_hd__mux2_1
XFILLER_0_637 VGND VGND VPWR VPWR sky130_fd_sc_hd__decap_3
XFILLER_0_648 VGND VGND VPWR VPWR sky130_fd_sc_hd__decap_3
XFILLER_76_906 VGND VGND VPWR VPWR sky130_fd_sc_hd__decap_3
XFILLER_76_928 VGND VGND VPWR VPWR sky130_fd_sc_hd__fill_1
XFILLER_75_405 VGND VGND VPWR VPWR sky130_fd_sc_hd__decap_3
XFILLER_5_1401 VGND VGND VPWR VPWR sky130_fd_sc_hd__decap_3
XFILLER_29_800 VGND VGND VPWR VPWR sky130_fd_sc_hd__decap_3
XFILLER_25_1340 VGND VGND VPWR VPWR sky130_fd_sc_hd__decap_3
XFILLER_25_1351 VGND VGND VPWR VPWR sky130_fd_sc_hd__decap_3
XFILLER_5_1434 VGND VGND VPWR VPWR sky130_fd_sc_hd__decap_3
X_7009_ _7009_/CLK _7009_/D fanout765/X VGND VGND VPWR VPWR _7009_/Q sky130_fd_sc_hd__dfrtp_2
XFILLER_60_1253 VGND VGND VPWR VPWR sky130_fd_sc_hd__decap_3
XFILLER_75_449 VGND VGND VPWR VPWR sky130_fd_sc_hd__decap_3
XFILLER_25_1384 VGND VGND VPWR VPWR sky130_fd_sc_hd__decap_3
XFILLER_29_844 VGND VGND VPWR VPWR sky130_fd_sc_hd__decap_3
XFILLER_60_1264 VGND VGND VPWR VPWR sky130_fd_sc_hd__decap_3
Xclkbuf_leaf_67_clk clkbuf_leaf_67_clk/A VGND VGND VPWR VPWR _6991_/CLK sky130_fd_sc_hd__clkbuf_8
XFILLER_21_1226 VGND VGND VPWR VPWR sky130_fd_sc_hd__decap_3
XFILLER_28_321 VGND VGND VPWR VPWR sky130_fd_sc_hd__fill_2
XFILLER_21_1248 VGND VGND VPWR VPWR sky130_fd_sc_hd__decap_3
XFILLER_60_1297 VGND VGND VPWR VPWR sky130_fd_sc_hd__decap_3
XFILLER_28_365 VGND VGND VPWR VPWR sky130_fd_sc_hd__decap_3
XFILLER_16_527 VGND VGND VPWR VPWR sky130_fd_sc_hd__decap_3
XFILLER_44_836 VGND VGND VPWR VPWR sky130_fd_sc_hd__fill_2
XFILLER_3_1180 VGND VGND VPWR VPWR sky130_fd_sc_hd__decap_3
XFILLER_43_335 VGND VGND VPWR VPWR sky130_fd_sc_hd__fill_1
XFILLER_43_346 VGND VGND VPWR VPWR sky130_fd_sc_hd__decap_3
XFILLER_71_688 VGND VGND VPWR VPWR sky130_fd_sc_hd__fill_2
XFILLER_54_1002 VGND VGND VPWR VPWR sky130_fd_sc_hd__fill_1
XFILLER_19_1133 VGND VGND VPWR VPWR sky130_fd_sc_hd__fill_1
XFILLER_34_42 VGND VGND VPWR VPWR sky130_fd_sc_hd__fill_2
XFILLER_58_1193 VGND VGND VPWR VPWR sky130_fd_sc_hd__fill_2
XFILLER_54_1035 VGND VGND VPWR VPWR sky130_fd_sc_hd__fill_1
XFILLER_51_390 VGND VGND VPWR VPWR sky130_fd_sc_hd__fill_2
XFILLER_12_766 VGND VGND VPWR VPWR sky130_fd_sc_hd__decap_3
XFILLER_32_1300 VGND VGND VPWR VPWR sky130_fd_sc_hd__decap_3
XFILLER_71_1360 VGND VGND VPWR VPWR sky130_fd_sc_hd__decap_3
Xwire112 wire112/A VGND VGND VPWR VPWR wire112/X sky130_fd_sc_hd__clkbuf_4
XTAP_TAPCELL_ROW_22_761 VGND VPWR sky130_fd_sc_hd__tapvpwrvgnd_1
XFILLER_7_225 VGND VGND VPWR VPWR sky130_fd_sc_hd__fill_1
XTAP_TAPCELL_ROW_22_772 VGND VPWR sky130_fd_sc_hd__tapvpwrvgnd_1
XFILLER_71_1393 VGND VGND VPWR VPWR sky130_fd_sc_hd__decap_3
XTAP_TAPCELL_ROW_22_783 VGND VPWR sky130_fd_sc_hd__tapvpwrvgnd_1
XFILLER_32_1344 VGND VGND VPWR VPWR sky130_fd_sc_hd__decap_3
XFILLER_50_52 VGND VGND VPWR VPWR sky130_fd_sc_hd__fill_1
XFILLER_32_1388 VGND VGND VPWR VPWR sky130_fd_sc_hd__decap_3
XFILLER_50_74 VGND VGND VPWR VPWR sky130_fd_sc_hd__fill_2
XFILLER_50_85 VGND VGND VPWR VPWR sky130_fd_sc_hd__decap_3
XFILLER_4_921 VGND VGND VPWR VPWR sky130_fd_sc_hd__decap_3
XFILLER_67_1407 VGND VGND VPWR VPWR sky130_fd_sc_hd__decap_3
XTAP_TAPCELL_ROW_76_2180 VGND VPWR sky130_fd_sc_hd__tapvpwrvgnd_1
XFILLER_3_420 VGND VGND VPWR VPWR sky130_fd_sc_hd__fill_1
XFILLER_4_965 VGND VGND VPWR VPWR sky130_fd_sc_hd__decap_3
XTAP_TAPCELL_ROW_72_2066 VGND VPWR sky130_fd_sc_hd__tapvpwrvgnd_1
XFILLER_79_722 VGND VGND VPWR VPWR sky130_fd_sc_hd__decap_3
XTAP_TAPCELL_ROW_72_2077 VGND VPWR sky130_fd_sc_hd__tapvpwrvgnd_1
XFILLER_3_486 VGND VGND VPWR VPWR sky130_fd_sc_hd__decap_3
XFILLER_79_744 VGND VGND VPWR VPWR sky130_fd_sc_hd__decap_3
XFILLER_26_1137 VGND VGND VPWR VPWR sky130_fd_sc_hd__decap_3
XFILLER_67_906 VGND VGND VPWR VPWR sky130_fd_sc_hd__decap_3
XFILLER_43_1440 VGND VGND VPWR VPWR sky130_fd_sc_hd__decap_3
XFILLER_8_1080 VGND VGND VPWR VPWR sky130_fd_sc_hd__fill_1
XFILLER_66_438 VGND VGND VPWR VPWR sky130_fd_sc_hd__decap_3
XFILLER_19_310 VGND VGND VPWR VPWR sky130_fd_sc_hd__fill_1
XFILLER_19_321 VGND VGND VPWR VPWR sky130_fd_sc_hd__decap_3
Xclkbuf_leaf_58_clk clkload4/A VGND VGND VPWR VPWR _6959_/CLK sky130_fd_sc_hd__clkbuf_8
XFILLER_75_60 VGND VGND VPWR VPWR sky130_fd_sc_hd__decap_3
XFILLER_35_803 VGND VGND VPWR VPWR sky130_fd_sc_hd__decap_3
XFILLER_19_376 VGND VGND VPWR VPWR sky130_fd_sc_hd__decap_3
XFILLER_46_162 VGND VGND VPWR VPWR sky130_fd_sc_hd__decap_3
XFILLER_47_685 VGND VGND VPWR VPWR sky130_fd_sc_hd__decap_3
XFILLER_74_482 VGND VGND VPWR VPWR sky130_fd_sc_hd__decap_3
XFILLER_34_335 VGND VGND VPWR VPWR sky130_fd_sc_hd__decap_3
XFILLER_34_368 VGND VGND VPWR VPWR sky130_fd_sc_hd__decap_3
XFILLER_76_1282 VGND VGND VPWR VPWR sky130_fd_sc_hd__decap_3
XFILLER_37_1233 VGND VGND VPWR VPWR sky130_fd_sc_hd__decap_3
XFILLER_72_1135 VGND VGND VPWR VPWR sky130_fd_sc_hd__decap_3
XFILLER_15_582 VGND VGND VPWR VPWR sky130_fd_sc_hd__decap_3
X_4710_ _4710_/A _4710_/B VGND VGND VPWR VPWR _4710_/Y sky130_fd_sc_hd__nor2_2
XFILLER_61_198 VGND VGND VPWR VPWR sky130_fd_sc_hd__decap_3
XFILLER_37_1266 VGND VGND VPWR VPWR sky130_fd_sc_hd__decap_3
XFILLER_42_390 VGND VGND VPWR VPWR sky130_fd_sc_hd__decap_3
X_5690_ _5690_/A0 _5902_/A0 _5693_/S VGND VGND VPWR VPWR _6742_/D sky130_fd_sc_hd__mux2_1
XFILLER_72_1179 VGND VGND VPWR VPWR sky130_fd_sc_hd__decap_3
XTAP_TAPCELL_ROW_20_709 VGND VPWR sky130_fd_sc_hd__tapvpwrvgnd_1
XFILLER_50_1400 VGND VGND VPWR VPWR sky130_fd_sc_hd__decap_3
X_4641_ _6260_/Q wire507/X _3378_/X _4875_/B2 VGND VGND VPWR VPWR _4641_/X sky130_fd_sc_hd__a22o_2
XTAP_TAPCELL_ROW_61_1781 VGND VPWR sky130_fd_sc_hd__tapvpwrvgnd_1
XTAP_TAPCELL_ROW_61_1792 VGND VPWR sky130_fd_sc_hd__tapvpwrvgnd_1
XFILLER_50_1444 VGND VGND VPWR VPWR sky130_fd_sc_hd__decap_3
X_4572_ _6539_/Q _4572_/B VGND VGND VPWR VPWR _4572_/Y sky130_fd_sc_hd__nand2_2
XFILLER_11_1428 VGND VGND VPWR VPWR sky130_fd_sc_hd__decap_3
X_6311_ _6889_/CLK _6311_/D load_slew748/X VGND VGND VPWR VPWR _6311_/Q sky130_fd_sc_hd__dfrtp_2
X_3523_ _6624_/Q _5591_/A2 _3522_/X VGND VGND VPWR VPWR _3523_/X sky130_fd_sc_hd__a21o_2
X_6242_ _7060_/CLK _6242_/D fanout781/X VGND VGND VPWR VPWR _6242_/Q sky130_fd_sc_hd__dfrtp_2
X_3454_ _6338_/Q _6458_/Q VGND VGND VPWR VPWR _3454_/X sky130_fd_sc_hd__xor2_2
XFILLER_48_1362 VGND VGND VPWR VPWR sky130_fd_sc_hd__decap_3
XFILLER_48_1373 VGND VGND VPWR VPWR sky130_fd_sc_hd__decap_3
X_6173_ _7024_/CLK _6173_/D fanout699/X VGND VGND VPWR VPWR _6173_/Q sky130_fd_sc_hd__dfrtp_2
X_3385_ hold887/X _3384_/X _3385_/S VGND VGND VPWR VPWR _6166_/D sky130_fd_sc_hd__mux2_1
XFILLER_44_1237 VGND VGND VPWR VPWR sky130_fd_sc_hd__decap_3
X_5124_ _6374_/Q _5123_/X _5123_/A _6712_/Q VGND VGND VPWR VPWR _5124_/X sky130_fd_sc_hd__a2bb2o_2
Xhold1404 _6919_/Q VGND VGND VPWR VPWR _5912_/A1 sky130_fd_sc_hd__dlygate4sd3_1
Xload_slew662 fanout661/X VGND VGND VPWR VPWR load_slew662/X sky130_fd_sc_hd__clkbuf_4
XFILLER_57_405 VGND VGND VPWR VPWR sky130_fd_sc_hd__decap_3
Xhold1415 _6851_/Q VGND VGND VPWR VPWR _5834_/A1 sky130_fd_sc_hd__dlygate4sd3_1
Xload_slew684 fanout683/X VGND VGND VPWR VPWR load_slew684/X sky130_fd_sc_hd__clkbuf_4
Xhold1426 _6533_/Q VGND VGND VPWR VPWR _5421_/A1 sky130_fd_sc_hd__dlygate4sd3_1
X_5055_ _6365_/Q _5054_/X _5055_/S VGND VGND VPWR VPWR _6365_/D sky130_fd_sc_hd__mux2_1
Xhold1437 _6523_/Q VGND VGND VPWR VPWR _5411_/A1 sky130_fd_sc_hd__dlygate4sd3_1
XFILLER_69_298 VGND VGND VPWR VPWR sky130_fd_sc_hd__decap_3
Xhold1448 _6562_/Q VGND VGND VPWR VPWR _5450_/A1 sky130_fd_sc_hd__dlygate4sd3_1
XFILLER_73_909 VGND VGND VPWR VPWR sky130_fd_sc_hd__decap_3
Xhold1459 _6493_/Q VGND VGND VPWR VPWR _5381_/A1 sky130_fd_sc_hd__dlygate4sd3_1
Xclkbuf_leaf_49_clk clkbuf_leaf_54_clk/A VGND VGND VPWR VPWR _7036_/CLK sky130_fd_sc_hd__clkbuf_8
XFILLER_66_950 VGND VGND VPWR VPWR sky130_fd_sc_hd__decap_3
X_4006_ _3352_/X _4056_/A2 _4263_/A2 _6873_/Q _4104_/C1 VGND VGND VPWR VPWR _4006_/X
+ sky130_fd_sc_hd__a221o_2
XFILLER_37_151 VGND VGND VPWR VPWR sky130_fd_sc_hd__decap_3
XFILLER_38_674 VGND VGND VPWR VPWR sky130_fd_sc_hd__fill_2
XFILLER_1_90 VGND VGND VPWR VPWR sky130_fd_sc_hd__decap_3
XFILLER_26_847 VGND VGND VPWR VPWR sky130_fd_sc_hd__decap_3
XTAP_TAPCELL_ROW_68_1957 VGND VPWR sky130_fd_sc_hd__tapvpwrvgnd_1
XFILLER_0_1320 VGND VGND VPWR VPWR sky130_fd_sc_hd__decap_3
XTAP_TAPCELL_ROW_68_1968 VGND VPWR sky130_fd_sc_hd__tapvpwrvgnd_1
XFILLER_52_121 VGND VGND VPWR VPWR sky130_fd_sc_hd__decap_3
XTAP_TAPCELL_ROW_68_1979 VGND VPWR sky130_fd_sc_hd__tapvpwrvgnd_1
XFILLER_20_1270 VGND VGND VPWR VPWR sky130_fd_sc_hd__decap_3
XFILLER_77_1068 VGND VGND VPWR VPWR sky130_fd_sc_hd__decap_3
XFILLER_80_463 VGND VGND VPWR VPWR sky130_fd_sc_hd__decap_3
XFILLER_13_508 VGND VGND VPWR VPWR sky130_fd_sc_hd__decap_3
XFILLER_25_379 VGND VGND VPWR VPWR sky130_fd_sc_hd__decap_3
XFILLER_71_18 VGND VGND VPWR VPWR sky130_fd_sc_hd__decap_3
X_5957_ _6110_/Q _5957_/A1 _6021_/S VGND VGND VPWR VPWR _5957_/X sky130_fd_sc_hd__mux2_1
XFILLER_53_699 VGND VGND VPWR VPWR sky130_fd_sc_hd__decap_3
XFILLER_55_1322 VGND VGND VPWR VPWR sky130_fd_sc_hd__decap_3
XFILLER_0_1397 VGND VGND VPWR VPWR sky130_fd_sc_hd__decap_3
XFILLER_40_327 VGND VGND VPWR VPWR sky130_fd_sc_hd__fill_2
XFILLER_52_187 VGND VGND VPWR VPWR sky130_fd_sc_hd__decap_3
XFILLER_16_1306 VGND VGND VPWR VPWR sky130_fd_sc_hd__decap_3
X_4908_ _6344_/Q _4907_/X _4908_/S VGND VGND VPWR VPWR _6344_/D sky130_fd_sc_hd__mux2_1
XFILLER_16_1317 VGND VGND VPWR VPWR sky130_fd_sc_hd__decap_3
XFILLER_55_1366 VGND VGND VPWR VPWR sky130_fd_sc_hd__decap_3
X_5888_ _5924_/C _5924_/B _5924_/A VGND VGND VPWR VPWR _5896_/S sky130_fd_sc_hd__or3b_2
XFILLER_51_1208 VGND VGND VPWR VPWR sky130_fd_sc_hd__fill_1
XFILLER_55_1399 VGND VGND VPWR VPWR sky130_fd_sc_hd__fill_1
X_4839_ _6287_/Q wire503/X _3448_/X wire383/X VGND VGND VPWR VPWR _4839_/X sky130_fd_sc_hd__a22o_2
XFILLER_14_1052 VGND VGND VPWR VPWR sky130_fd_sc_hd__decap_3
XFILLER_4_206 VGND VGND VPWR VPWR sky130_fd_sc_hd__decap_3
X_6509_ _6847_/CLK _6509_/D load_slew780/X VGND VGND VPWR VPWR _6509_/Q sky130_fd_sc_hd__dfrtp_2
XFILLER_20_55 VGND VGND VPWR VPWR sky130_fd_sc_hd__decap_3
XFILLER_1_924 VGND VGND VPWR VPWR sky130_fd_sc_hd__decap_3
XFILLER_27_1413 VGND VGND VPWR VPWR sky130_fd_sc_hd__decap_3
XFILLER_66_1462 VGND VGND VPWR VPWR sky130_fd_sc_hd__decap_3
XFILLER_62_1315 VGND VGND VPWR VPWR sky130_fd_sc_hd__fill_1
XFILLER_0_445 VGND VGND VPWR VPWR sky130_fd_sc_hd__decap_3
XFILLER_1_968 VGND VGND VPWR VPWR sky130_fd_sc_hd__decap_3
XFILLER_27_1446 VGND VGND VPWR VPWR sky130_fd_sc_hd__decap_3
XFILLER_62_1326 VGND VGND VPWR VPWR sky130_fd_sc_hd__decap_3
XFILLER_27_1457 VGND VGND VPWR VPWR sky130_fd_sc_hd__decap_3
XFILLER_0_467 VGND VGND VPWR VPWR sky130_fd_sc_hd__decap_3
XFILLER_48_405 VGND VGND VPWR VPWR sky130_fd_sc_hd__decap_3
XFILLER_62_1359 VGND VGND VPWR VPWR sky130_fd_sc_hd__decap_3
XFILLER_0_489 VGND VGND VPWR VPWR sky130_fd_sc_hd__decap_3
XFILLER_48_427 VGND VGND VPWR VPWR sky130_fd_sc_hd__decap_3
XFILLER_5_1231 VGND VGND VPWR VPWR sky130_fd_sc_hd__fill_1
XFILLER_5_1242 VGND VGND VPWR VPWR sky130_fd_sc_hd__decap_3
XFILLER_29_652 VGND VGND VPWR VPWR sky130_fd_sc_hd__decap_3
XFILLER_17_803 VGND VGND VPWR VPWR sky130_fd_sc_hd__fill_2
XFILLER_5_1275 VGND VGND VPWR VPWR sky130_fd_sc_hd__decap_3
XTAP_TAPCELL_ROW_3_272 VGND VPWR sky130_fd_sc_hd__tapvpwrvgnd_1
XFILLER_44_600 VGND VGND VPWR VPWR sky130_fd_sc_hd__fill_1
XTAP_TAPCELL_ROW_3_283 VGND VPWR sky130_fd_sc_hd__tapvpwrvgnd_1
XFILLER_72_931 VGND VGND VPWR VPWR sky130_fd_sc_hd__fill_2
XFILLER_1_1139 VGND VGND VPWR VPWR sky130_fd_sc_hd__decap_3
XFILLER_16_324 VGND VGND VPWR VPWR sky130_fd_sc_hd__decap_3
XFILLER_43_110 VGND VGND VPWR VPWR sky130_fd_sc_hd__fill_2
XTAP_TAPCELL_ROW_80_2302 VGND VPWR sky130_fd_sc_hd__tapvpwrvgnd_1
XFILLER_28_195 VGND VGND VPWR VPWR sky130_fd_sc_hd__fill_1
XFILLER_45_52 VGND VGND VPWR VPWR sky130_fd_sc_hd__decap_3
XTAP_TAPCELL_ROW_80_2313 VGND VPWR sky130_fd_sc_hd__tapvpwrvgnd_1
XFILLER_71_452 VGND VGND VPWR VPWR sky130_fd_sc_hd__decap_3
XFILLER_16_357 VGND VGND VPWR VPWR sky130_fd_sc_hd__decap_3
Xclkbuf_3_0_0_clk clkbuf_0_clk/X VGND VGND VPWR VPWR clkbuf_3_0_0_clk/X sky130_fd_sc_hd__clkbuf_8
XFILLER_73_1422 VGND VGND VPWR VPWR sky130_fd_sc_hd__decap_3
XTAP_TAPCELL_ROW_27_897 VGND VPWR sky130_fd_sc_hd__tapvpwrvgnd_1
XFILLER_31_316 VGND VGND VPWR VPWR sky130_fd_sc_hd__decap_3
XFILLER_73_1455 VGND VGND VPWR VPWR sky130_fd_sc_hd__fill_1
XFILLER_34_1406 VGND VGND VPWR VPWR sky130_fd_sc_hd__decap_3
XFILLER_73_1466 VGND VGND VPWR VPWR sky130_fd_sc_hd__decap_3
XTAP_TAPCELL_ROW_14_558 VGND VPWR sky130_fd_sc_hd__tapvpwrvgnd_1
XFILLER_12_552 VGND VGND VPWR VPWR sky130_fd_sc_hd__decap_3
XTAP_TAPCELL_ROW_14_569 VGND VPWR sky130_fd_sc_hd__tapvpwrvgnd_1
XFILLER_40_872 VGND VGND VPWR VPWR sky130_fd_sc_hd__fill_2
XFILLER_12_574 VGND VGND VPWR VPWR sky130_fd_sc_hd__fill_1
XTAP_TAPCELL_ROW_78_2220 VGND VPWR sky130_fd_sc_hd__tapvpwrvgnd_1
XTAP_TAPCELL_ROW_78_2231 VGND VPWR sky130_fd_sc_hd__tapvpwrvgnd_1
XFILLER_77_9 VGND VGND VPWR VPWR sky130_fd_sc_hd__decap_3
XFILLER_8_545 VGND VGND VPWR VPWR sky130_fd_sc_hd__decap_3
XFILLER_8_578 VGND VGND VPWR VPWR sky130_fd_sc_hd__decap_3
XFILLER_8_589 VGND VGND VPWR VPWR sky130_fd_sc_hd__decap_3
XFILLER_6_24 VGND VGND VPWR VPWR sky130_fd_sc_hd__decap_3
XTAP_TAPCELL_ROW_74_2117 VGND VPWR sky130_fd_sc_hd__tapvpwrvgnd_1
XFILLER_6_35 VGND VGND VPWR VPWR sky130_fd_sc_hd__decap_3
XTAP_TAPCELL_ROW_74_2128 VGND VPWR sky130_fd_sc_hd__tapvpwrvgnd_1
XANTENNA_6 _3202_/A VGND VGND VPWR VPWR sky130_fd_sc_hd__diode_2
XFILLER_32_1196 VGND VGND VPWR VPWR sky130_fd_sc_hd__fill_1
XFILLER_67_1204 VGND VGND VPWR VPWR sky130_fd_sc_hd__decap_3
XFILLER_10_1450 VGND VGND VPWR VPWR sky130_fd_sc_hd__decap_3
XFILLER_67_1248 VGND VGND VPWR VPWR sky130_fd_sc_hd__decap_3
XFILLER_4_784 VGND VGND VPWR VPWR sky130_fd_sc_hd__decap_3
XFILLER_80_1404 VGND VGND VPWR VPWR sky130_fd_sc_hd__decap_3
XFILLER_79_541 VGND VGND VPWR VPWR sky130_fd_sc_hd__fill_1
X_3170_ _3212_/A1 _7030_/Q _7038_/Q _3219_/B2 VGND VGND VPWR VPWR _3170_/X sky130_fd_sc_hd__a22o_2
XFILLER_67_725 VGND VGND VPWR VPWR sky130_fd_sc_hd__decap_3
XFILLER_0_990 VGND VGND VPWR VPWR sky130_fd_sc_hd__decap_3
XFILLER_39_449 VGND VGND VPWR VPWR sky130_fd_sc_hd__decap_3
XFILLER_66_235 VGND VGND VPWR VPWR sky130_fd_sc_hd__decap_3
XFILLER_48_950 VGND VGND VPWR VPWR sky130_fd_sc_hd__decap_3
XFILLER_43_1281 VGND VGND VPWR VPWR sky130_fd_sc_hd__decap_3
XFILLER_78_1300 VGND VGND VPWR VPWR sky130_fd_sc_hd__decap_3
XFILLER_43_1292 VGND VGND VPWR VPWR sky130_fd_sc_hd__decap_3
XFILLER_54_419 VGND VGND VPWR VPWR sky130_fd_sc_hd__fill_1
XTAP_TAPCELL_ROW_50_1493 VGND VPWR sky130_fd_sc_hd__tapvpwrvgnd_1
XFILLER_35_611 VGND VGND VPWR VPWR sky130_fd_sc_hd__decap_3
XFILLER_63_920 VGND VGND VPWR VPWR sky130_fd_sc_hd__decap_3
XFILLER_75_791 VGND VGND VPWR VPWR sky130_fd_sc_hd__fill_1
XFILLER_78_1344 VGND VGND VPWR VPWR sky130_fd_sc_hd__decap_3
XFILLER_47_493 VGND VGND VPWR VPWR sky130_fd_sc_hd__decap_3
X_6860_ _7015_/CLK _6860_/D fanout797/X VGND VGND VPWR VPWR _6860_/Q sky130_fd_sc_hd__dfrtp_2
XFILLER_62_441 VGND VGND VPWR VPWR sky130_fd_sc_hd__decap_3
XFILLER_74_1208 VGND VGND VPWR VPWR sky130_fd_sc_hd__decap_3
XFILLER_39_1328 VGND VGND VPWR VPWR sky130_fd_sc_hd__decap_3
XFILLER_78_1388 VGND VGND VPWR VPWR sky130_fd_sc_hd__decap_3
X_5811_ _5797_/C _5811_/A1 _5813_/S VGND VGND VPWR VPWR _6831_/D sky130_fd_sc_hd__mux2_1
XFILLER_50_603 VGND VGND VPWR VPWR sky130_fd_sc_hd__decap_3
XFILLER_35_688 VGND VGND VPWR VPWR sky130_fd_sc_hd__decap_3
XFILLER_62_474 VGND VGND VPWR VPWR sky130_fd_sc_hd__fill_2
X_6791_ _6991_/CLK _6791_/D fanout806/X VGND VGND VPWR VPWR _6791_/Q sky130_fd_sc_hd__dfrtp_2
XFILLER_34_187 VGND VGND VPWR VPWR sky130_fd_sc_hd__decap_3
XTAP_TAPCELL_ROW_63_1832 VGND VPWR sky130_fd_sc_hd__tapvpwrvgnd_1
XTAP_TAPCELL_ROW_63_1843 VGND VPWR sky130_fd_sc_hd__tapvpwrvgnd_1
X_5742_ _5908_/A0 _5742_/A1 _5748_/S VGND VGND VPWR VPWR _6787_/D sky130_fd_sc_hd__mux2_1
X_5673_ hold891/X _5912_/A0 _5675_/S VGND VGND VPWR VPWR _6727_/D sky130_fd_sc_hd__mux2_1
XFILLER_30_382 VGND VGND VPWR VPWR sky130_fd_sc_hd__fill_1
XPHY_EDGE_ROW_6_Right_6 VGND VGND VPWR VPWR sky130_fd_sc_hd__decap_3
X_4624_ _4624_/A _4624_/B VGND VGND VPWR VPWR _4624_/Y sky130_fd_sc_hd__nor2_2
XFILLER_15_1372 VGND VGND VPWR VPWR sky130_fd_sc_hd__decap_3
XFILLER_50_1252 VGND VGND VPWR VPWR sky130_fd_sc_hd__decap_3
XFILLER_11_1225 VGND VGND VPWR VPWR sky130_fd_sc_hd__decap_3
XFILLER_11_1236 VGND VGND VPWR VPWR sky130_fd_sc_hd__decap_3
XFILLER_50_1285 VGND VGND VPWR VPWR sky130_fd_sc_hd__decap_3
X_4555_ _4368_/X _4586_/D _4547_/X _6537_/Q _4763_/C1 VGND VGND VPWR VPWR _4558_/B
+ sky130_fd_sc_hd__a221o_2
XFILLER_11_1269 VGND VGND VPWR VPWR sky130_fd_sc_hd__decap_3
X_3506_ _4420_/C _3502_/X _5514_/A VGND VGND VPWR VPWR _3506_/X sky130_fd_sc_hd__o21a_2
X_4486_ _6287_/Q _4485_/X _4899_/S VGND VGND VPWR VPWR _6287_/D sky130_fd_sc_hd__mux2_1
X_6225_ _6900_/CLK _6225_/D fanout828/X VGND VGND VPWR VPWR _6225_/Q sky130_fd_sc_hd__dfrtp_2
X_3437_ _6039_/A0 _3436_/X _3453_/S VGND VGND VPWR VPWR _6192_/D sky130_fd_sc_hd__mux2_1
XFILLER_44_1023 VGND VGND VPWR VPWR sky130_fd_sc_hd__decap_3
X_3368_ _6303_/Q _6415_/Q VGND VGND VPWR VPWR _3368_/X sky130_fd_sc_hd__xor2_2
X_6156_ _7007_/CLK _6156_/D fanout818/X VGND VGND VPWR VPWR _6156_/Q sky130_fd_sc_hd__dfrtp_2
XFILLER_66_18 VGND VGND VPWR VPWR sky130_fd_sc_hd__decap_3
Xhold1201 _6864_/Q VGND VGND VPWR VPWR _5848_/A0 sky130_fd_sc_hd__dlygate4sd3_1
XFILLER_66_29 VGND VGND VPWR VPWR sky130_fd_sc_hd__decap_3
Xhold1212 _6749_/Q VGND VGND VPWR VPWR _5698_/A0 sky130_fd_sc_hd__dlygate4sd3_1
X_5107_ _5107_/A _5107_/B VGND VGND VPWR VPWR _5107_/X sky130_fd_sc_hd__or2_2
Xhold1223 _6798_/Q VGND VGND VPWR VPWR _5754_/A1 sky130_fd_sc_hd__dlygate4sd3_1
Xload_slew492 _3044_/A VGND VGND VPWR VPWR _5567_/A sky130_fd_sc_hd__clkbuf_2
Xhold1234 _6785_/Q VGND VGND VPWR VPWR _5739_/A1 sky130_fd_sc_hd__dlygate4sd3_1
X_6087_ _6752_/CLK _6087_/D load_slew674/X VGND VGND VPWR VPWR _6087_/Q sky130_fd_sc_hd__dfrtp_2
X_3299_ hold864/X _3298_/X _3385_/S VGND VGND VPWR VPWR _6123_/D sky130_fd_sc_hd__mux2_1
Xhold1245 _6747_/Q VGND VGND VPWR VPWR _5696_/A0 sky130_fd_sc_hd__dlygate4sd3_1
Xhold1256 _6925_/Q VGND VGND VPWR VPWR _5919_/A0 sky130_fd_sc_hd__dlygate4sd3_1
XFILLER_22_1332 VGND VGND VPWR VPWR sky130_fd_sc_hd__decap_3
XFILLER_61_1381 VGND VGND VPWR VPWR sky130_fd_sc_hd__decap_3
XFILLER_2_1415 VGND VGND VPWR VPWR sky130_fd_sc_hd__decap_3
Xhold1267 _6780_/Q VGND VGND VPWR VPWR _5734_/A1 sky130_fd_sc_hd__dlygate4sd3_1
X_5038_ _6395_/Q _5255_/B wire434/X VGND VGND VPWR VPWR _5038_/Y sky130_fd_sc_hd__a21oi_2
Xhold1278 _6473_/Q VGND VGND VPWR VPWR _5361_/A1 sky130_fd_sc_hd__dlygate4sd3_1
Xhold1289 _6918_/Q VGND VGND VPWR VPWR _5911_/A1 sky130_fd_sc_hd__dlygate4sd3_1
XFILLER_22_1365 VGND VGND VPWR VPWR sky130_fd_sc_hd__decap_3
XFILLER_54_920 VGND VGND VPWR VPWR sky130_fd_sc_hd__decap_3
XFILLER_22_1376 VGND VGND VPWR VPWR sky130_fd_sc_hd__decap_3
XFILLER_38_471 VGND VGND VPWR VPWR sky130_fd_sc_hd__decap_3
XFILLER_2_1459 VGND VGND VPWR VPWR sky130_fd_sc_hd__decap_3
XFILLER_54_953 VGND VGND VPWR VPWR sky130_fd_sc_hd__decap_3
XFILLER_57_1428 VGND VGND VPWR VPWR sky130_fd_sc_hd__decap_3
XFILLER_0_1161 VGND VGND VPWR VPWR sky130_fd_sc_hd__decap_3
XFILLER_14_839 VGND VGND VPWR VPWR sky130_fd_sc_hd__decap_3
XTAP_TAPCELL_ROW_24_812 VGND VPWR sky130_fd_sc_hd__tapvpwrvgnd_1
X_6989_ clkload8/A _6989_/D load_slew637/X VGND VGND VPWR VPWR _6989_/Q sky130_fd_sc_hd__dfrtp_2
XFILLER_0_1183 VGND VGND VPWR VPWR sky130_fd_sc_hd__decap_3
XTAP_TAPCELL_ROW_24_823 VGND VPWR sky130_fd_sc_hd__tapvpwrvgnd_1
XTAP_TAPCELL_ROW_24_834 VGND VPWR sky130_fd_sc_hd__tapvpwrvgnd_1
XFILLER_25_198 VGND VGND VPWR VPWR sky130_fd_sc_hd__decap_3
XFILLER_41_647 VGND VGND VPWR VPWR sky130_fd_sc_hd__decap_3
XFILLER_55_1141 VGND VGND VPWR VPWR sky130_fd_sc_hd__decap_3
XFILLER_55_1163 VGND VGND VPWR VPWR sky130_fd_sc_hd__fill_1
XFILLER_22_872 VGND VGND VPWR VPWR sky130_fd_sc_hd__decap_3
XFILLER_51_1038 VGND VGND VPWR VPWR sky130_fd_sc_hd__decap_3
XFILLER_5_526 VGND VGND VPWR VPWR sky130_fd_sc_hd__decap_3
XFILLER_1_721 VGND VGND VPWR VPWR sky130_fd_sc_hd__decap_3
XFILLER_1_732 VGND VGND VPWR VPWR sky130_fd_sc_hd__decap_3
XFILLER_66_1270 VGND VGND VPWR VPWR sky130_fd_sc_hd__decap_3
XFILLER_7_1304 VGND VGND VPWR VPWR sky130_fd_sc_hd__decap_3
XFILLER_0_231 VGND VGND VPWR VPWR sky130_fd_sc_hd__decap_3
XFILLER_1_765 VGND VGND VPWR VPWR sky130_fd_sc_hd__decap_3
XFILLER_0_253 VGND VGND VPWR VPWR sky130_fd_sc_hd__decap_3
XFILLER_27_1254 VGND VGND VPWR VPWR sky130_fd_sc_hd__decap_3
XTAP_TAPCELL_ROW_8_397 VGND VPWR sky130_fd_sc_hd__tapvpwrvgnd_1
XFILLER_76_511 VGND VGND VPWR VPWR sky130_fd_sc_hd__decap_3
XFILLER_7_1337 VGND VGND VPWR VPWR sky130_fd_sc_hd__decap_3
XFILLER_7_1348 VGND VGND VPWR VPWR sky130_fd_sc_hd__decap_3
XFILLER_76_533 VGND VGND VPWR VPWR sky130_fd_sc_hd__decap_3
XFILLER_27_1287 VGND VGND VPWR VPWR sky130_fd_sc_hd__fill_1
XFILLER_49_747 VGND VGND VPWR VPWR sky130_fd_sc_hd__decap_3
XFILLER_23_1129 VGND VGND VPWR VPWR sky130_fd_sc_hd__decap_3
XFILLER_27_1298 VGND VGND VPWR VPWR sky130_fd_sc_hd__decap_3
XFILLER_37_909 VGND VGND VPWR VPWR sky130_fd_sc_hd__decap_3
XFILLER_40_1421 VGND VGND VPWR VPWR sky130_fd_sc_hd__decap_3
XFILLER_40_1432 VGND VGND VPWR VPWR sky130_fd_sc_hd__decap_3
XFILLER_40_1465 VGND VGND VPWR VPWR sky130_fd_sc_hd__decap_3
XFILLER_45_920 VGND VGND VPWR VPWR sky130_fd_sc_hd__fill_1
XFILLER_5_1083 VGND VGND VPWR VPWR sky130_fd_sc_hd__decap_3
XFILLER_17_644 VGND VGND VPWR VPWR sky130_fd_sc_hd__decap_3
XFILLER_44_430 VGND VGND VPWR VPWR sky130_fd_sc_hd__decap_3
XFILLER_16_132 VGND VGND VPWR VPWR sky130_fd_sc_hd__decap_3
XFILLER_60_901 VGND VGND VPWR VPWR sky130_fd_sc_hd__decap_3
XFILLER_32_614 VGND VGND VPWR VPWR sky130_fd_sc_hd__decap_3
XFILLER_44_474 VGND VGND VPWR VPWR sky130_fd_sc_hd__fill_2
XFILLER_60_934 VGND VGND VPWR VPWR sky130_fd_sc_hd__fill_1
XFILLER_16_187 VGND VGND VPWR VPWR sky130_fd_sc_hd__decap_3
XFILLER_72_50 VGND VGND VPWR VPWR sky130_fd_sc_hd__decap_3
XFILLER_38_1350 VGND VGND VPWR VPWR sky130_fd_sc_hd__decap_3
XFILLER_73_1263 VGND VGND VPWR VPWR sky130_fd_sc_hd__decap_3
XFILLER_38_1394 VGND VGND VPWR VPWR sky130_fd_sc_hd__decap_3
XFILLER_34_1236 VGND VGND VPWR VPWR sky130_fd_sc_hd__decap_3
XFILLER_13_894 VGND VGND VPWR VPWR sky130_fd_sc_hd__fill_2
XFILLER_12_371 VGND VGND VPWR VPWR sky130_fd_sc_hd__fill_1
XPHY_EDGE_ROW_59_Right_59 VGND VGND VPWR VPWR sky130_fd_sc_hd__decap_3
XFILLER_40_691 VGND VGND VPWR VPWR sky130_fd_sc_hd__decap_3
XFILLER_75_6 VGND VGND VPWR VPWR sky130_fd_sc_hd__decap_3
X_4340_ _4885_/B1 _4335_/X _4339_/X VGND VGND VPWR VPWR _4340_/X sky130_fd_sc_hd__o21a_2
XFILLER_67_1045 VGND VGND VPWR VPWR sky130_fd_sc_hd__decap_3
XFILLER_4_581 VGND VGND VPWR VPWR sky130_fd_sc_hd__decap_3
XFILLER_10_1291 VGND VGND VPWR VPWR sky130_fd_sc_hd__decap_3
XFILLER_4_592 VGND VGND VPWR VPWR sky130_fd_sc_hd__decap_3
X_4271_ _4271_/A _4271_/B VGND VGND VPWR VPWR _4844_/B sky130_fd_sc_hd__xnor2_2
XFILLER_45_1310 VGND VGND VPWR VPWR sky130_fd_sc_hd__decap_3
XFILLER_80_1201 VGND VGND VPWR VPWR sky130_fd_sc_hd__decap_3
X_6010_ _6010_/A0 _6010_/A1 _6050_/S VGND VGND VPWR VPWR _7014_/D sky130_fd_sc_hd__mux2_1
X_3222_ _3222_/A _7075_/Q _6945_/Q VGND VGND VPWR VPWR _3222_/X sky130_fd_sc_hd__and3_2
XFILLER_80_1223 VGND VGND VPWR VPWR sky130_fd_sc_hd__decap_3
XFILLER_45_1343 VGND VGND VPWR VPWR sky130_fd_sc_hd__fill_1
XFILLER_45_1354 VGND VGND VPWR VPWR sky130_fd_sc_hd__decap_3
XTAP_TAPCELL_ROW_52_1544 VGND VPWR sky130_fd_sc_hd__tapvpwrvgnd_1
XFILLER_67_500 VGND VGND VPWR VPWR sky130_fd_sc_hd__decap_3
XFILLER_80_1245 VGND VGND VPWR VPWR sky130_fd_sc_hd__decap_3
XPHY_EDGE_ROW_68_Right_68 VGND VGND VPWR VPWR sky130_fd_sc_hd__decap_3
XFILLER_39_213 VGND VGND VPWR VPWR sky130_fd_sc_hd__fill_2
XTAP_TAPCELL_ROW_52_1555 VGND VPWR sky130_fd_sc_hd__tapvpwrvgnd_1
XFILLER_80_1267 VGND VGND VPWR VPWR sky130_fd_sc_hd__decap_3
X_3153_ _7060_/Q _3152_/X _3225_/S VGND VGND VPWR VPWR wire80/A sky130_fd_sc_hd__mux2_1
XFILLER_45_1387 VGND VGND VPWR VPWR sky130_fd_sc_hd__decap_3
XFILLER_80_1289 VGND VGND VPWR VPWR sky130_fd_sc_hd__decap_3
XFILLER_39_246 VGND VGND VPWR VPWR sky130_fd_sc_hd__decap_3
XFILLER_55_706 VGND VGND VPWR VPWR sky130_fd_sc_hd__fill_1
XFILLER_27_408 VGND VGND VPWR VPWR sky130_fd_sc_hd__decap_3
X_3084_ _4783_/B _3957_/B VGND VGND VPWR VPWR _3084_/Y sky130_fd_sc_hd__nor2_2
XFILLER_55_739 VGND VGND VPWR VPWR sky130_fd_sc_hd__decap_3
XFILLER_36_942 VGND VGND VPWR VPWR sky130_fd_sc_hd__decap_3
X_6912_ _6912_/CLK _6912_/D wire715/X VGND VGND VPWR VPWR _6912_/Q sky130_fd_sc_hd__dfrtp_2
XFILLER_78_1141 VGND VGND VPWR VPWR sky130_fd_sc_hd__decap_3
XFILLER_78_1152 VGND VGND VPWR VPWR sky130_fd_sc_hd__decap_3
XFILLER_35_452 VGND VGND VPWR VPWR sky130_fd_sc_hd__decap_3
XFILLER_78_1185 VGND VGND VPWR VPWR sky130_fd_sc_hd__decap_3
XTAP_TAPCELL_ROW_18_661 VGND VPWR sky130_fd_sc_hd__tapvpwrvgnd_1
X_6843_ _7036_/CLK _6843_/D fanout835/X VGND VGND VPWR VPWR _6843_/Q sky130_fd_sc_hd__dfrtp_2
XFILLER_63_783 VGND VGND VPWR VPWR sky130_fd_sc_hd__fill_1
XTAP_TAPCELL_ROW_18_672 VGND VPWR sky130_fd_sc_hd__tapvpwrvgnd_1
XFILLER_63_794 VGND VGND VPWR VPWR sky130_fd_sc_hd__decap_3
XFILLER_17_1401 VGND VGND VPWR VPWR sky130_fd_sc_hd__decap_3
XFILLER_56_1450 VGND VGND VPWR VPWR sky130_fd_sc_hd__decap_3
X_6774_ _7063_/CLK _6774_/D fanout776/X VGND VGND VPWR VPWR _6774_/Q sky130_fd_sc_hd__dfrtp_2
XPHY_EDGE_ROW_77_Right_77 VGND VGND VPWR VPWR sky130_fd_sc_hd__decap_3
XFILLER_22_157 VGND VGND VPWR VPWR sky130_fd_sc_hd__decap_3
XFILLER_50_466 VGND VGND VPWR VPWR sky130_fd_sc_hd__decap_3
XFILLER_51_989 VGND VGND VPWR VPWR sky130_fd_sc_hd__decap_3
XFILLER_52_1303 VGND VGND VPWR VPWR sky130_fd_sc_hd__decap_3
X_3986_ _6532_/Q _4396_/A _3486_/B VGND VGND VPWR VPWR _3986_/X sky130_fd_sc_hd__a21bo_2
XFILLER_17_1434 VGND VGND VPWR VPWR sky130_fd_sc_hd__decap_3
XFILLER_50_477 VGND VGND VPWR VPWR sky130_fd_sc_hd__decap_3
X_5725_ _5900_/A0 _5725_/A1 _5730_/S VGND VGND VPWR VPWR _6772_/D sky130_fd_sc_hd__mux2_1
XFILLER_50_499 VGND VGND VPWR VPWR sky130_fd_sc_hd__decap_3
XFILLER_52_1347 VGND VGND VPWR VPWR sky130_fd_sc_hd__decap_3
X_5656_ hold977/X _5904_/A0 _5657_/S VGND VGND VPWR VPWR _6712_/D sky130_fd_sc_hd__mux2_1
X_4607_ _6303_/Q _4775_/A2 _4604_/X _4606_/X VGND VGND VPWR VPWR _6303_/D sky130_fd_sc_hd__o22a_2
X_5587_ _5577_/A wire431/A _4562_/B _5584_/Y _5587_/B2 VGND VGND VPWR VPWR _6660_/D
+ sky130_fd_sc_hd__a32o_2
X_4538_ _6864_/Q _4833_/A2 _4833_/B1 _4537_/X VGND VGND VPWR VPWR _4538_/X sky130_fd_sc_hd__a211o_2
XFILLER_2_518 VGND VGND VPWR VPWR sky130_fd_sc_hd__decap_3
XFILLER_11_1099 VGND VGND VPWR VPWR sky130_fd_sc_hd__decap_3
XFILLER_7_9 VGND VGND VPWR VPWR sky130_fd_sc_hd__decap_3
X_4469_ _4859_/C1 _4466_/X _4467_/Y _4468_/X _4683_/A VGND VGND VPWR VPWR _4469_/X
+ sky130_fd_sc_hd__o221a_2
Xfanout800 fanout802/X VGND VGND VPWR VPWR fanout800/X sky130_fd_sc_hd__clkdlybuf4s25_1
XFILLER_63_1410 VGND VGND VPWR VPWR sky130_fd_sc_hd__decap_3
Xfanout811 fanout817/X VGND VGND VPWR VPWR fanout811/X sky130_fd_sc_hd__clkdlybuf4s25_1
XFILLER_77_39 VGND VGND VPWR VPWR sky130_fd_sc_hd__decap_3
X_6208_ _7060_/CLK _6208_/D fanout781/X VGND VGND VPWR VPWR _6208_/Q sky130_fd_sc_hd__dfrtp_2
Xfanout833 fanout846/X VGND VGND VPWR VPWR fanout833/X sky130_fd_sc_hd__clkdlybuf4s25_1
XFILLER_63_1443 VGND VGND VPWR VPWR sky130_fd_sc_hd__decap_3
Xfanout844 fanout846/X VGND VGND VPWR VPWR fanout844/X sky130_fd_sc_hd__clkdlybuf4s25_1
XTAP_TAPCELL_ROW_5_323 VGND VPWR sky130_fd_sc_hd__tapvpwrvgnd_1
XTAP_TAPCELL_ROW_5_334 VGND VPWR sky130_fd_sc_hd__tapvpwrvgnd_1
XFILLER_58_522 VGND VGND VPWR VPWR sky130_fd_sc_hd__decap_3
XFILLER_24_1427 VGND VGND VPWR VPWR sky130_fd_sc_hd__fill_1
XFILLER_24_1438 VGND VGND VPWR VPWR sky130_fd_sc_hd__decap_3
X_6139_ _6982_/CLK _6139_/D load_slew742/X VGND VGND VPWR VPWR _6139_/Q sky130_fd_sc_hd__dfrtp_2
XFILLER_19_909 VGND VGND VPWR VPWR sky130_fd_sc_hd__decap_3
Xhold1020 _6196_/Q VGND VGND VPWR VPWR _6043_/A0 sky130_fd_sc_hd__dlygate4sd3_1
Xhold1031 _6111_/Q VGND VGND VPWR VPWR _5958_/A0 sky130_fd_sc_hd__dlygate4sd3_1
Xhold1042 _6124_/Q VGND VGND VPWR VPWR _5971_/A0 sky130_fd_sc_hd__dlygate4sd3_1
Xhold1053 _6722_/Q VGND VGND VPWR VPWR _5668_/A0 sky130_fd_sc_hd__dlygate4sd3_1
XFILLER_46_728 VGND VGND VPWR VPWR sky130_fd_sc_hd__decap_3
XFILLER_22_1140 VGND VGND VPWR VPWR sky130_fd_sc_hd__decap_3
Xhold1064 _6006_/X VGND VGND VPWR VPWR _7010_/D sky130_fd_sc_hd__dlygate4sd3_1
XFILLER_2_1223 VGND VGND VPWR VPWR sky130_fd_sc_hd__decap_3
XFILLER_39_780 VGND VGND VPWR VPWR sky130_fd_sc_hd__decap_3
Xhold1075 _6153_/Q VGND VGND VPWR VPWR _6000_/A0 sky130_fd_sc_hd__dlygate4sd3_1
Xhold1086 _6735_/Q VGND VGND VPWR VPWR _5682_/A0 sky130_fd_sc_hd__dlygate4sd3_1
XTAP_TAPCELL_ROW_29_948 VGND VPWR sky130_fd_sc_hd__tapvpwrvgnd_1
Xhold1097 _6801_/Q VGND VGND VPWR VPWR _5757_/A1 sky130_fd_sc_hd__dlygate4sd3_1
XTAP_TAPCELL_ROW_29_959 VGND VPWR sky130_fd_sc_hd__tapvpwrvgnd_1
XFILLER_2_1256 VGND VGND VPWR VPWR sky130_fd_sc_hd__decap_3
XFILLER_22_1195 VGND VGND VPWR VPWR sky130_fd_sc_hd__fill_2
XFILLER_26_32 VGND VGND VPWR VPWR sky130_fd_sc_hd__fill_1
XFILLER_27_964 VGND VGND VPWR VPWR sky130_fd_sc_hd__decap_3
XFILLER_2_1267 VGND VGND VPWR VPWR sky130_fd_sc_hd__decap_3
XTAP_TAPCELL_ROW_16_609 VGND VPWR sky130_fd_sc_hd__tapvpwrvgnd_1
XFILLER_26_65 VGND VGND VPWR VPWR sky130_fd_sc_hd__decap_3
XFILLER_14_614 VGND VGND VPWR VPWR sky130_fd_sc_hd__decap_3
XFILLER_27_997 VGND VGND VPWR VPWR sky130_fd_sc_hd__decap_3
XFILLER_57_1236 VGND VGND VPWR VPWR sky130_fd_sc_hd__decap_3
XFILLER_53_271 VGND VGND VPWR VPWR sky130_fd_sc_hd__fill_1
XFILLER_57_1269 VGND VGND VPWR VPWR sky130_fd_sc_hd__decap_3
XFILLER_42_967 VGND VGND VPWR VPWR sky130_fd_sc_hd__decap_3
XFILLER_14_669 VGND VGND VPWR VPWR sky130_fd_sc_hd__decap_3
XFILLER_70_1403 VGND VGND VPWR VPWR sky130_fd_sc_hd__decap_3
XFILLER_70_1447 VGND VGND VPWR VPWR sky130_fd_sc_hd__decap_3
XFILLER_42_64 VGND VGND VPWR VPWR sky130_fd_sc_hd__decap_3
XFILLER_10_875 VGND VGND VPWR VPWR sky130_fd_sc_hd__decap_3
XFILLER_5_356 VGND VGND VPWR VPWR sky130_fd_sc_hd__fill_2
XFILLER_68_1332 VGND VGND VPWR VPWR sky130_fd_sc_hd__decap_3
XFILLER_29_1316 VGND VGND VPWR VPWR sky130_fd_sc_hd__decap_3
XFILLER_68_1365 VGND VGND VPWR VPWR sky130_fd_sc_hd__decap_3
XFILLER_68_1376 VGND VGND VPWR VPWR sky130_fd_sc_hd__decap_3
XFILLER_64_1229 VGND VGND VPWR VPWR sky130_fd_sc_hd__decap_3
XFILLER_3_36 VGND VGND VPWR VPWR sky130_fd_sc_hd__decap_3
XFILLER_7_1101 VGND VGND VPWR VPWR sky130_fd_sc_hd__decap_3
XFILLER_1_573 VGND VGND VPWR VPWR sky130_fd_sc_hd__decap_3
XFILLER_3_69 VGND VGND VPWR VPWR sky130_fd_sc_hd__decap_3
XTAP_TAPCELL_ROW_69_2005 VGND VPWR sky130_fd_sc_hd__tapvpwrvgnd_1
XFILLER_7_1145 VGND VGND VPWR VPWR sky130_fd_sc_hd__decap_3
XFILLER_67_72 VGND VGND VPWR VPWR sky130_fd_sc_hd__decap_3
XFILLER_3_1009 VGND VGND VPWR VPWR sky130_fd_sc_hd__decap_3
XFILLER_7_1189 VGND VGND VPWR VPWR sky130_fd_sc_hd__decap_3
XFILLER_40_1240 VGND VGND VPWR VPWR sky130_fd_sc_hd__decap_3
XFILLER_36_238 VGND VGND VPWR VPWR sky130_fd_sc_hd__decap_3
XFILLER_40_1273 VGND VGND VPWR VPWR sky130_fd_sc_hd__decap_3
XFILLER_64_569 VGND VGND VPWR VPWR sky130_fd_sc_hd__fill_1
XFILLER_18_975 VGND VGND VPWR VPWR sky130_fd_sc_hd__decap_3
XFILLER_45_772 VGND VGND VPWR VPWR sky130_fd_sc_hd__decap_3
XFILLER_75_1325 VGND VGND VPWR VPWR sky130_fd_sc_hd__decap_3
XFILLER_51_219 VGND VGND VPWR VPWR sky130_fd_sc_hd__decap_3
XFILLER_32_411 VGND VGND VPWR VPWR sky130_fd_sc_hd__decap_3
XFILLER_45_794 VGND VGND VPWR VPWR sky130_fd_sc_hd__decap_3
XFILLER_60_720 VGND VGND VPWR VPWR sky130_fd_sc_hd__decap_3
XFILLER_36_1309 VGND VGND VPWR VPWR sky130_fd_sc_hd__decap_3
XFILLER_75_1369 VGND VGND VPWR VPWR sky130_fd_sc_hd__decap_3
XFILLER_33_967 VGND VGND VPWR VPWR sky130_fd_sc_hd__decap_3
X_3840_ _3960_/A _6315_/Q VGND VGND VPWR VPWR _3840_/X sky130_fd_sc_hd__and2b_2
XFILLER_33_978 VGND VGND VPWR VPWR sky130_fd_sc_hd__decap_3
XTAP_TAPCELL_ROW_45_1370 VGND VPWR sky130_fd_sc_hd__tapvpwrvgnd_1
XTAP_TAPCELL_ROW_45_1381 VGND VPWR sky130_fd_sc_hd__tapvpwrvgnd_1
X_3771_ _4281_/B _4291_/A VGND VGND VPWR VPWR _4211_/A sky130_fd_sc_hd__xnor2_2
XFILLER_73_1093 VGND VGND VPWR VPWR sky130_fd_sc_hd__decap_3
XFILLER_34_1055 VGND VGND VPWR VPWR sky130_fd_sc_hd__decap_3
X_5510_ wire431/X _5512_/B _4355_/A VGND VGND VPWR VPWR _5513_/B sky130_fd_sc_hd__a21o_2
XTAP_TAPCELL_ROW_41_1256 VGND VPWR sky130_fd_sc_hd__tapvpwrvgnd_1
XFILLER_73_3 VGND VGND VPWR VPWR sky130_fd_sc_hd__decap_3
XFILLER_9_673 VGND VGND VPWR VPWR sky130_fd_sc_hd__decap_3
X_6490_ _6926_/CLK _6490_/D fanout759/X VGND VGND VPWR VPWR _6490_/Q sky130_fd_sc_hd__dfrtp_2
XTAP_TAPCELL_ROW_41_1267 VGND VPWR sky130_fd_sc_hd__tapvpwrvgnd_1
XFILLER_34_1088 VGND VGND VPWR VPWR sky130_fd_sc_hd__decap_3
XTAP_TAPCELL_ROW_41_1278 VGND VPWR sky130_fd_sc_hd__tapvpwrvgnd_1
XFILLER_12_1320 VGND VGND VPWR VPWR sky130_fd_sc_hd__decap_3
X_5441_ _5441_/A1 _5465_/A2 _4676_/X VGND VGND VPWR VPWR _6553_/D sky130_fd_sc_hd__a21o_2
XFILLER_69_1129 VGND VGND VPWR VPWR sky130_fd_sc_hd__decap_3
XFILLER_12_1353 VGND VGND VPWR VPWR sky130_fd_sc_hd__decap_3
XTAP_TAPCELL_ROW_58_1720 VGND VPWR sky130_fd_sc_hd__tapvpwrvgnd_1
X_5372_ _5372_/A1 _5476_/A2 _4235_/X VGND VGND VPWR VPWR _6484_/D sky130_fd_sc_hd__a21o_2
XFILLER_12_1397 VGND VGND VPWR VPWR sky130_fd_sc_hd__decap_3
XFILLER_47_1416 VGND VGND VPWR VPWR sky130_fd_sc_hd__decap_3
XTAP_TAPCELL_ROW_54_1606 VGND VPWR sky130_fd_sc_hd__tapvpwrvgnd_1
X_7111_ _7111_/A VGND VGND VPWR VPWR uio_out[6] sky130_fd_sc_hd__buf_2
XFILLER_5_890 VGND VGND VPWR VPWR sky130_fd_sc_hd__fill_1
X_4323_ _6268_/Q wire60/X _4320_/X _4322_/X VGND VGND VPWR VPWR _6268_/D sky130_fd_sc_hd__o22a_2
XTAP_TAPCELL_ROW_54_1617 VGND VPWR sky130_fd_sc_hd__tapvpwrvgnd_1
XFILLER_47_1449 VGND VGND VPWR VPWR sky130_fd_sc_hd__decap_3
Xfanout107 _5293_/A2 VGND VGND VPWR VPWR _5221_/A2 sky130_fd_sc_hd__clkdlybuf4s25_1
Xfanout118 fanout121/X VGND VGND VPWR VPWR _5287_/A2 sky130_fd_sc_hd__clkdlybuf4s25_1
X_7042_ _7050_/CLK _7042_/D fanout646/X VGND VGND VPWR VPWR _7042_/Q sky130_fd_sc_hd__dfrtp_2
X_4254_ _6310_/Q _4832_/A2 _3254_/X _4832_/B2 VGND VGND VPWR VPWR _4254_/X sky130_fd_sc_hd__a22o_2
XFILLER_45_1173 VGND VGND VPWR VPWR sky130_fd_sc_hd__decap_3
X_3205_ _7000_/Q wire419/X _3205_/B1 _3204_/X VGND VGND VPWR VPWR _3205_/X sky130_fd_sc_hd__a211o_2
XFILLER_41_1026 VGND VGND VPWR VPWR sky130_fd_sc_hd__decap_3
X_4185_ _6479_/Q _4261_/A2 _4772_/C1 _4184_/X VGND VGND VPWR VPWR _4185_/X sky130_fd_sc_hd__o211a_2
XFILLER_80_1086 VGND VGND VPWR VPWR sky130_fd_sc_hd__decap_3
XFILLER_68_886 VGND VGND VPWR VPWR sky130_fd_sc_hd__decap_3
X_3136_ _3136_/A _3136_/B VGND VGND VPWR VPWR _3136_/Y sky130_fd_sc_hd__nor2_2
XFILLER_23_1460 VGND VGND VPWR VPWR sky130_fd_sc_hd__decap_3
XFILLER_67_385 VGND VGND VPWR VPWR sky130_fd_sc_hd__decap_3
X_3067_ _6363_/Q VGND VGND VPWR VPWR _3067_/Y sky130_fd_sc_hd__inv_2
XFILLER_70_506 VGND VGND VPWR VPWR sky130_fd_sc_hd__decap_3
XFILLER_36_772 VGND VGND VPWR VPWR sky130_fd_sc_hd__decap_3
XFILLER_23_411 VGND VGND VPWR VPWR sky130_fd_sc_hd__decap_3
XFILLER_24_945 VGND VGND VPWR VPWR sky130_fd_sc_hd__fill_1
XFILLER_54_1409 VGND VGND VPWR VPWR sky130_fd_sc_hd__decap_3
XFILLER_51_742 VGND VGND VPWR VPWR sky130_fd_sc_hd__decap_3
XFILLER_23_444 VGND VGND VPWR VPWR sky130_fd_sc_hd__decap_3
X_6826_ _6882_/CLK _6826_/D wire652/X VGND VGND VPWR VPWR _6826_/Q sky130_fd_sc_hd__dfrtp_2
XFILLER_50_230 VGND VGND VPWR VPWR sky130_fd_sc_hd__fill_1
XFILLER_23_455 VGND VGND VPWR VPWR sky130_fd_sc_hd__decap_3
XFILLER_17_1220 VGND VGND VPWR VPWR sky130_fd_sc_hd__decap_3
XFILLER_52_1111 VGND VGND VPWR VPWR sky130_fd_sc_hd__decap_3
XFILLER_51_797 VGND VGND VPWR VPWR sky130_fd_sc_hd__decap_3
X_6757_ _6765_/CLK _6757_/D wire639/X VGND VGND VPWR VPWR _6757_/Q sky130_fd_sc_hd__dfrtp_2
XFILLER_17_1242 VGND VGND VPWR VPWR sky130_fd_sc_hd__decap_3
XFILLER_56_1291 VGND VGND VPWR VPWR sky130_fd_sc_hd__decap_3
X_3969_ _4123_/B2 _3966_/X _3967_/Y _3968_/X _4734_/C1 VGND VGND VPWR VPWR _3969_/X
+ sky130_fd_sc_hd__o221a_2
XFILLER_17_1275 VGND VGND VPWR VPWR sky130_fd_sc_hd__decap_3
XFILLER_12_12 VGND VGND VPWR VPWR sky130_fd_sc_hd__decap_3
X_5708_ _5910_/A0 _5708_/A1 wire89/A VGND VGND VPWR VPWR _6757_/D sky130_fd_sc_hd__mux2_1
XFILLER_52_1166 VGND VGND VPWR VPWR sky130_fd_sc_hd__decap_3
X_6688_ _6954_/CLK _6688_/D load_slew669/X VGND VGND VPWR VPWR _6688_/Q sky130_fd_sc_hd__dfrtp_2
X_5639_ _7066_/Q _7067_/Q VGND VGND VPWR VPWR _5758_/B sky130_fd_sc_hd__or2_2
XFILLER_30_1453 VGND VGND VPWR VPWR sky130_fd_sc_hd__decap_3
XFILLER_3_827 VGND VGND VPWR VPWR sky130_fd_sc_hd__decap_3
XFILLER_5_6 VGND VGND VPWR VPWR sky130_fd_sc_hd__decap_3
XFILLER_2_348 VGND VGND VPWR VPWR sky130_fd_sc_hd__decap_3
XFILLER_77_116 VGND VGND VPWR VPWR sky130_fd_sc_hd__fill_1
Xfanout630 _5825_/A0 VGND VGND VPWR VPWR _5899_/A0 sky130_fd_sc_hd__clkdlybuf4s25_1
XFILLER_8_1421 VGND VGND VPWR VPWR sky130_fd_sc_hd__decap_3
XFILLER_59_820 VGND VGND VPWR VPWR sky130_fd_sc_hd__decap_3
XFILLER_77_127 VGND VGND VPWR VPWR sky130_fd_sc_hd__decap_3
XFILLER_8_1432 VGND VGND VPWR VPWR sky130_fd_sc_hd__decap_3
XFILLER_63_1251 VGND VGND VPWR VPWR sky130_fd_sc_hd__decap_3
XFILLER_28_1371 VGND VGND VPWR VPWR sky130_fd_sc_hd__fill_1
XFILLER_28_1382 VGND VGND VPWR VPWR sky130_fd_sc_hd__decap_3
XFILLER_8_1465 VGND VGND VPWR VPWR sky130_fd_sc_hd__decap_3
Xfanout663 fanout665/X VGND VGND VPWR VPWR fanout663/X sky130_fd_sc_hd__clkdlybuf4s25_1
XFILLER_24_1235 VGND VGND VPWR VPWR sky130_fd_sc_hd__decap_3
XFILLER_63_1284 VGND VGND VPWR VPWR sky130_fd_sc_hd__decap_3
Xfanout685 fanout698/X VGND VGND VPWR VPWR fanout685/X sky130_fd_sc_hd__clkdlybuf4s25_1
XFILLER_59_875 VGND VGND VPWR VPWR sky130_fd_sc_hd__decap_3
XFILLER_63_1295 VGND VGND VPWR VPWR sky130_fd_sc_hd__decap_3
XFILLER_19_717 VGND VGND VPWR VPWR sky130_fd_sc_hd__fill_2
XFILLER_4_1329 VGND VGND VPWR VPWR sky130_fd_sc_hd__decap_3
XFILLER_58_363 VGND VGND VPWR VPWR sky130_fd_sc_hd__fill_1
XFILLER_73_300 VGND VGND VPWR VPWR sky130_fd_sc_hd__decap_3
XFILLER_59_897 VGND VGND VPWR VPWR sky130_fd_sc_hd__decap_3
XFILLER_24_1279 VGND VGND VPWR VPWR sky130_fd_sc_hd__decap_3
XFILLER_46_536 VGND VGND VPWR VPWR sky130_fd_sc_hd__decap_3
XFILLER_2_1020 VGND VGND VPWR VPWR sky130_fd_sc_hd__decap_3
XFILLER_2_1064 VGND VGND VPWR VPWR sky130_fd_sc_hd__decap_3
XFILLER_27_783 VGND VGND VPWR VPWR sky130_fd_sc_hd__fill_1
XFILLER_73_399 VGND VGND VPWR VPWR sky130_fd_sc_hd__decap_3
XFILLER_27_794 VGND VGND VPWR VPWR sky130_fd_sc_hd__decap_3
XFILLER_42_731 VGND VGND VPWR VPWR sky130_fd_sc_hd__decap_3
XFILLER_14_433 VGND VGND VPWR VPWR sky130_fd_sc_hd__decap_3
XFILLER_41_252 VGND VGND VPWR VPWR sky130_fd_sc_hd__decap_3
XFILLER_70_1200 VGND VGND VPWR VPWR sky130_fd_sc_hd__decap_3
XFILLER_14_477 VGND VGND VPWR VPWR sky130_fd_sc_hd__decap_3
XFILLER_70_1211 VGND VGND VPWR VPWR sky130_fd_sc_hd__decap_3
XFILLER_35_1331 VGND VGND VPWR VPWR sky130_fd_sc_hd__decap_3
XFILLER_41_274 VGND VGND VPWR VPWR sky130_fd_sc_hd__decap_3
XFILLER_74_1391 VGND VGND VPWR VPWR sky130_fd_sc_hd__decap_3
XFILLER_70_1244 VGND VGND VPWR VPWR sky130_fd_sc_hd__decap_3
XFILLER_35_1375 VGND VGND VPWR VPWR sky130_fd_sc_hd__decap_3
XFILLER_10_661 VGND VGND VPWR VPWR sky130_fd_sc_hd__decap_3
XFILLER_70_1288 VGND VGND VPWR VPWR sky130_fd_sc_hd__decap_3
XFILLER_31_1239 VGND VGND VPWR VPWR sky130_fd_sc_hd__decap_3
XFILLER_6_665 VGND VGND VPWR VPWR sky130_fd_sc_hd__decap_3
XFILLER_5_164 VGND VGND VPWR VPWR sky130_fd_sc_hd__decap_3
XFILLER_68_1184 VGND VGND VPWR VPWR sky130_fd_sc_hd__decap_3
XFILLER_9_1207 VGND VGND VPWR VPWR sky130_fd_sc_hd__decap_3
XFILLER_64_1037 VGND VGND VPWR VPWR sky130_fd_sc_hd__decap_3
XFILLER_78_71 VGND VGND VPWR VPWR sky130_fd_sc_hd__decap_3
XFILLER_38_6 VGND VGND VPWR VPWR sky130_fd_sc_hd__decap_3
XFILLER_2_893 VGND VGND VPWR VPWR sky130_fd_sc_hd__decap_3
XFILLER_1_370 VGND VGND VPWR VPWR sky130_fd_sc_hd__decap_3
XFILLER_68_138 VGND VGND VPWR VPWR sky130_fd_sc_hd__fill_2
XFILLER_42_1335 VGND VGND VPWR VPWR sky130_fd_sc_hd__decap_3
XTAP_TAPCELL_ROW_34_1082 VGND VPWR sky130_fd_sc_hd__tapvpwrvgnd_1
XFILLER_49_363 VGND VGND VPWR VPWR sky130_fd_sc_hd__decap_3
XTAP_TAPCELL_ROW_34_1093 VGND VPWR sky130_fd_sc_hd__tapvpwrvgnd_1
XFILLER_42_1368 VGND VGND VPWR VPWR sky130_fd_sc_hd__decap_3
XFILLER_42_1379 VGND VGND VPWR VPWR sky130_fd_sc_hd__decap_3
XFILLER_49_396 VGND VGND VPWR VPWR sky130_fd_sc_hd__decap_3
XFILLER_76_193 VGND VGND VPWR VPWR sky130_fd_sc_hd__decap_3
X_5990_ _5990_/A0 _5990_/A1 _6001_/S VGND VGND VPWR VPWR _6994_/D sky130_fd_sc_hd__mux2_1
XFILLER_64_377 VGND VGND VPWR VPWR sky130_fd_sc_hd__fill_1
XFILLER_75_1111 VGND VGND VPWR VPWR sky130_fd_sc_hd__decap_3
XTAP_TAPCELL_ROW_47_1410 VGND VPWR sky130_fd_sc_hd__tapvpwrvgnd_1
XFILLER_52_528 VGND VGND VPWR VPWR sky130_fd_sc_hd__decap_3
XTAP_TAPCELL_ROW_47_1421 VGND VPWR sky130_fd_sc_hd__tapvpwrvgnd_1
X_4941_ _4939_/X _4940_/Y _5215_/A2 VGND VGND VPWR VPWR _4943_/S sky130_fd_sc_hd__a21oi_2
XFILLER_18_794 VGND VGND VPWR VPWR sky130_fd_sc_hd__decap_3
XTAP_TAPCELL_ROW_47_1432 VGND VPWR sky130_fd_sc_hd__tapvpwrvgnd_1
XFILLER_75_1133 VGND VGND VPWR VPWR sky130_fd_sc_hd__decap_3
XFILLER_75_1166 VGND VGND VPWR VPWR sky130_fd_sc_hd__decap_3
XFILLER_36_1117 VGND VGND VPWR VPWR sky130_fd_sc_hd__fill_2
X_4872_ _4872_/A _4872_/B VGND VGND VPWR VPWR _4872_/Y sky130_fd_sc_hd__nor2_2
XTAP_TAPCELL_ROW_43_1307 VGND VPWR sky130_fd_sc_hd__tapvpwrvgnd_1
XFILLER_75_1177 VGND VGND VPWR VPWR sky130_fd_sc_hd__decap_3
XFILLER_21_915 VGND VGND VPWR VPWR sky130_fd_sc_hd__decap_3
XTAP_TAPCELL_ROW_43_1318 VGND VPWR sky130_fd_sc_hd__tapvpwrvgnd_1
XTAP_TAPCELL_ROW_43_1329 VGND VPWR sky130_fd_sc_hd__tapvpwrvgnd_1
X_6611_ _6617_/CLK _6611_/D fanout731/X VGND VGND VPWR VPWR _6611_/Q sky130_fd_sc_hd__dfrtp_2
XFILLER_60_572 VGND VGND VPWR VPWR sky130_fd_sc_hd__decap_3
X_3823_ _3758_/A _3758_/B _3821_/Y _3822_/X VGND VGND VPWR VPWR _3827_/B sky130_fd_sc_hd__a211o_2
XFILLER_20_414 VGND VGND VPWR VPWR sky130_fd_sc_hd__decap_3
XFILLER_32_274 VGND VGND VPWR VPWR sky130_fd_sc_hd__decap_3
XFILLER_53_1431 VGND VGND VPWR VPWR sky130_fd_sc_hd__decap_3
XFILLER_21_959 VGND VGND VPWR VPWR sky130_fd_sc_hd__decap_3
XFILLER_14_1415 VGND VGND VPWR VPWR sky130_fd_sc_hd__decap_3
X_6542_ _7057_/CLK _6542_/D load_slew718/X VGND VGND VPWR VPWR _6542_/Q sky130_fd_sc_hd__dfrtp_2
X_3754_ _3753_/A _3879_/B _3879_/C _3753_/B VGND VGND VPWR VPWR _3760_/B sky130_fd_sc_hd__a31o_2
XFILLER_14_1459 VGND VGND VPWR VPWR sky130_fd_sc_hd__decap_3
XTAP_TAPCELL_ROW_31_998 VGND VPWR sky130_fd_sc_hd__tapvpwrvgnd_1
X_6473_ _7007_/CLK _6473_/D load_slew778/X VGND VGND VPWR VPWR _6473_/Q sky130_fd_sc_hd__dfrtp_2
X_3685_ _3693_/A _3693_/C _3683_/B _3683_/A wire26/X VGND VGND VPWR VPWR _3685_/X
+ sky130_fd_sc_hd__o221a_2
X_5424_ _5424_/A1 _5456_/A2 _4551_/X VGND VGND VPWR VPWR _6536_/D sky130_fd_sc_hd__a21o_2
XFILLER_12_1183 VGND VGND VPWR VPWR sky130_fd_sc_hd__decap_3
X_5355_ _6470_/Q _5354_/X _5355_/S VGND VGND VPWR VPWR _6470_/D sky130_fd_sc_hd__mux2_1
XFILLER_47_1224 VGND VGND VPWR VPWR sky130_fd_sc_hd__decap_3
XFILLER_0_819 VGND VGND VPWR VPWR sky130_fd_sc_hd__decap_3
XFILLER_47_1257 VGND VGND VPWR VPWR sky130_fd_sc_hd__decap_3
X_4306_ _4338_/A _4865_/B VGND VGND VPWR VPWR _4306_/Y sky130_fd_sc_hd__nand2_2
X_5286_ _6775_/Q _5285_/A _5286_/B1 _5285_/Y VGND VGND VPWR VPWR _5286_/X sky130_fd_sc_hd__o211a_2
XFILLER_59_116 VGND VGND VPWR VPWR sky130_fd_sc_hd__decap_3
X_7025_ _7025_/CLK _7025_/D wire764/X VGND VGND VPWR VPWR _7025_/Q sky130_fd_sc_hd__dfrtp_2
X_4237_ _6822_/Q wire295/X _4876_/B1 _4236_/X VGND VGND VPWR VPWR _4237_/X sky130_fd_sc_hd__a211o_2
XFILLER_60_1424 VGND VGND VPWR VPWR sky130_fd_sc_hd__decap_3
XFILLER_60_1435 VGND VGND VPWR VPWR sky130_fd_sc_hd__decap_3
XFILLER_21_1419 VGND VGND VPWR VPWR sky130_fd_sc_hd__decap_3
XFILLER_60_1468 VGND VGND VPWR VPWR sky130_fd_sc_hd__fill_1
XFILLER_74_18 VGND VGND VPWR VPWR sky130_fd_sc_hd__decap_3
X_4168_ _6253_/Q _4622_/S _4165_/X _4167_/X VGND VGND VPWR VPWR _6253_/D sky130_fd_sc_hd__o22a_2
XFILLER_55_322 VGND VGND VPWR VPWR sky130_fd_sc_hd__decap_3
XFILLER_74_29 VGND VGND VPWR VPWR sky130_fd_sc_hd__decap_3
XFILLER_3_1340 VGND VGND VPWR VPWR sky130_fd_sc_hd__decap_3
X_3119_ _6994_/Q wire419/X _6081_/B _7002_/Q VGND VGND VPWR VPWR _3119_/X sky130_fd_sc_hd__a22o_2
XFILLER_3_1351 VGND VGND VPWR VPWR sky130_fd_sc_hd__decap_3
X_4099_ _6246_/Q _4105_/A2 _4097_/X _4098_/X VGND VGND VPWR VPWR _6246_/D sky130_fd_sc_hd__o22a_2
XFILLER_15_219 VGND VGND VPWR VPWR sky130_fd_sc_hd__decap_3
XFILLER_3_1384 VGND VGND VPWR VPWR sky130_fd_sc_hd__decap_3
XFILLER_43_528 VGND VGND VPWR VPWR sky130_fd_sc_hd__decap_3
XFILLER_58_1320 VGND VGND VPWR VPWR sky130_fd_sc_hd__decap_3
XFILLER_19_1304 VGND VGND VPWR VPWR sky130_fd_sc_hd__decap_3
XFILLER_58_1353 VGND VGND VPWR VPWR sky130_fd_sc_hd__decap_3
XFILLER_19_1337 VGND VGND VPWR VPWR sky130_fd_sc_hd__decap_3
XFILLER_19_1348 VGND VGND VPWR VPWR sky130_fd_sc_hd__decap_3
XFILLER_51_561 VGND VGND VPWR VPWR sky130_fd_sc_hd__decap_3
XFILLER_58_1397 VGND VGND VPWR VPWR sky130_fd_sc_hd__decap_3
XFILLER_12_937 VGND VGND VPWR VPWR sky130_fd_sc_hd__decap_3
XFILLER_23_263 VGND VGND VPWR VPWR sky130_fd_sc_hd__decap_3
X_6809_ _7065_/CLK _6809_/D fanout735/X VGND VGND VPWR VPWR _6809_/Q sky130_fd_sc_hd__dfrtp_2
XFILLER_11_425 VGND VGND VPWR VPWR sky130_fd_sc_hd__decap_3
XFILLER_23_296 VGND VGND VPWR VPWR sky130_fd_sc_hd__decap_3
XFILLER_7_429 VGND VGND VPWR VPWR sky130_fd_sc_hd__fill_2
XFILLER_20_970 VGND VGND VPWR VPWR sky130_fd_sc_hd__decap_3
XFILLER_20_981 VGND VGND VPWR VPWR sky130_fd_sc_hd__decap_3
XFILLER_30_1250 VGND VGND VPWR VPWR sky130_fd_sc_hd__decap_3
XFILLER_30_1261 VGND VGND VPWR VPWR sky130_fd_sc_hd__decap_3
XFILLER_69_1460 VGND VGND VPWR VPWR sky130_fd_sc_hd__decap_3
XFILLER_3_635 VGND VGND VPWR VPWR sky130_fd_sc_hd__fill_1
XFILLER_2_112 VGND VGND VPWR VPWR sky130_fd_sc_hd__decap_3
XFILLER_30_1294 VGND VGND VPWR VPWR sky130_fd_sc_hd__decap_3
XFILLER_3_646 VGND VGND VPWR VPWR sky130_fd_sc_hd__decap_3
XFILLER_65_1313 VGND VGND VPWR VPWR sky130_fd_sc_hd__decap_3
XFILLER_3_3 VGND VGND VPWR VPWR sky130_fd_sc_hd__decap_3
XFILLER_3_679 VGND VGND VPWR VPWR sky130_fd_sc_hd__decap_3
XFILLER_2_156 VGND VGND VPWR VPWR sky130_fd_sc_hd__decap_3
XFILLER_65_1357 VGND VGND VPWR VPWR sky130_fd_sc_hd__decap_3
XFILLER_2_189 VGND VGND VPWR VPWR sky130_fd_sc_hd__decap_3
XFILLER_66_609 VGND VGND VPWR VPWR sky130_fd_sc_hd__decap_3
XFILLER_59_650 VGND VGND VPWR VPWR sky130_fd_sc_hd__fill_1
Xfanout460 _4838_/A1 VGND VGND VPWR VPWR _4654_/A1 sky130_fd_sc_hd__clkdlybuf4s25_1
XFILLER_48_63 VGND VGND VPWR VPWR sky130_fd_sc_hd__fill_1
XFILLER_8_1273 VGND VGND VPWR VPWR sky130_fd_sc_hd__decap_3
Xfanout471 _7090_/Q VGND VGND VPWR VPWR _5358_/C sky130_fd_sc_hd__clkdlybuf4s25_1
Xfanout493 _5581_/A VGND VGND VPWR VPWR _5577_/A sky130_fd_sc_hd__clkdlybuf4s25_1
XFILLER_4_1126 VGND VGND VPWR VPWR sky130_fd_sc_hd__decap_3
XFILLER_48_85 VGND VGND VPWR VPWR sky130_fd_sc_hd__decap_3
XFILLER_0_15 VGND VGND VPWR VPWR sky130_fd_sc_hd__decap_3
XFILLER_47_878 VGND VGND VPWR VPWR sky130_fd_sc_hd__decap_3
XFILLER_59_1117 VGND VGND VPWR VPWR sky130_fd_sc_hd__decap_3
XFILLER_34_506 VGND VGND VPWR VPWR sky130_fd_sc_hd__decap_3
XFILLER_41_1390 VGND VGND VPWR VPWR sky130_fd_sc_hd__decap_3
XFILLER_64_51 VGND VGND VPWR VPWR sky130_fd_sc_hd__decap_3
XFILLER_15_720 VGND VGND VPWR VPWR sky130_fd_sc_hd__decap_3
XFILLER_27_580 VGND VGND VPWR VPWR sky130_fd_sc_hd__decap_3
XFILLER_76_1453 VGND VGND VPWR VPWR sky130_fd_sc_hd__decap_3
XFILLER_37_1404 VGND VGND VPWR VPWR sky130_fd_sc_hd__decap_3
XFILLER_15_753 VGND VGND VPWR VPWR sky130_fd_sc_hd__decap_3
XFILLER_72_1306 VGND VGND VPWR VPWR sky130_fd_sc_hd__decap_3
XFILLER_72_1317 VGND VGND VPWR VPWR sky130_fd_sc_hd__decap_3
XFILLER_37_1437 VGND VGND VPWR VPWR sky130_fd_sc_hd__decap_3
XFILLER_9_24 VGND VGND VPWR VPWR sky130_fd_sc_hd__decap_3
XFILLER_30_701 VGND VGND VPWR VPWR sky130_fd_sc_hd__fill_2
XFILLER_30_734 VGND VGND VPWR VPWR sky130_fd_sc_hd__fill_2
XFILLER_80_50 VGND VGND VPWR VPWR sky130_fd_sc_hd__decap_3
XFILLER_30_778 VGND VGND VPWR VPWR sky130_fd_sc_hd__decap_3
XFILLER_35_1172 VGND VGND VPWR VPWR sky130_fd_sc_hd__decap_3
XFILLER_80_94 VGND VGND VPWR VPWR sky130_fd_sc_hd__decap_3
XFILLER_70_1085 VGND VGND VPWR VPWR sky130_fd_sc_hd__fill_1
XFILLER_31_1047 VGND VGND VPWR VPWR sky130_fd_sc_hd__fill_1
XFILLER_10_480 VGND VGND VPWR VPWR sky130_fd_sc_hd__decap_3
Xhold908 _6030_/X VGND VGND VPWR VPWR _7034_/D sky130_fd_sc_hd__dlygate4sd3_1
Xhold919 _6145_/Q VGND VGND VPWR VPWR hold919/X sky130_fd_sc_hd__dlygate4sd3_1
X_3470_ _6242_/Q _6466_/Q VGND VGND VPWR VPWR _3470_/X sky130_fd_sc_hd__xor2_2
XFILLER_6_495 VGND VGND VPWR VPWR sky130_fd_sc_hd__decap_3
XTAP_TAPCELL_ROW_36_1133 VGND VPWR sky130_fd_sc_hd__tapvpwrvgnd_1
X_5140_ _6717_/Q _5216_/A VGND VGND VPWR VPWR _5140_/X sky130_fd_sc_hd__or2_2
XFILLER_36_3 VGND VGND VPWR VPWR sky130_fd_sc_hd__decap_3
XTAP_TAPCELL_ROW_36_1144 VGND VPWR sky130_fd_sc_hd__tapvpwrvgnd_1
Xload_slew822 fanout821/X VGND VGND VPWR VPWR load_slew822/X sky130_fd_sc_hd__buf_4
XFILLER_2_690 VGND VGND VPWR VPWR sky130_fd_sc_hd__decap_3
X_5071_ _6464_/Q _5071_/B VGND VGND VPWR VPWR _5072_/B sky130_fd_sc_hd__xnor2_2
XFILLER_78_981 VGND VGND VPWR VPWR sky130_fd_sc_hd__decap_3
X_4022_ _4040_/A1 _4694_/B _5605_/A3 _4008_/Y _6562_/Q VGND VGND VPWR VPWR _4022_/X
+ sky130_fd_sc_hd__a32o_2
XFILLER_37_311 VGND VGND VPWR VPWR sky130_fd_sc_hd__decap_3
XFILLER_49_193 VGND VGND VPWR VPWR sky130_fd_sc_hd__fill_2
XFILLER_38_867 VGND VGND VPWR VPWR sky130_fd_sc_hd__fill_1
XFILLER_38_878 VGND VGND VPWR VPWR sky130_fd_sc_hd__decap_3
XFILLER_80_601 VGND VGND VPWR VPWR sky130_fd_sc_hd__decap_3
XFILLER_77_1228 VGND VGND VPWR VPWR sky130_fd_sc_hd__decap_3
XFILLER_20_1441 VGND VGND VPWR VPWR sky130_fd_sc_hd__decap_3
XFILLER_37_366 VGND VGND VPWR VPWR sky130_fd_sc_hd__decap_3
XFILLER_53_815 VGND VGND VPWR VPWR sky130_fd_sc_hd__fill_2
XFILLER_80_623 VGND VGND VPWR VPWR sky130_fd_sc_hd__decap_3
XFILLER_77_1239 VGND VGND VPWR VPWR sky130_fd_sc_hd__decap_3
XFILLER_37_388 VGND VGND VPWR VPWR sky130_fd_sc_hd__decap_3
X_5973_ hold902/X hold947/X _6021_/S VGND VGND VPWR VPWR _6977_/D sky130_fd_sc_hd__mux2_1
XFILLER_80_645 VGND VGND VPWR VPWR sky130_fd_sc_hd__fill_2
X_4924_ _6411_/Q _4924_/B VGND VGND VPWR VPWR _5207_/B sky130_fd_sc_hd__xnor2_2
XFILLER_33_550 VGND VGND VPWR VPWR sky130_fd_sc_hd__decap_3
XFILLER_33_561 VGND VGND VPWR VPWR sky130_fd_sc_hd__decap_3
XFILLER_20_200 VGND VGND VPWR VPWR sky130_fd_sc_hd__decap_3
XFILLER_61_892 VGND VGND VPWR VPWR sky130_fd_sc_hd__decap_3
X_4855_ _6923_/Q _4855_/A2 _4855_/B1 _4854_/X VGND VGND VPWR VPWR _4855_/X sky130_fd_sc_hd__a211o_2
X_3806_ _6282_/Q _3928_/A2 _3928_/B1 _6258_/Q _3928_/C1 VGND VGND VPWR VPWR _3806_/X
+ sky130_fd_sc_hd__a221o_2
XFILLER_14_1223 VGND VGND VPWR VPWR sky130_fd_sc_hd__decap_3
X_4786_ _6576_/Q _4786_/B VGND VGND VPWR VPWR _4786_/Y sky130_fd_sc_hd__nand2_2
XFILLER_53_1272 VGND VGND VPWR VPWR sky130_fd_sc_hd__decap_3
XFILLER_20_277 VGND VGND VPWR VPWR sky130_fd_sc_hd__decap_3
XFILLER_14_1256 VGND VGND VPWR VPWR sky130_fd_sc_hd__decap_3
X_6525_ _6863_/CLK _6525_/D fanout758/X VGND VGND VPWR VPWR _6525_/Q sky130_fd_sc_hd__dfrtp_2
XFILLER_14_1267 VGND VGND VPWR VPWR sky130_fd_sc_hd__decap_3
X_3737_ _6247_/Q _5517_/A3 _3735_/X _3736_/X VGND VGND VPWR VPWR _4347_/A sky130_fd_sc_hd__o22a_2
X_6456_ _6858_/CLK _6456_/D wire652/X VGND VGND VPWR VPWR _6456_/Q sky130_fd_sc_hd__dfrtp_2
X_3668_ _3669_/A _3669_/B VGND VGND VPWR VPWR _3748_/B sky130_fd_sc_hd__xor2_2
XFILLER_49_1319 VGND VGND VPWR VPWR sky130_fd_sc_hd__decap_3
XFILLER_69_18 VGND VGND VPWR VPWR sky130_fd_sc_hd__decap_3
X_5407_ _5407_/A1 _5479_/A2 _4483_/X VGND VGND VPWR VPWR _6519_/D sky130_fd_sc_hd__a21o_2
X_6387_ clkload7/A _6387_/D wire639/X VGND VGND VPWR VPWR _6387_/Q sky130_fd_sc_hd__dfrtp_2
X_3599_ _3594_/X _3595_/X _4355_/A _3593_/X VGND VGND VPWR VPWR _3599_/X sky130_fd_sc_hd__o211a_2
XFILLER_47_1032 VGND VGND VPWR VPWR sky130_fd_sc_hd__fill_2
X_5338_ _6800_/Q _5057_/B _5338_/S VGND VGND VPWR VPWR _5338_/X sky130_fd_sc_hd__mux2_1
XFILLER_47_1065 VGND VGND VPWR VPWR sky130_fd_sc_hd__decap_3
XFILLER_76_918 VGND VGND VPWR VPWR sky130_fd_sc_hd__decap_3
X_5269_ _6431_/Q _5269_/A2 _5268_/X VGND VGND VPWR VPWR _6431_/D sky130_fd_sc_hd__a21o_2
XFILLER_75_417 VGND VGND VPWR VPWR sky130_fd_sc_hd__decap_3
XFILLER_5_1413 VGND VGND VPWR VPWR sky130_fd_sc_hd__decap_3
XFILLER_60_1232 VGND VGND VPWR VPWR sky130_fd_sc_hd__decap_3
X_7008_ _7072_/CLK _7008_/D wire687/X VGND VGND VPWR VPWR _7008_/Q sky130_fd_sc_hd__dfrtp_2
XFILLER_25_1363 VGND VGND VPWR VPWR sky130_fd_sc_hd__decap_3
XFILLER_69_992 VGND VGND VPWR VPWR sky130_fd_sc_hd__decap_3
XFILLER_5_1446 VGND VGND VPWR VPWR sky130_fd_sc_hd__decap_3
XFILLER_29_834 VGND VGND VPWR VPWR sky130_fd_sc_hd__decap_3
XFILLER_68_480 VGND VGND VPWR VPWR sky130_fd_sc_hd__decap_3
XFILLER_5_1457 VGND VGND VPWR VPWR sky130_fd_sc_hd__decap_3
XFILLER_25_1396 VGND VGND VPWR VPWR sky130_fd_sc_hd__decap_3
XFILLER_60_1276 VGND VGND VPWR VPWR sky130_fd_sc_hd__decap_3
XFILLER_28_355 VGND VGND VPWR VPWR sky130_fd_sc_hd__decap_3
XFILLER_16_506 VGND VGND VPWR VPWR sky130_fd_sc_hd__decap_3
XFILLER_29_889 VGND VGND VPWR VPWR sky130_fd_sc_hd__decap_3
XFILLER_43_303 VGND VGND VPWR VPWR sky130_fd_sc_hd__decap_3
XFILLER_3_1192 VGND VGND VPWR VPWR sky130_fd_sc_hd__decap_3
XFILLER_52_881 VGND VGND VPWR VPWR sky130_fd_sc_hd__decap_3
XFILLER_24_583 VGND VGND VPWR VPWR sky130_fd_sc_hd__decap_3
XFILLER_11_222 VGND VGND VPWR VPWR sky130_fd_sc_hd__fill_2
XFILLER_8_716 VGND VGND VPWR VPWR sky130_fd_sc_hd__decap_3
XFILLER_12_778 VGND VGND VPWR VPWR sky130_fd_sc_hd__decap_3
XFILLER_32_1312 VGND VGND VPWR VPWR sky130_fd_sc_hd__decap_3
XFILLER_71_1372 VGND VGND VPWR VPWR sky130_fd_sc_hd__decap_3
XTAP_TAPCELL_ROW_22_762 VGND VPWR sky130_fd_sc_hd__tapvpwrvgnd_1
XFILLER_32_1323 VGND VGND VPWR VPWR sky130_fd_sc_hd__decap_3
XTAP_TAPCELL_ROW_22_773 VGND VPWR sky130_fd_sc_hd__tapvpwrvgnd_1
XFILLER_11_277 VGND VGND VPWR VPWR sky130_fd_sc_hd__decap_3
XTAP_TAPCELL_ROW_22_784 VGND VPWR sky130_fd_sc_hd__tapvpwrvgnd_1
Xwire157 _3561_/Y VGND VGND VPWR VPWR _3637_/B sky130_fd_sc_hd__buf_2
XFILLER_32_1356 VGND VGND VPWR VPWR sky130_fd_sc_hd__decap_3
XFILLER_4_900 VGND VGND VPWR VPWR sky130_fd_sc_hd__decap_3
XFILLER_67_1419 VGND VGND VPWR VPWR sky130_fd_sc_hd__decap_3
XTAP_TAPCELL_ROW_76_2170 VGND VPWR sky130_fd_sc_hd__tapvpwrvgnd_1
XTAP_TAPCELL_ROW_76_2181 VGND VPWR sky130_fd_sc_hd__tapvpwrvgnd_1
XFILLER_3_432 VGND VGND VPWR VPWR sky130_fd_sc_hd__decap_3
XFILLER_4_977 VGND VGND VPWR VPWR sky130_fd_sc_hd__decap_3
XFILLER_65_1132 VGND VGND VPWR VPWR sky130_fd_sc_hd__decap_3
XTAP_TAPCELL_ROW_72_2067 VGND VPWR sky130_fd_sc_hd__tapvpwrvgnd_1
XFILLER_78_200 VGND VGND VPWR VPWR sky130_fd_sc_hd__decap_3
XTAP_TAPCELL_ROW_72_2078 VGND VPWR sky130_fd_sc_hd__tapvpwrvgnd_1
XFILLER_79_756 VGND VGND VPWR VPWR sky130_fd_sc_hd__decap_3
XFILLER_67_918 VGND VGND VPWR VPWR sky130_fd_sc_hd__decap_3
XFILLER_79_778 VGND VGND VPWR VPWR sky130_fd_sc_hd__decap_3
XFILLER_22_9 VGND VGND VPWR VPWR sky130_fd_sc_hd__decap_3
XFILLER_66_417 VGND VGND VPWR VPWR sky130_fd_sc_hd__decap_3
XFILLER_43_1452 VGND VGND VPWR VPWR sky130_fd_sc_hd__decap_3
XFILLER_43_1463 VGND VGND VPWR VPWR sky130_fd_sc_hd__decap_3
XFILLER_75_951 VGND VGND VPWR VPWR sky130_fd_sc_hd__fill_1
XFILLER_75_50 VGND VGND VPWR VPWR sky130_fd_sc_hd__decap_3
XFILLER_19_333 VGND VGND VPWR VPWR sky130_fd_sc_hd__decap_3
XFILLER_75_973 VGND VGND VPWR VPWR sky130_fd_sc_hd__decap_3
XFILLER_46_141 VGND VGND VPWR VPWR sky130_fd_sc_hd__decap_3
Xload_slew43 _4592_/B1 VGND VGND VPWR VPWR _4766_/B1 sky130_fd_sc_hd__clkbuf_4
XFILLER_62_601 VGND VGND VPWR VPWR sky130_fd_sc_hd__decap_3
Xload_slew65 _4593_/A2 VGND VGND VPWR VPWR _4622_/S sky130_fd_sc_hd__clkbuf_4
XFILLER_61_122 VGND VGND VPWR VPWR sky130_fd_sc_hd__decap_3
XFILLER_76_1250 VGND VGND VPWR VPWR sky130_fd_sc_hd__decap_3
XFILLER_76_1261 VGND VGND VPWR VPWR sky130_fd_sc_hd__decap_3
XFILLER_15_561 VGND VGND VPWR VPWR sky130_fd_sc_hd__decap_3
XFILLER_72_1114 VGND VGND VPWR VPWR sky130_fd_sc_hd__decap_3
XFILLER_76_1294 VGND VGND VPWR VPWR sky130_fd_sc_hd__decap_3
XFILLER_37_1245 VGND VGND VPWR VPWR sky130_fd_sc_hd__decap_3
XFILLER_72_1147 VGND VGND VPWR VPWR sky130_fd_sc_hd__fill_1
XFILLER_30_520 VGND VGND VPWR VPWR sky130_fd_sc_hd__decap_3
XFILLER_72_1158 VGND VGND VPWR VPWR sky130_fd_sc_hd__decap_3
XFILLER_37_1278 VGND VGND VPWR VPWR sky130_fd_sc_hd__decap_3
XFILLER_30_553 VGND VGND VPWR VPWR sky130_fd_sc_hd__decap_3
XFILLER_37_1289 VGND VGND VPWR VPWR sky130_fd_sc_hd__decap_3
X_4640_ _4817_/A1 _4637_/X _4638_/Y _4639_/X _4874_/C1 VGND VGND VPWR VPWR _4640_/X
+ sky130_fd_sc_hd__o221a_2
XFILLER_50_1412 VGND VGND VPWR VPWR sky130_fd_sc_hd__decap_3
XTAP_TAPCELL_ROW_61_1782 VGND VPWR sky130_fd_sc_hd__tapvpwrvgnd_1
XFILLER_30_597 VGND VGND VPWR VPWR sky130_fd_sc_hd__decap_3
XTAP_TAPCELL_ROW_61_1793 VGND VPWR sky130_fd_sc_hd__tapvpwrvgnd_1
XFILLER_11_1407 VGND VGND VPWR VPWR sky130_fd_sc_hd__decap_3
XFILLER_50_1456 VGND VGND VPWR VPWR sky130_fd_sc_hd__decap_3
X_4571_ _5508_/A _5588_/A3 _4586_/C _4444_/Y _4570_/X VGND VGND VPWR VPWR _4574_/B
+ sky130_fd_sc_hd__a41o_2
X_6310_ _7016_/CLK _6310_/D fanout659/X VGND VGND VPWR VPWR _6310_/Q sky130_fd_sc_hd__dfrtp_2
X_3522_ _6632_/Q _5600_/A2 _5606_/A2 _6640_/Q _3533_/B1 VGND VGND VPWR VPWR _3522_/X
+ sky130_fd_sc_hd__a221o_2
XFILLER_7_782 VGND VGND VPWR VPWR sky130_fd_sc_hd__fill_2
XFILLER_6_281 VGND VGND VPWR VPWR sky130_fd_sc_hd__decap_3
X_6241_ _6807_/CLK _6241_/D load_slew786/X VGND VGND VPWR VPWR _6241_/Q sky130_fd_sc_hd__dfrtp_2
X_3453_ _6047_/A0 _3452_/X _3453_/S VGND VGND VPWR VPWR _6200_/D sky130_fd_sc_hd__mux2_1
XFILLER_48_1341 VGND VGND VPWR VPWR sky130_fd_sc_hd__decap_3
X_6172_ _7055_/CLK _6172_/D fanout791/A VGND VGND VPWR VPWR _6172_/Q sky130_fd_sc_hd__dfrtp_2
X_3384_ _6311_/Q _6423_/Q VGND VGND VPWR VPWR _3384_/X sky130_fd_sc_hd__xor2_2
XFILLER_48_1385 VGND VGND VPWR VPWR sky130_fd_sc_hd__decap_3
X_5123_ _5123_/A _5123_/B VGND VGND VPWR VPWR _5123_/X sky130_fd_sc_hd__or2_2
XFILLER_58_918 VGND VGND VPWR VPWR sky130_fd_sc_hd__decap_3
XFILLER_44_1249 VGND VGND VPWR VPWR sky130_fd_sc_hd__decap_3
Xhold1405 _6480_/Q VGND VGND VPWR VPWR _5368_/A1 sky130_fd_sc_hd__dlygate4sd3_1
Xhold1416 _6904_/Q VGND VGND VPWR VPWR _5895_/A1 sky130_fd_sc_hd__dlygate4sd3_1
Xload_slew674 fanout673/X VGND VGND VPWR VPWR load_slew674/X sky130_fd_sc_hd__buf_4
Xhold1427 _6487_/Q VGND VGND VPWR VPWR _5375_/A1 sky130_fd_sc_hd__dlygate4sd3_1
Xload_slew696 fanout695/X VGND VGND VPWR VPWR load_slew696/X sky130_fd_sc_hd__clkbuf_4
Xhold1438 _6579_/Q VGND VGND VPWR VPWR _5467_/A1 sky130_fd_sc_hd__dlygate4sd3_1
X_5054_ _6703_/Q _3069_/Y _5334_/S VGND VGND VPWR VPWR _5054_/X sky130_fd_sc_hd__mux2_1
Xhold1449 _6521_/Q VGND VGND VPWR VPWR _5409_/A1 sky130_fd_sc_hd__dlygate4sd3_1
XFILLER_38_653 VGND VGND VPWR VPWR sky130_fd_sc_hd__decap_3
XFILLER_66_962 VGND VGND VPWR VPWR sky130_fd_sc_hd__decap_3
X_4005_ _4779_/A1 _4002_/X _4003_/Y _4004_/X _4005_/C1 VGND VGND VPWR VPWR _4005_/X
+ sky130_fd_sc_hd__o221a_2
XFILLER_26_804 VGND VGND VPWR VPWR sky130_fd_sc_hd__fill_2
XFILLER_37_130 VGND VGND VPWR VPWR sky130_fd_sc_hd__decap_3
XFILLER_53_612 VGND VGND VPWR VPWR sky130_fd_sc_hd__decap_3
XFILLER_0_1310 VGND VGND VPWR VPWR sky130_fd_sc_hd__decap_3
XTAP_TAPCELL_ROW_68_1958 VGND VPWR sky130_fd_sc_hd__tapvpwrvgnd_1
XFILLER_0_1332 VGND VGND VPWR VPWR sky130_fd_sc_hd__decap_3
XTAP_TAPCELL_ROW_68_1969 VGND VPWR sky130_fd_sc_hd__tapvpwrvgnd_1
XFILLER_20_1282 VGND VGND VPWR VPWR sky130_fd_sc_hd__decap_3
XFILLER_52_133 VGND VGND VPWR VPWR sky130_fd_sc_hd__decap_3
XFILLER_0_1354 VGND VGND VPWR VPWR sky130_fd_sc_hd__decap_3
XFILLER_41_807 VGND VGND VPWR VPWR sky130_fd_sc_hd__decap_3
XFILLER_52_144 VGND VGND VPWR VPWR sky130_fd_sc_hd__decap_3
XFILLER_55_1301 VGND VGND VPWR VPWR sky130_fd_sc_hd__decap_3
XFILLER_0_1376 VGND VGND VPWR VPWR sky130_fd_sc_hd__decap_3
X_5956_ _5956_/A0 _5956_/A1 _6049_/S VGND VGND VPWR VPWR _6960_/D sky130_fd_sc_hd__mux2_1
XFILLER_80_475 VGND VGND VPWR VPWR sky130_fd_sc_hd__fill_1
XFILLER_34_881 VGND VGND VPWR VPWR sky130_fd_sc_hd__decap_3
XFILLER_80_497 VGND VGND VPWR VPWR sky130_fd_sc_hd__decap_3
XFILLER_55_1334 VGND VGND VPWR VPWR sky130_fd_sc_hd__decap_3
X_4907_ _6682_/Q _3048_/Y _5216_/A VGND VGND VPWR VPWR _4907_/X sky130_fd_sc_hd__mux2_1
XFILLER_55_1345 VGND VGND VPWR VPWR sky130_fd_sc_hd__decap_3
X_5887_ _5923_/A1 _5887_/A1 _5887_/S VGND VGND VPWR VPWR _6897_/D sky130_fd_sc_hd__mux2_1
XFILLER_16_1329 VGND VGND VPWR VPWR sky130_fd_sc_hd__decap_3
XFILLER_55_1378 VGND VGND VPWR VPWR sky130_fd_sc_hd__decap_3
X_4838_ _4838_/A1 _4835_/X _4836_/Y _4837_/X _4896_/C1 VGND VGND VPWR VPWR _4838_/X
+ sky130_fd_sc_hd__o221a_2
XFILLER_21_597 VGND VGND VPWR VPWR sky130_fd_sc_hd__decap_3
XFILLER_53_1091 VGND VGND VPWR VPWR sky130_fd_sc_hd__decap_3
X_4769_ _6574_/Q _4723_/X _4769_/B1 VGND VGND VPWR VPWR _4769_/X sky130_fd_sc_hd__a21o_2
XFILLER_14_1064 VGND VGND VPWR VPWR sky130_fd_sc_hd__decap_3
X_6508_ _7009_/CLK _6508_/D load_slew767/X VGND VGND VPWR VPWR _6508_/Q sky130_fd_sc_hd__dfrtp_2
XFILLER_20_12 VGND VGND VPWR VPWR sky130_fd_sc_hd__decap_3
X_6439_ _7065_/CLK _6439_/D load_slew736/X VGND VGND VPWR VPWR _6439_/Q sky130_fd_sc_hd__dfrtp_2
XFILLER_1_903 VGND VGND VPWR VPWR sky130_fd_sc_hd__decap_3
XFILLER_49_1149 VGND VGND VPWR VPWR sky130_fd_sc_hd__decap_3
XFILLER_66_1441 VGND VGND VPWR VPWR sky130_fd_sc_hd__decap_3
XFILLER_0_402 VGND VGND VPWR VPWR sky130_fd_sc_hd__decap_3
XFILLER_1_936 VGND VGND VPWR VPWR sky130_fd_sc_hd__decap_3
XFILLER_0_424 VGND VGND VPWR VPWR sky130_fd_sc_hd__decap_3
XFILLER_27_1425 VGND VGND VPWR VPWR sky130_fd_sc_hd__decap_3
XFILLER_49_907 VGND VGND VPWR VPWR sky130_fd_sc_hd__decap_3
XFILLER_76_704 VGND VGND VPWR VPWR sky130_fd_sc_hd__fill_1
XFILLER_62_1338 VGND VGND VPWR VPWR sky130_fd_sc_hd__decap_3
XFILLER_48_417 VGND VGND VPWR VPWR sky130_fd_sc_hd__decap_3
XFILLER_5_1210 VGND VGND VPWR VPWR sky130_fd_sc_hd__decap_3
XFILLER_76_748 VGND VGND VPWR VPWR sky130_fd_sc_hd__decap_3
XFILLER_9_1390 VGND VGND VPWR VPWR sky130_fd_sc_hd__decap_3
XFILLER_29_620 VGND VGND VPWR VPWR sky130_fd_sc_hd__decap_3
XFILLER_60_1040 VGND VGND VPWR VPWR sky130_fd_sc_hd__decap_3
XFILLER_29_98 VGND VGND VPWR VPWR sky130_fd_sc_hd__fill_1
XFILLER_5_1254 VGND VGND VPWR VPWR sky130_fd_sc_hd__decap_3
XFILLER_1_1107 VGND VGND VPWR VPWR sky130_fd_sc_hd__decap_3
XTAP_TAPCELL_ROW_3_273 VGND VPWR sky130_fd_sc_hd__tapvpwrvgnd_1
XFILLER_72_921 VGND VGND VPWR VPWR sky130_fd_sc_hd__decap_3
XFILLER_5_1287 VGND VGND VPWR VPWR sky130_fd_sc_hd__fill_1
XTAP_TAPCELL_ROW_3_284 VGND VPWR sky130_fd_sc_hd__tapvpwrvgnd_1
XFILLER_5_1298 VGND VGND VPWR VPWR sky130_fd_sc_hd__decap_3
XFILLER_17_837 VGND VGND VPWR VPWR sky130_fd_sc_hd__decap_3
XFILLER_72_954 VGND VGND VPWR VPWR sky130_fd_sc_hd__decap_3
XFILLER_71_431 VGND VGND VPWR VPWR sky130_fd_sc_hd__decap_3
XTAP_TAPCELL_ROW_80_2303 VGND VPWR sky130_fd_sc_hd__tapvpwrvgnd_1
XTAP_TAPCELL_ROW_80_2314 VGND VPWR sky130_fd_sc_hd__tapvpwrvgnd_1
XFILLER_72_976 VGND VGND VPWR VPWR sky130_fd_sc_hd__decap_3
XFILLER_44_667 VGND VGND VPWR VPWR sky130_fd_sc_hd__decap_3
XFILLER_45_75 VGND VGND VPWR VPWR sky130_fd_sc_hd__decap_3
XFILLER_73_1401 VGND VGND VPWR VPWR sky130_fd_sc_hd__decap_3
XFILLER_73_1434 VGND VGND VPWR VPWR sky130_fd_sc_hd__decap_3
XTAP_TAPCELL_ROW_27_898 VGND VPWR sky130_fd_sc_hd__tapvpwrvgnd_1
XFILLER_31_328 VGND VGND VPWR VPWR sky130_fd_sc_hd__decap_3
XFILLER_24_380 VGND VGND VPWR VPWR sky130_fd_sc_hd__decap_3
XFILLER_43_199 VGND VGND VPWR VPWR sky130_fd_sc_hd__decap_3
XFILLER_24_391 VGND VGND VPWR VPWR sky130_fd_sc_hd__decap_3
XFILLER_34_1418 VGND VGND VPWR VPWR sky130_fd_sc_hd__decap_3
XTAP_TAPCELL_ROW_14_559 VGND VPWR sky130_fd_sc_hd__tapvpwrvgnd_1
XFILLER_34_1429 VGND VGND VPWR VPWR sky130_fd_sc_hd__decap_3
XFILLER_8_513 VGND VGND VPWR VPWR sky130_fd_sc_hd__decap_3
XTAP_TAPCELL_ROW_78_2221 VGND VPWR sky130_fd_sc_hd__tapvpwrvgnd_1
XTAP_TAPCELL_ROW_78_2232 VGND VPWR sky130_fd_sc_hd__tapvpwrvgnd_1
XFILLER_71_1180 VGND VGND VPWR VPWR sky130_fd_sc_hd__decap_3
XFILLER_8_557 VGND VGND VPWR VPWR sky130_fd_sc_hd__decap_3
XTAP_TAPCELL_ROW_74_2118 VGND VPWR sky130_fd_sc_hd__tapvpwrvgnd_1
XTAP_TAPCELL_ROW_74_2129 VGND VPWR sky130_fd_sc_hd__tapvpwrvgnd_1
XANTENNA_7 _3202_/A VGND VGND VPWR VPWR sky130_fd_sc_hd__diode_2
XFILLER_6_58 VGND VGND VPWR VPWR sky130_fd_sc_hd__decap_3
XFILLER_4_730 VGND VGND VPWR VPWR sky130_fd_sc_hd__decap_3
XFILLER_67_1216 VGND VGND VPWR VPWR sky130_fd_sc_hd__decap_3
XFILLER_10_1462 VGND VGND VPWR VPWR sky130_fd_sc_hd__decap_3
XFILLER_79_520 VGND VGND VPWR VPWR sky130_fd_sc_hd__decap_3
XFILLER_3_284 VGND VGND VPWR VPWR sky130_fd_sc_hd__decap_3
XFILLER_80_1416 VGND VGND VPWR VPWR sky130_fd_sc_hd__decap_3
XFILLER_80_1438 VGND VGND VPWR VPWR sky130_fd_sc_hd__decap_3
XFILLER_20_6 VGND VGND VPWR VPWR sky130_fd_sc_hd__decap_3
XFILLER_39_428 VGND VGND VPWR VPWR sky130_fd_sc_hd__fill_1
XFILLER_66_203 VGND VGND VPWR VPWR sky130_fd_sc_hd__decap_3
XFILLER_67_737 VGND VGND VPWR VPWR sky130_fd_sc_hd__decap_3
XFILLER_79_597 VGND VGND VPWR VPWR sky130_fd_sc_hd__decap_3
XFILLER_43_1260 VGND VGND VPWR VPWR sky130_fd_sc_hd__decap_3
XFILLER_66_247 VGND VGND VPWR VPWR sky130_fd_sc_hd__decap_3
XFILLER_78_1312 VGND VGND VPWR VPWR sky130_fd_sc_hd__decap_3
XFILLER_48_984 VGND VGND VPWR VPWR sky130_fd_sc_hd__decap_3
XTAP_TAPCELL_ROW_50_1494 VGND VPWR sky130_fd_sc_hd__tapvpwrvgnd_1
XFILLER_78_1323 VGND VGND VPWR VPWR sky130_fd_sc_hd__decap_3
XFILLER_78_1356 VGND VGND VPWR VPWR sky130_fd_sc_hd__decap_3
XFILLER_39_1307 VGND VGND VPWR VPWR sky130_fd_sc_hd__decap_3
XFILLER_34_133 VGND VGND VPWR VPWR sky130_fd_sc_hd__decap_3
X_5810_ _5795_/C _5810_/A1 _5813_/S VGND VGND VPWR VPWR _6830_/D sky130_fd_sc_hd__mux2_1
XFILLER_34_144 VGND VGND VPWR VPWR sky130_fd_sc_hd__decap_3
XFILLER_35_667 VGND VGND VPWR VPWR sky130_fd_sc_hd__decap_3
X_6790_ _7046_/CLK _6790_/D fanout745/X VGND VGND VPWR VPWR _6790_/Q sky130_fd_sc_hd__dfrtp_2
XFILLER_37_1020 VGND VGND VPWR VPWR sky130_fd_sc_hd__fill_2
XFILLER_37_1031 VGND VGND VPWR VPWR sky130_fd_sc_hd__decap_3
XFILLER_50_637 VGND VGND VPWR VPWR sky130_fd_sc_hd__decap_3
XTAP_TAPCELL_ROW_63_1833 VGND VPWR sky130_fd_sc_hd__tapvpwrvgnd_1
XFILLER_22_339 VGND VGND VPWR VPWR sky130_fd_sc_hd__fill_2
X_5741_ _5907_/A0 _5741_/A1 _5747_/S VGND VGND VPWR VPWR _6786_/D sky130_fd_sc_hd__mux2_1
XFILLER_50_648 VGND VGND VPWR VPWR sky130_fd_sc_hd__decap_3
XTAP_TAPCELL_ROW_63_1844 VGND VPWR sky130_fd_sc_hd__tapvpwrvgnd_1
XFILLER_76_1091 VGND VGND VPWR VPWR sky130_fd_sc_hd__fill_1
XFILLER_15_391 VGND VGND VPWR VPWR sky130_fd_sc_hd__fill_1
X_5672_ hold914/X _5911_/A0 _5675_/S VGND VGND VPWR VPWR _6726_/D sky130_fd_sc_hd__mux2_1
XFILLER_15_1340 VGND VGND VPWR VPWR sky130_fd_sc_hd__decap_3
XFILLER_15_1351 VGND VGND VPWR VPWR sky130_fd_sc_hd__decap_3
X_4623_ _5605_/A3 _6546_/Q _4658_/S VGND VGND VPWR VPWR _4623_/X sky130_fd_sc_hd__mux2_1
XFILLER_11_1204 VGND VGND VPWR VPWR sky130_fd_sc_hd__decap_3
XFILLER_15_1384 VGND VGND VPWR VPWR sky130_fd_sc_hd__decap_3
XFILLER_50_1264 VGND VGND VPWR VPWR sky130_fd_sc_hd__decap_3
X_4554_ _6296_/Q wire54/X _4551_/X _4553_/X VGND VGND VPWR VPWR _6296_/D sky130_fd_sc_hd__o22a_2
XFILLER_11_1248 VGND VGND VPWR VPWR sky130_fd_sc_hd__decap_3
XFILLER_50_1297 VGND VGND VPWR VPWR sky130_fd_sc_hd__decap_3
XFILLER_7_590 VGND VGND VPWR VPWR sky130_fd_sc_hd__decap_3
X_3505_ _3503_/X _3504_/X _4355_/A VGND VGND VPWR VPWR _3505_/X sky130_fd_sc_hd__mux2_1
X_4485_ _6857_/Q _4898_/A2 _4483_/X _4484_/X VGND VGND VPWR VPWR _4485_/X sky130_fd_sc_hd__a211o_2
X_6224_ _7037_/CLK _6224_/D fanout693/X VGND VGND VPWR VPWR _6224_/Q sky130_fd_sc_hd__dfrtp_2
X_3436_ _6329_/Q _6449_/Q VGND VGND VPWR VPWR _3436_/X sky130_fd_sc_hd__xor2_2
XFILLER_44_1002 VGND VGND VPWR VPWR sky130_fd_sc_hd__decap_3
X_6155_ _6974_/CLK _6155_/D load_slew773/X VGND VGND VPWR VPWR _6155_/Q sky130_fd_sc_hd__dfrtp_2
XFILLER_44_1035 VGND VGND VPWR VPWR sky130_fd_sc_hd__fill_1
X_3367_ hold961/X _3366_/X _3463_/S VGND VGND VPWR VPWR _6157_/D sky130_fd_sc_hd__mux2_1
XFILLER_44_1046 VGND VGND VPWR VPWR sky130_fd_sc_hd__fill_1
Xhold1202 _6154_/Q VGND VGND VPWR VPWR _6001_/A0 sky130_fd_sc_hd__dlygate4sd3_1
X_5106_ _5350_/S _5107_/B _5284_/A2 VGND VGND VPWR VPWR _5106_/X sky130_fd_sc_hd__a21o_2
Xhold1213 _6700_/Q VGND VGND VPWR VPWR _5643_/A1 sky130_fd_sc_hd__dlygate4sd3_1
XFILLER_57_225 VGND VGND VPWR VPWR sky130_fd_sc_hd__decap_3
X_6086_ _6062_/X _6085_/X _5993_/S VGND VGND VPWR VPWR _7080_/D sky130_fd_sc_hd__a21bo_2
XFILLER_22_1300 VGND VGND VPWR VPWR sky130_fd_sc_hd__decap_3
XFILLER_44_1079 VGND VGND VPWR VPWR sky130_fd_sc_hd__decap_3
Xload_slew482 _4741_/C1 VGND VGND VPWR VPWR _4763_/C1 sky130_fd_sc_hd__buf_2
Xhold1224 _6838_/Q VGND VGND VPWR VPWR _5819_/A0 sky130_fd_sc_hd__dlygate4sd3_1
X_3298_ _6276_/Q _6380_/Q VGND VGND VPWR VPWR _3298_/X sky130_fd_sc_hd__xor2_2
Xhold1235 _6879_/Q VGND VGND VPWR VPWR _5865_/A0 sky130_fd_sc_hd__dlygate4sd3_1
XFILLER_61_1360 VGND VGND VPWR VPWR sky130_fd_sc_hd__decap_3
XFILLER_79_1109 VGND VGND VPWR VPWR sky130_fd_sc_hd__decap_3
Xhold1246 _6858_/Q VGND VGND VPWR VPWR _5842_/A0 sky130_fd_sc_hd__dlygate4sd3_1
XFILLER_39_951 VGND VGND VPWR VPWR sky130_fd_sc_hd__fill_1
Xhold1257 _6704_/Q VGND VGND VPWR VPWR _5647_/A1 sky130_fd_sc_hd__dlygate4sd3_1
X_5037_ _6395_/Q _5255_/B VGND VGND VPWR VPWR _5037_/X sky130_fd_sc_hd__or2_2
XFILLER_22_1344 VGND VGND VPWR VPWR sky130_fd_sc_hd__decap_3
XFILLER_61_1393 VGND VGND VPWR VPWR sky130_fd_sc_hd__decap_3
Xhold1268 _6902_/Q VGND VGND VPWR VPWR _5893_/A1 sky130_fd_sc_hd__dlygate4sd3_1
XFILLER_73_729 VGND VGND VPWR VPWR sky130_fd_sc_hd__decap_3
Xhold1279 _6702_/Q VGND VGND VPWR VPWR _5645_/A1 sky130_fd_sc_hd__dlygate4sd3_1
XFILLER_2_1427 VGND VGND VPWR VPWR sky130_fd_sc_hd__fill_1
XTAP_TAPCELL_ROW_0_210 VGND VPWR sky130_fd_sc_hd__tapvpwrvgnd_1
XFILLER_2_1438 VGND VGND VPWR VPWR sky130_fd_sc_hd__decap_3
XFILLER_38_483 VGND VGND VPWR VPWR sky130_fd_sc_hd__fill_1
XFILLER_22_1388 VGND VGND VPWR VPWR sky130_fd_sc_hd__decap_3
XFILLER_25_111 VGND VGND VPWR VPWR sky130_fd_sc_hd__fill_1
XFILLER_53_420 VGND VGND VPWR VPWR sky130_fd_sc_hd__decap_3
XFILLER_26_645 VGND VGND VPWR VPWR sky130_fd_sc_hd__decap_3
XFILLER_57_1407 VGND VGND VPWR VPWR sky130_fd_sc_hd__decap_3
XFILLER_14_807 VGND VGND VPWR VPWR sky130_fd_sc_hd__decap_3
XFILLER_15_12 VGND VGND VPWR VPWR sky130_fd_sc_hd__decap_3
XFILLER_53_475 VGND VGND VPWR VPWR sky130_fd_sc_hd__decap_3
XFILLER_0_1173 VGND VGND VPWR VPWR sky130_fd_sc_hd__decap_3
XTAP_TAPCELL_ROW_24_813 VGND VPWR sky130_fd_sc_hd__tapvpwrvgnd_1
X_6988_ _6988_/CLK _6988_/D load_slew813/X VGND VGND VPWR VPWR _6988_/Q sky130_fd_sc_hd__dfrtp_2
XFILLER_13_328 VGND VGND VPWR VPWR sky130_fd_sc_hd__decap_3
XTAP_TAPCELL_ROW_24_824 VGND VPWR sky130_fd_sc_hd__tapvpwrvgnd_1
XFILLER_0_1195 VGND VGND VPWR VPWR sky130_fd_sc_hd__decap_3
XTAP_TAPCELL_ROW_24_835 VGND VPWR sky130_fd_sc_hd__tapvpwrvgnd_1
XFILLER_40_136 VGND VGND VPWR VPWR sky130_fd_sc_hd__decap_3
X_5939_ hold951/X _5939_/A1 _6035_/S VGND VGND VPWR VPWR _6943_/D sky130_fd_sc_hd__mux2_1
XFILLER_22_851 VGND VGND VPWR VPWR sky130_fd_sc_hd__decap_3
XFILLER_55_1153 VGND VGND VPWR VPWR sky130_fd_sc_hd__fill_1
XFILLER_16_1126 VGND VGND VPWR VPWR sky130_fd_sc_hd__decap_3
XFILLER_22_862 VGND VGND VPWR VPWR sky130_fd_sc_hd__decap_3
XFILLER_55_1175 VGND VGND VPWR VPWR sky130_fd_sc_hd__fill_1
XFILLER_33_1440 VGND VGND VPWR VPWR sky130_fd_sc_hd__decap_3
XFILLER_5_505 VGND VGND VPWR VPWR sky130_fd_sc_hd__decap_3
XFILLER_5_538 VGND VGND VPWR VPWR sky130_fd_sc_hd__decap_3
XFILLER_1_700 VGND VGND VPWR VPWR sky130_fd_sc_hd__decap_3
XFILLER_0_221 VGND VGND VPWR VPWR sky130_fd_sc_hd__decap_3
XFILLER_1_744 VGND VGND VPWR VPWR sky130_fd_sc_hd__decap_3
XFILLER_27_1233 VGND VGND VPWR VPWR sky130_fd_sc_hd__decap_3
XFILLER_66_1282 VGND VGND VPWR VPWR sky130_fd_sc_hd__decap_3
XFILLER_62_1124 VGND VGND VPWR VPWR sky130_fd_sc_hd__decap_3
XFILLER_7_1316 VGND VGND VPWR VPWR sky130_fd_sc_hd__decap_3
XFILLER_0_243 VGND VGND VPWR VPWR sky130_fd_sc_hd__decap_3
XFILLER_1_777 VGND VGND VPWR VPWR sky130_fd_sc_hd__decap_3
XFILLER_49_715 VGND VGND VPWR VPWR sky130_fd_sc_hd__decap_3
XTAP_TAPCELL_ROW_8_398 VGND VPWR sky130_fd_sc_hd__tapvpwrvgnd_1
XFILLER_0_265 VGND VGND VPWR VPWR sky130_fd_sc_hd__decap_3
XFILLER_1_788 VGND VGND VPWR VPWR sky130_fd_sc_hd__decap_3
XFILLER_27_1266 VGND VGND VPWR VPWR sky130_fd_sc_hd__decap_3
XFILLER_48_203 VGND VGND VPWR VPWR sky130_fd_sc_hd__fill_1
XFILLER_76_523 VGND VGND VPWR VPWR sky130_fd_sc_hd__decap_3
XFILLER_0_287 VGND VGND VPWR VPWR sky130_fd_sc_hd__decap_3
XFILLER_40_1400 VGND VGND VPWR VPWR sky130_fd_sc_hd__decap_3
XFILLER_49_759 VGND VGND VPWR VPWR sky130_fd_sc_hd__decap_3
XFILLER_76_556 VGND VGND VPWR VPWR sky130_fd_sc_hd__decap_3
XFILLER_5_1040 VGND VGND VPWR VPWR sky130_fd_sc_hd__decap_3
XFILLER_56_41 VGND VGND VPWR VPWR sky130_fd_sc_hd__decap_3
XFILLER_40_1444 VGND VGND VPWR VPWR sky130_fd_sc_hd__decap_3
XFILLER_76_589 VGND VGND VPWR VPWR sky130_fd_sc_hd__decap_3
XFILLER_17_601 VGND VGND VPWR VPWR sky130_fd_sc_hd__decap_3
XFILLER_29_461 VGND VGND VPWR VPWR sky130_fd_sc_hd__decap_3
XFILLER_57_770 VGND VGND VPWR VPWR sky130_fd_sc_hd__decap_3
XFILLER_5_1095 VGND VGND VPWR VPWR sky130_fd_sc_hd__decap_3
XFILLER_29_483 VGND VGND VPWR VPWR sky130_fd_sc_hd__decap_3
XFILLER_32_604 VGND VGND VPWR VPWR sky130_fd_sc_hd__fill_2
XFILLER_32_637 VGND VGND VPWR VPWR sky130_fd_sc_hd__decap_3
XFILLER_73_1231 VGND VGND VPWR VPWR sky130_fd_sc_hd__fill_1
XFILLER_72_62 VGND VGND VPWR VPWR sky130_fd_sc_hd__decap_3
XFILLER_73_1242 VGND VGND VPWR VPWR sky130_fd_sc_hd__decap_3
XFILLER_38_1362 VGND VGND VPWR VPWR sky130_fd_sc_hd__decap_3
XFILLER_38_1373 VGND VGND VPWR VPWR sky130_fd_sc_hd__decap_3
XFILLER_73_1275 VGND VGND VPWR VPWR sky130_fd_sc_hd__decap_3
XFILLER_31_169 VGND VGND VPWR VPWR sky130_fd_sc_hd__decap_3
XFILLER_12_361 VGND VGND VPWR VPWR sky130_fd_sc_hd__decap_3
XFILLER_34_1248 VGND VGND VPWR VPWR sky130_fd_sc_hd__decap_3
XFILLER_9_844 VGND VGND VPWR VPWR sky130_fd_sc_hd__decap_3
XFILLER_9_877 VGND VGND VPWR VPWR sky130_fd_sc_hd__decap_3
XFILLER_8_365 VGND VGND VPWR VPWR sky130_fd_sc_hd__fill_1
XFILLER_68_6 VGND VGND VPWR VPWR sky130_fd_sc_hd__decap_3
XFILLER_8_398 VGND VGND VPWR VPWR sky130_fd_sc_hd__decap_3
XFILLER_4_560 VGND VGND VPWR VPWR sky130_fd_sc_hd__decap_3
XFILLER_10_1270 VGND VGND VPWR VPWR sky130_fd_sc_hd__decap_3
XFILLER_28_1008 VGND VGND VPWR VPWR sky130_fd_sc_hd__fill_1
XFILLER_67_1057 VGND VGND VPWR VPWR sky130_fd_sc_hd__decap_3
X_4270_ _4270_/A _4270_/B VGND VGND VPWR VPWR _4271_/B sky130_fd_sc_hd__xnor2_2
XFILLER_45_1322 VGND VGND VPWR VPWR sky130_fd_sc_hd__decap_3
X_3221_ _6953_/Q _6961_/Q _3222_/A VGND VGND VPWR VPWR _3221_/X sky130_fd_sc_hd__mux2_1
XTAP_TAPCELL_ROW_52_1545 VGND VPWR sky130_fd_sc_hd__tapvpwrvgnd_1
XFILLER_45_1366 VGND VGND VPWR VPWR sky130_fd_sc_hd__decap_3
XTAP_TAPCELL_ROW_52_1556 VGND VPWR sky130_fd_sc_hd__tapvpwrvgnd_1
XFILLER_80_1257 VGND VGND VPWR VPWR sky130_fd_sc_hd__decap_3
XFILLER_39_225 VGND VGND VPWR VPWR sky130_fd_sc_hd__decap_3
X_3152_ _3217_/A _3148_/X _3151_/X _3145_/X VGND VGND VPWR VPWR _3152_/X sky130_fd_sc_hd__a31o_2
XFILLER_80_1279 VGND VGND VPWR VPWR sky130_fd_sc_hd__decap_3
XFILLER_45_1399 VGND VGND VPWR VPWR sky130_fd_sc_hd__fill_1
XFILLER_67_567 VGND VGND VPWR VPWR sky130_fd_sc_hd__decap_3
XFILLER_36_910 VGND VGND VPWR VPWR sky130_fd_sc_hd__decap_3
XFILLER_54_206 VGND VGND VPWR VPWR sky130_fd_sc_hd__fill_1
X_3083_ _4386_/A _4420_/B VGND VGND VPWR VPWR _3957_/B sky130_fd_sc_hd__nand2_2
XFILLER_78_1120 VGND VGND VPWR VPWR sky130_fd_sc_hd__decap_3
XFILLER_54_228 VGND VGND VPWR VPWR sky130_fd_sc_hd__decap_3
X_6911_ _6943_/CLK _6911_/D load_slew819/X VGND VGND VPWR VPWR _6911_/Q sky130_fd_sc_hd__dfrtp_2
XFILLER_36_954 VGND VGND VPWR VPWR sky130_fd_sc_hd__decap_3
XFILLER_35_431 VGND VGND VPWR VPWR sky130_fd_sc_hd__decap_3
XFILLER_78_1164 VGND VGND VPWR VPWR sky130_fd_sc_hd__decap_3
XFILLER_1_1460 VGND VGND VPWR VPWR sky130_fd_sc_hd__decap_3
XFILLER_74_1017 VGND VGND VPWR VPWR sky130_fd_sc_hd__decap_3
XTAP_TAPCELL_ROW_18_662 VGND VPWR sky130_fd_sc_hd__tapvpwrvgnd_1
XFILLER_36_998 VGND VGND VPWR VPWR sky130_fd_sc_hd__decap_3
X_6842_ _7073_/CLK _6842_/D load_slew684/X VGND VGND VPWR VPWR _6842_/Q sky130_fd_sc_hd__dfrtp_2
XFILLER_51_924 VGND VGND VPWR VPWR sky130_fd_sc_hd__decap_3
XFILLER_78_1197 VGND VGND VPWR VPWR sky130_fd_sc_hd__decap_3
XFILLER_23_626 VGND VGND VPWR VPWR sky130_fd_sc_hd__decap_3
XTAP_TAPCELL_ROW_18_673 VGND VPWR sky130_fd_sc_hd__tapvpwrvgnd_1
X_6773_ _7092_/CLK _6773_/D load_slew690/X VGND VGND VPWR VPWR _6773_/Q sky130_fd_sc_hd__dfrtp_2
XFILLER_17_1413 VGND VGND VPWR VPWR sky130_fd_sc_hd__decap_3
XFILLER_56_1462 VGND VGND VPWR VPWR sky130_fd_sc_hd__decap_3
X_3985_ _4083_/B _4396_/A VGND VGND VPWR VPWR _3985_/Y sky130_fd_sc_hd__nor2_2
XFILLER_52_1315 VGND VGND VPWR VPWR sky130_fd_sc_hd__fill_1
X_5724_ _5899_/A0 _5724_/A1 _5730_/S VGND VGND VPWR VPWR _6771_/D sky130_fd_sc_hd__mux2_1
XFILLER_10_309 VGND VGND VPWR VPWR sky130_fd_sc_hd__decap_3
XFILLER_22_169 VGND VGND VPWR VPWR sky130_fd_sc_hd__decap_3
XFILLER_17_1446 VGND VGND VPWR VPWR sky130_fd_sc_hd__decap_3
XFILLER_52_1326 VGND VGND VPWR VPWR sky130_fd_sc_hd__decap_3
XFILLER_17_1457 VGND VGND VPWR VPWR sky130_fd_sc_hd__decap_3
XFILLER_52_1359 VGND VGND VPWR VPWR sky130_fd_sc_hd__decap_3
X_5655_ hold984/X _5664_/A0 _5657_/S VGND VGND VPWR VPWR _6711_/D sky130_fd_sc_hd__mux2_1
XFILLER_30_191 VGND VGND VPWR VPWR sky130_fd_sc_hd__decap_3
XFILLER_50_1050 VGND VGND VPWR VPWR sky130_fd_sc_hd__fill_1
XFILLER_11_1012 VGND VGND VPWR VPWR sky130_fd_sc_hd__decap_3
X_4606_ _6881_/Q _4781_/A2 _4606_/B1 _4605_/X VGND VGND VPWR VPWR _4606_/X sky130_fd_sc_hd__a211o_2
X_5586_ _5589_/A2 _5572_/Y _5584_/Y _5586_/B2 VGND VGND VPWR VPWR _6659_/D sky130_fd_sc_hd__a22o_2
XFILLER_7_90 VGND VGND VPWR VPWR sky130_fd_sc_hd__fill_2
X_4537_ _6270_/Q _4832_/A2 _3334_/X _4713_/B2 VGND VGND VPWR VPWR _4537_/X sky130_fd_sc_hd__a22o_2
XFILLER_11_1078 VGND VGND VPWR VPWR sky130_fd_sc_hd__decap_3
XPHY_EDGE_ROW_15_Left_96 VGND VGND VPWR VPWR sky130_fd_sc_hd__decap_3
X_4468_ _6517_/Q _4526_/B _4859_/C1 VGND VGND VPWR VPWR _4468_/X sky130_fd_sc_hd__a21bo_2
XFILLER_77_18 VGND VGND VPWR VPWR sky130_fd_sc_hd__decap_3
X_6207_ _7095_/CLK _6207_/D load_slew690/X VGND VGND VPWR VPWR _6207_/Q sky130_fd_sc_hd__dfrtp_2
Xfanout812 fanout816/X VGND VGND VPWR VPWR fanout812/X sky130_fd_sc_hd__clkdlybuf4s25_1
XFILLER_63_1422 VGND VGND VPWR VPWR sky130_fd_sc_hd__decap_3
X_3419_ hold907/X _3418_/X _3425_/S VGND VGND VPWR VPWR _6183_/D sky130_fd_sc_hd__mux2_1
Xfanout823 fanout847/X VGND VGND VPWR VPWR fanout823/X sky130_fd_sc_hd__clkdlybuf4s25_1
XFILLER_24_1406 VGND VGND VPWR VPWR sky130_fd_sc_hd__decap_3
X_4399_ _6300_/Q wire515/A _3298_/X _4583_/B2 VGND VGND VPWR VPWR _4399_/X sky130_fd_sc_hd__a22o_2
XFILLER_63_1455 VGND VGND VPWR VPWR sky130_fd_sc_hd__fill_1
XTAP_TAPCELL_ROW_5_324 VGND VPWR sky130_fd_sc_hd__tapvpwrvgnd_1
XTAP_TAPCELL_ROW_5_335 VGND VPWR sky130_fd_sc_hd__tapvpwrvgnd_1
XFILLER_63_1466 VGND VGND VPWR VPWR sky130_fd_sc_hd__decap_3
X_6138_ clkload8/A _6138_/D load_slew637/X VGND VGND VPWR VPWR _6138_/Q sky130_fd_sc_hd__dfrtp_2
Xhold1010 _6147_/Q VGND VGND VPWR VPWR _5994_/A0 sky130_fd_sc_hd__dlygate4sd3_1
Xhold1021 _6043_/X VGND VGND VPWR VPWR _7047_/D sky130_fd_sc_hd__dlygate4sd3_1
Xload_slew290 _4263_/A2 VGND VGND VPWR VPWR _4898_/A2 sky130_fd_sc_hd__clkbuf_4
XFILLER_46_707 VGND VGND VPWR VPWR sky130_fd_sc_hd__decap_3
Xhold1032 _5958_/X VGND VGND VPWR VPWR _6962_/D sky130_fd_sc_hd__dlygate4sd3_1
XFILLER_18_409 VGND VGND VPWR VPWR sky130_fd_sc_hd__decap_3
Xhold1043 _7012_/Q VGND VGND VPWR VPWR _6008_/A1 sky130_fd_sc_hd__dlygate4sd3_1
XFILLER_6_1371 VGND VGND VPWR VPWR sky130_fd_sc_hd__fill_1
Xhold1054 _7044_/Q VGND VGND VPWR VPWR _6040_/A1 sky130_fd_sc_hd__dlygate4sd3_1
X_6069_ _5868_/A _6068_/X _6069_/S VGND VGND VPWR VPWR _7070_/D sky130_fd_sc_hd__mux2_1
XFILLER_27_910 VGND VGND VPWR VPWR sky130_fd_sc_hd__fill_1
Xhold1065 _6108_/Q VGND VGND VPWR VPWR _5955_/A0 sky130_fd_sc_hd__dlygate4sd3_1
XFILLER_6_1382 VGND VGND VPWR VPWR sky130_fd_sc_hd__decap_3
XFILLER_27_921 VGND VGND VPWR VPWR sky130_fd_sc_hd__fill_2
XFILLER_45_217 VGND VGND VPWR VPWR sky130_fd_sc_hd__decap_3
Xhold1076 _6000_/X VGND VGND VPWR VPWR _7004_/D sky130_fd_sc_hd__dlygate4sd3_1
XFILLER_2_1235 VGND VGND VPWR VPWR sky130_fd_sc_hd__decap_3
XTAP_TAPCELL_ROW_29_949 VGND VPWR sky130_fd_sc_hd__tapvpwrvgnd_1
Xhold1087 _7043_/Q VGND VGND VPWR VPWR _6039_/A1 sky130_fd_sc_hd__dlygate4sd3_1
XFILLER_45_239 VGND VGND VPWR VPWR sky130_fd_sc_hd__fill_2
Xhold1098 _7014_/Q VGND VGND VPWR VPWR _6010_/A1 sky130_fd_sc_hd__dlygate4sd3_1
XFILLER_26_442 VGND VGND VPWR VPWR sky130_fd_sc_hd__decap_3
XFILLER_42_902 VGND VGND VPWR VPWR sky130_fd_sc_hd__decap_3
XFILLER_2_1279 VGND VGND VPWR VPWR sky130_fd_sc_hd__decap_3
XFILLER_57_1226 VGND VGND VPWR VPWR sky130_fd_sc_hd__decap_3
XFILLER_42_935 VGND VGND VPWR VPWR sky130_fd_sc_hd__fill_2
XFILLER_57_1248 VGND VGND VPWR VPWR sky130_fd_sc_hd__decap_3
XFILLER_26_497 VGND VGND VPWR VPWR sky130_fd_sc_hd__decap_3
XFILLER_14_648 VGND VGND VPWR VPWR sky130_fd_sc_hd__decap_3
XFILLER_41_445 VGND VGND VPWR VPWR sky130_fd_sc_hd__decap_3
XFILLER_41_467 VGND VGND VPWR VPWR sky130_fd_sc_hd__decap_3
XFILLER_70_1415 VGND VGND VPWR VPWR sky130_fd_sc_hd__decap_3
XFILLER_50_990 VGND VGND VPWR VPWR sky130_fd_sc_hd__decap_3
XFILLER_70_1459 VGND VGND VPWR VPWR sky130_fd_sc_hd__decap_3
XFILLER_10_865 VGND VGND VPWR VPWR sky130_fd_sc_hd__decap_3
XFILLER_33_1281 VGND VGND VPWR VPWR sky130_fd_sc_hd__decap_3
XFILLER_33_1292 VGND VGND VPWR VPWR sky130_fd_sc_hd__decap_3
XFILLER_68_1300 VGND VGND VPWR VPWR sky130_fd_sc_hd__decap_3
XFILLER_68_1344 VGND VGND VPWR VPWR sky130_fd_sc_hd__decap_3
XFILLER_29_1328 VGND VGND VPWR VPWR sky130_fd_sc_hd__decap_3
XFILLER_64_1208 VGND VGND VPWR VPWR sky130_fd_sc_hd__decap_3
XFILLER_68_1388 VGND VGND VPWR VPWR sky130_fd_sc_hd__decap_3
XFILLER_3_15 VGND VGND VPWR VPWR sky130_fd_sc_hd__decap_3
XFILLER_68_309 VGND VGND VPWR VPWR sky130_fd_sc_hd__fill_1
XFILLER_3_48 VGND VGND VPWR VPWR sky130_fd_sc_hd__decap_3
XFILLER_7_1113 VGND VGND VPWR VPWR sky130_fd_sc_hd__decap_3
XFILLER_7_1124 VGND VGND VPWR VPWR sky130_fd_sc_hd__decap_3
XFILLER_67_51 VGND VGND VPWR VPWR sky130_fd_sc_hd__decap_3
XTAP_TAPCELL_ROW_69_2006 VGND VPWR sky130_fd_sc_hd__tapvpwrvgnd_1
XFILLER_27_1074 VGND VGND VPWR VPWR sky130_fd_sc_hd__decap_3
XFILLER_7_1157 VGND VGND VPWR VPWR sky130_fd_sc_hd__decap_3
XFILLER_77_865 VGND VGND VPWR VPWR sky130_fd_sc_hd__decap_3
XFILLER_49_567 VGND VGND VPWR VPWR sky130_fd_sc_hd__fill_1
XFILLER_37_729 VGND VGND VPWR VPWR sky130_fd_sc_hd__fill_1
XFILLER_49_589 VGND VGND VPWR VPWR sky130_fd_sc_hd__decap_3
XFILLER_18_921 VGND VGND VPWR VPWR sky130_fd_sc_hd__decap_3
XFILLER_40_1252 VGND VGND VPWR VPWR sky130_fd_sc_hd__decap_3
XFILLER_79_1440 VGND VGND VPWR VPWR sky130_fd_sc_hd__decap_3
XFILLER_18_943 VGND VGND VPWR VPWR sky130_fd_sc_hd__decap_3
XFILLER_40_1285 VGND VGND VPWR VPWR sky130_fd_sc_hd__decap_3
XFILLER_75_1304 VGND VGND VPWR VPWR sky130_fd_sc_hd__decap_3
XFILLER_18_987 VGND VGND VPWR VPWR sky130_fd_sc_hd__decap_3
XFILLER_75_1337 VGND VGND VPWR VPWR sky130_fd_sc_hd__decap_3
XFILLER_75_1348 VGND VGND VPWR VPWR sky130_fd_sc_hd__decap_3
XFILLER_72_581 VGND VGND VPWR VPWR sky130_fd_sc_hd__decap_3
XFILLER_72_592 VGND VGND VPWR VPWR sky130_fd_sc_hd__fill_1
XFILLER_17_497 VGND VGND VPWR VPWR sky130_fd_sc_hd__decap_3
XFILLER_60_732 VGND VGND VPWR VPWR sky130_fd_sc_hd__decap_3
XFILLER_44_294 VGND VGND VPWR VPWR sky130_fd_sc_hd__decap_3
XTAP_TAPCELL_ROW_45_1360 VGND VPWR sky130_fd_sc_hd__tapvpwrvgnd_1
XFILLER_60_776 VGND VGND VPWR VPWR sky130_fd_sc_hd__decap_3
XFILLER_38_1181 VGND VGND VPWR VPWR sky130_fd_sc_hd__decap_3
XFILLER_32_489 VGND VGND VPWR VPWR sky130_fd_sc_hd__decap_3
X_3770_ _6329_/Q _3807_/A2 _3768_/X _3769_/X VGND VGND VPWR VPWR _4291_/A sky130_fd_sc_hd__o22a_2
XTAP_TAPCELL_ROW_45_1371 VGND VPWR sky130_fd_sc_hd__tapvpwrvgnd_1
XFILLER_13_670 VGND VGND VPWR VPWR sky130_fd_sc_hd__fill_2
XTAP_TAPCELL_ROW_45_1382 VGND VPWR sky130_fd_sc_hd__tapvpwrvgnd_1
Xclkbuf_4_8__f_clk clkbuf_3_4_0_clk/X VGND VGND VPWR VPWR clkbuf_4_8__f_clk/X sky130_fd_sc_hd__clkbuf_16
XFILLER_9_652 VGND VGND VPWR VPWR sky130_fd_sc_hd__decap_3
XFILLER_34_1067 VGND VGND VPWR VPWR sky130_fd_sc_hd__decap_3
XFILLER_12_191 VGND VGND VPWR VPWR sky130_fd_sc_hd__decap_3
XTAP_TAPCELL_ROW_41_1257 VGND VPWR sky130_fd_sc_hd__tapvpwrvgnd_1
XTAP_TAPCELL_ROW_41_1268 VGND VPWR sky130_fd_sc_hd__tapvpwrvgnd_1
XTAP_TAPCELL_ROW_41_1279 VGND VPWR sky130_fd_sc_hd__tapvpwrvgnd_1
X_5440_ _5440_/A1 _5478_/A2 _4669_/X VGND VGND VPWR VPWR _6552_/D sky130_fd_sc_hd__a21o_2
XFILLER_12_1332 VGND VGND VPWR VPWR sky130_fd_sc_hd__decap_3
XFILLER_51_1381 VGND VGND VPWR VPWR sky130_fd_sc_hd__decap_3
XFILLER_69_1119 VGND VGND VPWR VPWR sky130_fd_sc_hd__fill_1
XFILLER_66_3 VGND VGND VPWR VPWR sky130_fd_sc_hd__decap_3
XTAP_TAPCELL_ROW_58_1710 VGND VPWR sky130_fd_sc_hd__tapvpwrvgnd_1
XTAP_TAPCELL_ROW_58_1721 VGND VPWR sky130_fd_sc_hd__tapvpwrvgnd_1
XFILLER_12_1365 VGND VGND VPWR VPWR sky130_fd_sc_hd__decap_3
XFILLER_12_1376 VGND VGND VPWR VPWR sky130_fd_sc_hd__decap_3
X_5371_ _5371_/A1 _5470_/A2 _4225_/X VGND VGND VPWR VPWR _6483_/D sky130_fd_sc_hd__a21o_2
X_7110_ _7110_/A VGND VGND VPWR VPWR uio_out[5] sky130_fd_sc_hd__buf_2
X_4322_ _6830_/Q wire295/X _4876_/B1 _4321_/X VGND VGND VPWR VPWR _4322_/X sky130_fd_sc_hd__a211o_2
XTAP_TAPCELL_ROW_54_1607 VGND VPWR sky130_fd_sc_hd__tapvpwrvgnd_1
XFILLER_47_1428 VGND VGND VPWR VPWR sky130_fd_sc_hd__decap_3
X_7041_ _7041_/CLK _7041_/D fanout730/X VGND VGND VPWR VPWR _7041_/Q sky130_fd_sc_hd__dfrtp_2
X_4253_ _4787_/C1 _4248_/X _4252_/X VGND VGND VPWR VPWR _4253_/X sky130_fd_sc_hd__o21a_2
XFILLER_68_810 VGND VGND VPWR VPWR sky130_fd_sc_hd__fill_2
XFILLER_80_1043 VGND VGND VPWR VPWR sky130_fd_sc_hd__decap_3
X_3204_ _7008_/Q _3207_/B2 _3213_/A1 _3203_/X VGND VGND VPWR VPWR _3204_/X sky130_fd_sc_hd__a22o_2
X_4184_ _3933_/A _4777_/B _4179_/X _3098_/A VGND VGND VPWR VPWR _4184_/X sky130_fd_sc_hd__o2bb2a_2
XFILLER_68_854 VGND VGND VPWR VPWR sky130_fd_sc_hd__fill_1
XFILLER_80_1065 VGND VGND VPWR VPWR sky130_fd_sc_hd__decap_3
XFILLER_28_707 VGND VGND VPWR VPWR sky130_fd_sc_hd__decap_3
X_3135_ _7075_/Q _6947_/Q _6955_/Q _3172_/S VGND VGND VPWR VPWR _3136_/B sky130_fd_sc_hd__a22oi_2
XFILLER_68_898 VGND VGND VPWR VPWR sky130_fd_sc_hd__fill_1
X_3066_ _6362_/Q VGND VGND VPWR VPWR _3066_/Y sky130_fd_sc_hd__inv_2
XFILLER_36_751 VGND VGND VPWR VPWR sky130_fd_sc_hd__decap_3
XFILLER_24_913 VGND VGND VPWR VPWR sky130_fd_sc_hd__fill_1
XFILLER_42_209 VGND VGND VPWR VPWR sky130_fd_sc_hd__decap_3
XFILLER_36_784 VGND VGND VPWR VPWR sky130_fd_sc_hd__fill_2
XFILLER_24_968 VGND VGND VPWR VPWR sky130_fd_sc_hd__decap_3
X_6825_ _6889_/CLK _6825_/D fanout749/X VGND VGND VPWR VPWR _6825_/Q sky130_fd_sc_hd__dfrtp_2
XFILLER_51_754 VGND VGND VPWR VPWR sky130_fd_sc_hd__decap_3
XFILLER_56_1270 VGND VGND VPWR VPWR sky130_fd_sc_hd__decap_3
XFILLER_10_106 VGND VGND VPWR VPWR sky130_fd_sc_hd__decap_3
X_6756_ _7020_/CLK _6756_/D fanout807/X VGND VGND VPWR VPWR _6756_/Q sky130_fd_sc_hd__dfrtp_2
X_3968_ _6529_/Q _3991_/B _4123_/B2 VGND VGND VPWR VPWR _3968_/X sky130_fd_sc_hd__a21bo_2
XFILLER_17_1254 VGND VGND VPWR VPWR sky130_fd_sc_hd__decap_3
X_5707_ _5909_/A0 _5707_/A1 wire89/X VGND VGND VPWR VPWR _6756_/D sky130_fd_sc_hd__mux2_1
XFILLER_17_1287 VGND VGND VPWR VPWR sky130_fd_sc_hd__fill_1
X_6687_ _7019_/CLK _6687_/D fanout838/X VGND VGND VPWR VPWR _6687_/Q sky130_fd_sc_hd__dfrtp_2
XFILLER_12_24 VGND VGND VPWR VPWR sky130_fd_sc_hd__decap_3
XFILLER_17_1298 VGND VGND VPWR VPWR sky130_fd_sc_hd__decap_3
X_3899_ _6277_/Q _4010_/B _3902_/B1 _6253_/Q _3902_/C1 VGND VGND VPWR VPWR _3899_/X
+ sky130_fd_sc_hd__a221o_2
XFILLER_30_1421 VGND VGND VPWR VPWR sky130_fd_sc_hd__decap_3
XFILLER_30_1432 VGND VGND VPWR VPWR sky130_fd_sc_hd__decap_3
X_5638_ _5923_/A1 _5638_/A1 wire93/X VGND VGND VPWR VPWR _6697_/D sky130_fd_sc_hd__mux2_1
XFILLER_3_806 VGND VGND VPWR VPWR sky130_fd_sc_hd__decap_3
XFILLER_30_1465 VGND VGND VPWR VPWR sky130_fd_sc_hd__decap_3
X_5569_ _5569_/A wire25/X VGND VGND VPWR VPWR _5569_/Y sky130_fd_sc_hd__nor2_2
XFILLER_3_839 VGND VGND VPWR VPWR sky130_fd_sc_hd__fill_1
XFILLER_8_1400 VGND VGND VPWR VPWR sky130_fd_sc_hd__decap_3
Xfanout620 _5928_/A0 VGND VGND VPWR VPWR _5901_/A0 sky130_fd_sc_hd__clkdlybuf4s25_1
XFILLER_28_1350 VGND VGND VPWR VPWR sky130_fd_sc_hd__decap_3
XFILLER_63_1230 VGND VGND VPWR VPWR sky130_fd_sc_hd__fill_2
Xfanout631 _5789_/C VGND VGND VPWR VPWR _5825_/A0 sky130_fd_sc_hd__clkdlybuf4s25_1
Xfanout642 fanout667/X VGND VGND VPWR VPWR fanout642/X sky130_fd_sc_hd__clkdlybuf4s25_1
XFILLER_24_1203 VGND VGND VPWR VPWR sky130_fd_sc_hd__fill_1
XFILLER_59_832 VGND VGND VPWR VPWR sky130_fd_sc_hd__decap_3
XFILLER_8_1444 VGND VGND VPWR VPWR sky130_fd_sc_hd__decap_3
Xfanout653 fanout667/X VGND VGND VPWR VPWR fanout653/X sky130_fd_sc_hd__clkdlybuf4s25_1
XFILLER_63_1263 VGND VGND VPWR VPWR sky130_fd_sc_hd__decap_3
XFILLER_28_1394 VGND VGND VPWR VPWR sky130_fd_sc_hd__decap_3
Xfanout675 fanout682/X VGND VGND VPWR VPWR fanout675/X sky130_fd_sc_hd__clkdlybuf4s25_1
XFILLER_19_707 VGND VGND VPWR VPWR sky130_fd_sc_hd__fill_1
XFILLER_24_1247 VGND VGND VPWR VPWR sky130_fd_sc_hd__decap_3
Xfanout686 fanout698/X VGND VGND VPWR VPWR wire687/A sky130_fd_sc_hd__clkdlybuf4s25_1
Xfanout697 fanout698/X VGND VGND VPWR VPWR fanout697/X sky130_fd_sc_hd__clkdlybuf4s25_1
XFILLER_59_887 VGND VGND VPWR VPWR sky130_fd_sc_hd__fill_1
XFILLER_19_729 VGND VGND VPWR VPWR sky130_fd_sc_hd__fill_2
XFILLER_73_312 VGND VGND VPWR VPWR sky130_fd_sc_hd__decap_3
XFILLER_18_239 VGND VGND VPWR VPWR sky130_fd_sc_hd__decap_3
XFILLER_46_548 VGND VGND VPWR VPWR sky130_fd_sc_hd__decap_3
XFILLER_2_1032 VGND VGND VPWR VPWR sky130_fd_sc_hd__decap_3
XFILLER_73_356 VGND VGND VPWR VPWR sky130_fd_sc_hd__decap_3
XFILLER_2_1043 VGND VGND VPWR VPWR sky130_fd_sc_hd__decap_3
XFILLER_2_1076 VGND VGND VPWR VPWR sky130_fd_sc_hd__decap_3
XFILLER_54_592 VGND VGND VPWR VPWR sky130_fd_sc_hd__decap_3
XFILLER_30_905 VGND VGND VPWR VPWR sky130_fd_sc_hd__decap_3
XFILLER_14_467 VGND VGND VPWR VPWR sky130_fd_sc_hd__decap_3
XFILLER_35_1310 VGND VGND VPWR VPWR sky130_fd_sc_hd__decap_3
XFILLER_42_776 VGND VGND VPWR VPWR sky130_fd_sc_hd__decap_3
XFILLER_14_489 VGND VGND VPWR VPWR sky130_fd_sc_hd__fill_2
XFILLER_70_1223 VGND VGND VPWR VPWR sky130_fd_sc_hd__decap_3
XFILLER_23_990 VGND VGND VPWR VPWR sky130_fd_sc_hd__decap_3
XFILLER_35_1343 VGND VGND VPWR VPWR sky130_fd_sc_hd__fill_1
XFILLER_35_1354 VGND VGND VPWR VPWR sky130_fd_sc_hd__decap_3
XFILLER_70_1256 VGND VGND VPWR VPWR sky130_fd_sc_hd__decap_3
XFILLER_70_1267 VGND VGND VPWR VPWR sky130_fd_sc_hd__decap_3
XFILLER_10_651 VGND VGND VPWR VPWR sky130_fd_sc_hd__decap_3
XFILLER_35_1387 VGND VGND VPWR VPWR sky130_fd_sc_hd__decap_3
XFILLER_6_611 VGND VGND VPWR VPWR sky130_fd_sc_hd__decap_3
XFILLER_10_673 VGND VGND VPWR VPWR sky130_fd_sc_hd__decap_3
XFILLER_52_9 VGND VGND VPWR VPWR sky130_fd_sc_hd__fill_2
XFILLER_6_699 VGND VGND VPWR VPWR sky130_fd_sc_hd__fill_1
XFILLER_68_1163 VGND VGND VPWR VPWR sky130_fd_sc_hd__decap_3
XFILLER_9_1219 VGND VGND VPWR VPWR sky130_fd_sc_hd__decap_3
XFILLER_68_1196 VGND VGND VPWR VPWR sky130_fd_sc_hd__decap_3
XFILLER_78_50 VGND VGND VPWR VPWR sky130_fd_sc_hd__decap_3
XFILLER_2_861 VGND VGND VPWR VPWR sky130_fd_sc_hd__decap_3
XFILLER_2_872 VGND VGND VPWR VPWR sky130_fd_sc_hd__decap_3
XFILLER_78_83 VGND VGND VPWR VPWR sky130_fd_sc_hd__fill_1
XFILLER_46_1450 VGND VGND VPWR VPWR sky130_fd_sc_hd__decap_3
XFILLER_68_117 VGND VGND VPWR VPWR sky130_fd_sc_hd__decap_3
XFILLER_42_1303 VGND VGND VPWR VPWR sky130_fd_sc_hd__decap_3
XFILLER_1_382 VGND VGND VPWR VPWR sky130_fd_sc_hd__decap_3
XFILLER_1_393 VGND VGND VPWR VPWR sky130_fd_sc_hd__decap_3
XTAP_TAPCELL_ROW_34_1072 VGND VPWR sky130_fd_sc_hd__tapvpwrvgnd_1
XFILLER_65_802 VGND VGND VPWR VPWR sky130_fd_sc_hd__decap_3
XTAP_TAPCELL_ROW_34_1083 VGND VPWR sky130_fd_sc_hd__tapvpwrvgnd_1
XFILLER_42_1347 VGND VGND VPWR VPWR sky130_fd_sc_hd__decap_3
XTAP_TAPCELL_ROW_34_1094 VGND VPWR sky130_fd_sc_hd__tapvpwrvgnd_1
XFILLER_37_537 VGND VGND VPWR VPWR sky130_fd_sc_hd__decap_3
XFILLER_40_1082 VGND VGND VPWR VPWR sky130_fd_sc_hd__fill_1
XFILLER_40_1093 VGND VGND VPWR VPWR sky130_fd_sc_hd__fill_2
XTAP_TAPCELL_ROW_47_1411 VGND VPWR sky130_fd_sc_hd__tapvpwrvgnd_1
X_4940_ _6381_/Q _5213_/B _5083_/A VGND VGND VPWR VPWR _4940_/Y sky130_fd_sc_hd__a21oi_2
XFILLER_79_1281 VGND VGND VPWR VPWR sky130_fd_sc_hd__decap_3
XFILLER_80_838 VGND VGND VPWR VPWR sky130_fd_sc_hd__fill_2
XTAP_TAPCELL_ROW_47_1422 VGND VPWR sky130_fd_sc_hd__tapvpwrvgnd_1
XFILLER_79_1292 VGND VGND VPWR VPWR sky130_fd_sc_hd__decap_3
XFILLER_45_581 VGND VGND VPWR VPWR sky130_fd_sc_hd__decap_3
XTAP_TAPCELL_ROW_47_1433 VGND VPWR sky130_fd_sc_hd__tapvpwrvgnd_1
XFILLER_33_732 VGND VGND VPWR VPWR sky130_fd_sc_hd__fill_2
XFILLER_75_1145 VGND VGND VPWR VPWR sky130_fd_sc_hd__decap_3
X_4871_ _4403_/A _4665_/B _4694_/C _4842_/X _6588_/Q VGND VGND VPWR VPWR _4871_/X
+ sky130_fd_sc_hd__a32o_2
XTAP_TAPCELL_ROW_43_1308 VGND VPWR sky130_fd_sc_hd__tapvpwrvgnd_1
XFILLER_71_1009 VGND VGND VPWR VPWR sky130_fd_sc_hd__decap_3
XFILLER_75_1189 VGND VGND VPWR VPWR sky130_fd_sc_hd__decap_3
XFILLER_32_253 VGND VGND VPWR VPWR sky130_fd_sc_hd__fill_1
XTAP_TAPCELL_ROW_43_1319 VGND VPWR sky130_fd_sc_hd__tapvpwrvgnd_1
XFILLER_53_1410 VGND VGND VPWR VPWR sky130_fd_sc_hd__decap_3
X_6610_ _6617_/CLK _6610_/D fanout724/X VGND VGND VPWR VPWR _6610_/Q sky130_fd_sc_hd__dfrtp_2
X_3822_ _3822_/A _3822_/B _3822_/C _3822_/D VGND VGND VPWR VPWR _3822_/X sky130_fd_sc_hd__and4_2
XFILLER_32_286 VGND VGND VPWR VPWR sky130_fd_sc_hd__decap_3
XFILLER_53_1443 VGND VGND VPWR VPWR sky130_fd_sc_hd__decap_3
XFILLER_20_437 VGND VGND VPWR VPWR sky130_fd_sc_hd__fill_1
X_6541_ _6847_/CLK _6541_/D fanout777/X VGND VGND VPWR VPWR _6541_/Q sky130_fd_sc_hd__dfrtp_2
X_3753_ _3753_/A _3753_/B _3879_/B _3879_/C VGND VGND VPWR VPWR _3760_/A sky130_fd_sc_hd__nand4_2
XFILLER_14_1427 VGND VGND VPWR VPWR sky130_fd_sc_hd__fill_1
XFILLER_14_1438 VGND VGND VPWR VPWR sky130_fd_sc_hd__decap_3
XFILLER_9_460 VGND VGND VPWR VPWR sky130_fd_sc_hd__decap_3
XTAP_TAPCELL_ROW_31_999 VGND VPWR sky130_fd_sc_hd__tapvpwrvgnd_1
X_6472_ _6912_/CLK _6472_/D load_slew718/X VGND VGND VPWR VPWR _6472_/Q sky130_fd_sc_hd__dfrtp_2
X_3684_ _3683_/A _3683_/B wire26/X VGND VGND VPWR VPWR _3786_/C sky130_fd_sc_hd__o21ai_2
XFILLER_12_1140 VGND VGND VPWR VPWR sky130_fd_sc_hd__fill_1
X_5423_ _5423_/A1 _5487_/A2 _4005_/X VGND VGND VPWR VPWR _6535_/D sky130_fd_sc_hd__a21o_2
XFILLER_12_1195 VGND VGND VPWR VPWR sky130_fd_sc_hd__decap_3
X_5354_ _6808_/Q _5120_/B _5354_/S VGND VGND VPWR VPWR _5354_/X sky130_fd_sc_hd__mux2_1
XFILLER_0_809 VGND VGND VPWR VPWR sky130_fd_sc_hd__decap_3
XFILLER_47_1236 VGND VGND VPWR VPWR sky130_fd_sc_hd__decap_3
X_4305_ _4305_/A _4305_/B VGND VGND VPWR VPWR _4865_/B sky130_fd_sc_hd__xnor2_2
X_5285_ _5285_/A _5285_/B VGND VGND VPWR VPWR _5285_/Y sky130_fd_sc_hd__nand2_2
XFILLER_47_1269 VGND VGND VPWR VPWR sky130_fd_sc_hd__decap_3
X_7024_ _7024_/CLK _7024_/D fanout699/A VGND VGND VPWR VPWR _7024_/Q sky130_fd_sc_hd__dfrtp_2
XFILLER_4_80 VGND VGND VPWR VPWR sky130_fd_sc_hd__decap_3
XFILLER_4_91 VGND VGND VPWR VPWR sky130_fd_sc_hd__decap_3
X_4236_ _6308_/Q wire507/X _3250_/X _4875_/B2 VGND VGND VPWR VPWR _4236_/X sky130_fd_sc_hd__a22o_2
XFILLER_60_1403 VGND VGND VPWR VPWR sky130_fd_sc_hd__decap_3
XFILLER_68_662 VGND VGND VPWR VPWR sky130_fd_sc_hd__fill_2
XFILLER_60_1447 VGND VGND VPWR VPWR sky130_fd_sc_hd__decap_3
X_4167_ _6815_/Q _4766_/A2 _4766_/B1 _4166_/X VGND VGND VPWR VPWR _4167_/X sky130_fd_sc_hd__a211o_2
XFILLER_56_824 VGND VGND VPWR VPWR sky130_fd_sc_hd__decap_3
XFILLER_56_846 VGND VGND VPWR VPWR sky130_fd_sc_hd__decap_3
XPHY_EDGE_ROW_27_Left_108 VGND VGND VPWR VPWR sky130_fd_sc_hd__decap_3
X_3118_ _7010_/Q _7018_/Q _3200_/S VGND VGND VPWR VPWR _3118_/X sky130_fd_sc_hd__mux2_1
X_4098_ _3478_/X _5519_/A2 _4781_/A2 _6936_/Q _4104_/C1 VGND VGND VPWR VPWR _4098_/X
+ sky130_fd_sc_hd__a221o_2
XFILLER_3_1363 VGND VGND VPWR VPWR sky130_fd_sc_hd__decap_3
XFILLER_70_315 VGND VGND VPWR VPWR sky130_fd_sc_hd__fill_1
X_3049_ _6345_/Q VGND VGND VPWR VPWR _3049_/Y sky130_fd_sc_hd__inv_2
XFILLER_3_1396 VGND VGND VPWR VPWR sky130_fd_sc_hd__decap_3
XFILLER_58_1332 VGND VGND VPWR VPWR sky130_fd_sc_hd__decap_3
XFILLER_19_1316 VGND VGND VPWR VPWR sky130_fd_sc_hd__decap_3
XFILLER_23_220 VGND VGND VPWR VPWR sky130_fd_sc_hd__decap_3
XFILLER_58_1365 VGND VGND VPWR VPWR sky130_fd_sc_hd__decap_3
XFILLER_51_540 VGND VGND VPWR VPWR sky130_fd_sc_hd__decap_3
XFILLER_58_1376 VGND VGND VPWR VPWR sky130_fd_sc_hd__decap_3
XFILLER_24_765 VGND VGND VPWR VPWR sky130_fd_sc_hd__fill_1
XFILLER_54_1229 VGND VGND VPWR VPWR sky130_fd_sc_hd__decap_3
X_6808_ _7064_/CLK _6808_/D fanout719/X VGND VGND VPWR VPWR _6808_/Q sky130_fd_sc_hd__dfrtp_2
XFILLER_23_12 VGND VGND VPWR VPWR sky130_fd_sc_hd__decap_3
XFILLER_12_949 VGND VGND VPWR VPWR sky130_fd_sc_hd__decap_3
XFILLER_23_275 VGND VGND VPWR VPWR sky130_fd_sc_hd__decap_3
XFILLER_11_437 VGND VGND VPWR VPWR sky130_fd_sc_hd__decap_3
XFILLER_7_408 VGND VGND VPWR VPWR sky130_fd_sc_hd__decap_3
X_6739_ _6900_/CLK _6739_/D fanout832/X VGND VGND VPWR VPWR _6739_/Q sky130_fd_sc_hd__dfrtp_2
Xwire339 wire339/A VGND VGND VPWR VPWR _4894_/A sky130_fd_sc_hd__clkbuf_4
XPHY_EDGE_ROW_36_Left_117 VGND VGND VPWR VPWR sky130_fd_sc_hd__decap_3
XFILLER_3_603 VGND VGND VPWR VPWR sky130_fd_sc_hd__decap_3
XFILLER_30_1273 VGND VGND VPWR VPWR sky130_fd_sc_hd__decap_3
XFILLER_2_124 VGND VGND VPWR VPWR sky130_fd_sc_hd__decap_3
XFILLER_3_658 VGND VGND VPWR VPWR sky130_fd_sc_hd__decap_3
XFILLER_65_1325 VGND VGND VPWR VPWR sky130_fd_sc_hd__decap_3
XFILLER_2_168 VGND VGND VPWR VPWR sky130_fd_sc_hd__decap_3
XFILLER_26_1309 VGND VGND VPWR VPWR sky130_fd_sc_hd__decap_3
XFILLER_65_1369 VGND VGND VPWR VPWR sky130_fd_sc_hd__decap_3
XFILLER_8_1241 VGND VGND VPWR VPWR sky130_fd_sc_hd__decap_3
Xfanout450 _3043_/Y VGND VGND VPWR VPWR _4723_/B sky130_fd_sc_hd__clkdlybuf4s25_1
Xfanout461 _4838_/A1 VGND VGND VPWR VPWR _4787_/C1 sky130_fd_sc_hd__clkdlybuf4s25_1
Xfanout472 _4874_/A1 VGND VGND VPWR VPWR _4817_/A1 sky130_fd_sc_hd__clkdlybuf4s25_1
XFILLER_24_1033 VGND VGND VPWR VPWR sky130_fd_sc_hd__decap_3
XPHY_EDGE_ROW_45_Left_126 VGND VGND VPWR VPWR sky130_fd_sc_hd__decap_3
XFILLER_4_1105 VGND VGND VPWR VPWR sky130_fd_sc_hd__decap_3
XFILLER_8_1285 VGND VGND VPWR VPWR sky130_fd_sc_hd__decap_3
XFILLER_47_824 VGND VGND VPWR VPWR sky130_fd_sc_hd__decap_3
Xfanout483 _4381_/C1 VGND VGND VPWR VPWR _4756_/A1 sky130_fd_sc_hd__clkdlybuf4s25_1
XFILLER_24_1055 VGND VGND VPWR VPWR sky130_fd_sc_hd__decap_3
XFILLER_59_684 VGND VGND VPWR VPWR sky130_fd_sc_hd__decap_3
Xfanout494 _7089_/Q VGND VGND VPWR VPWR _5581_/A sky130_fd_sc_hd__clkdlybuf4s25_1
XFILLER_4_1138 VGND VGND VPWR VPWR sky130_fd_sc_hd__decap_3
XFILLER_46_312 VGND VGND VPWR VPWR sky130_fd_sc_hd__decap_3
XFILLER_48_97 VGND VGND VPWR VPWR sky130_fd_sc_hd__decap_3
XFILLER_4_1149 VGND VGND VPWR VPWR sky130_fd_sc_hd__decap_3
XFILLER_19_548 VGND VGND VPWR VPWR sky130_fd_sc_hd__decap_3
XFILLER_0_27 VGND VGND VPWR VPWR sky130_fd_sc_hd__fill_1
XFILLER_0_38 VGND VGND VPWR VPWR sky130_fd_sc_hd__decap_3
XFILLER_73_153 VGND VGND VPWR VPWR sky130_fd_sc_hd__decap_3
XFILLER_74_687 VGND VGND VPWR VPWR sky130_fd_sc_hd__decap_3
XFILLER_34_518 VGND VGND VPWR VPWR sky130_fd_sc_hd__decap_3
XFILLER_61_304 VGND VGND VPWR VPWR sky130_fd_sc_hd__fill_2
XFILLER_64_41 VGND VGND VPWR VPWR sky130_fd_sc_hd__fill_1
XFILLER_76_1421 VGND VGND VPWR VPWR sky130_fd_sc_hd__decap_3
XFILLER_73_175 VGND VGND VPWR VPWR sky130_fd_sc_hd__fill_1
XFILLER_76_1432 VGND VGND VPWR VPWR sky130_fd_sc_hd__decap_3
XFILLER_15_732 VGND VGND VPWR VPWR sky130_fd_sc_hd__decap_3
XFILLER_64_85 VGND VGND VPWR VPWR sky130_fd_sc_hd__decap_3
XFILLER_76_1465 VGND VGND VPWR VPWR sky130_fd_sc_hd__decap_3
XFILLER_37_1416 VGND VGND VPWR VPWR sky130_fd_sc_hd__decap_3
XFILLER_15_765 VGND VGND VPWR VPWR sky130_fd_sc_hd__decap_3
XFILLER_72_1329 VGND VGND VPWR VPWR sky130_fd_sc_hd__decap_3
XFILLER_37_1449 VGND VGND VPWR VPWR sky130_fd_sc_hd__decap_3
XFILLER_14_264 VGND VGND VPWR VPWR sky130_fd_sc_hd__decap_3
XFILLER_9_36 VGND VGND VPWR VPWR sky130_fd_sc_hd__decap_3
XFILLER_30_757 VGND VGND VPWR VPWR sky130_fd_sc_hd__decap_3
XPHY_EDGE_ROW_54_Left_135 VGND VGND VPWR VPWR sky130_fd_sc_hd__decap_3
XFILLER_70_1031 VGND VGND VPWR VPWR sky130_fd_sc_hd__decap_3
XFILLER_13_1460 VGND VGND VPWR VPWR sky130_fd_sc_hd__decap_3
XFILLER_10_492 VGND VGND VPWR VPWR sky130_fd_sc_hd__decap_3
XFILLER_7_975 VGND VGND VPWR VPWR sky130_fd_sc_hd__decap_3
XFILLER_6_452 VGND VGND VPWR VPWR sky130_fd_sc_hd__decap_3
Xhold909 _6161_/Q VGND VGND VPWR VPWR hold909/X sky130_fd_sc_hd__dlygate4sd3_1
XFILLER_50_6 VGND VGND VPWR VPWR sky130_fd_sc_hd__fill_1
Xload_slew801 fanout800/X VGND VGND VPWR VPWR load_slew801/X sky130_fd_sc_hd__clkbuf_4
XTAP_TAPCELL_ROW_36_1134 VGND VPWR sky130_fd_sc_hd__tapvpwrvgnd_1
XTAP_TAPCELL_ROW_36_1145 VGND VPWR sky130_fd_sc_hd__tapvpwrvgnd_1
XFILLER_44_1409 VGND VGND VPWR VPWR sky130_fd_sc_hd__decap_3
Xload_slew834 fanout833/X VGND VGND VPWR VPWR load_slew834/X sky130_fd_sc_hd__clkbuf_4
XFILLER_69_437 VGND VGND VPWR VPWR sky130_fd_sc_hd__decap_3
Xload_slew845 fanout844/X VGND VGND VPWR VPWR load_slew845/X sky130_fd_sc_hd__clkbuf_4
XFILLER_9_1049 VGND VGND VPWR VPWR sky130_fd_sc_hd__decap_3
XPHY_EDGE_ROW_63_Left_144 VGND VGND VPWR VPWR sky130_fd_sc_hd__decap_3
X_5070_ _6610_/Q _6650_/Q VGND VGND VPWR VPWR _5071_/B sky130_fd_sc_hd__xnor2_2
XFILLER_1_190 VGND VGND VPWR VPWR sky130_fd_sc_hd__decap_3
XFILLER_29_3 VGND VGND VPWR VPWR sky130_fd_sc_hd__decap_3
XFILLER_46_1291 VGND VGND VPWR VPWR sky130_fd_sc_hd__decap_3
X_4021_ _6233_/Q _4069_/A2 _4019_/X _4020_/X VGND VGND VPWR VPWR _6233_/D sky130_fd_sc_hd__o22a_2
XFILLER_38_813 VGND VGND VPWR VPWR sky130_fd_sc_hd__decap_3
XFILLER_42_1133 VGND VGND VPWR VPWR sky130_fd_sc_hd__decap_3
XFILLER_49_172 VGND VGND VPWR VPWR sky130_fd_sc_hd__fill_1
XFILLER_64_131 VGND VGND VPWR VPWR sky130_fd_sc_hd__decap_3
XFILLER_77_1207 VGND VGND VPWR VPWR sky130_fd_sc_hd__decap_3
XFILLER_80_613 VGND VGND VPWR VPWR sky130_fd_sc_hd__decap_3
XFILLER_20_1453 VGND VGND VPWR VPWR sky130_fd_sc_hd__decap_3
X_5972_ hold900/X _6976_/Q _6033_/S VGND VGND VPWR VPWR _5972_/X sky130_fd_sc_hd__mux2_1
XFILLER_64_186 VGND VGND VPWR VPWR sky130_fd_sc_hd__decap_3
XFILLER_64_197 VGND VGND VPWR VPWR sky130_fd_sc_hd__decap_3
X_4923_ _6443_/Q _6661_/Q VGND VGND VPWR VPWR _4924_/B sky130_fd_sc_hd__xor2_2
XFILLER_80_679 VGND VGND VPWR VPWR sky130_fd_sc_hd__fill_1
XFILLER_61_871 VGND VGND VPWR VPWR sky130_fd_sc_hd__fill_1
XPHY_EDGE_ROW_72_Left_153 VGND VGND VPWR VPWR sky130_fd_sc_hd__decap_3
XFILLER_21_724 VGND VGND VPWR VPWR sky130_fd_sc_hd__decap_3
XFILLER_21_735 VGND VGND VPWR VPWR sky130_fd_sc_hd__decap_3
X_4854_ _6313_/Q _4854_/A2 _3452_/X _4854_/B2 VGND VGND VPWR VPWR _4854_/X sky130_fd_sc_hd__a22o_2
XFILLER_60_392 VGND VGND VPWR VPWR sky130_fd_sc_hd__decap_3
XFILLER_21_757 VGND VGND VPWR VPWR sky130_fd_sc_hd__decap_3
XFILLER_18_1371 VGND VGND VPWR VPWR sky130_fd_sc_hd__fill_1
X_3805_ _3927_/A_N _6306_/Q VGND VGND VPWR VPWR _3805_/X sky130_fd_sc_hd__and2b_2
XFILLER_53_1251 VGND VGND VPWR VPWR sky130_fd_sc_hd__decap_3
XFILLER_18_1382 VGND VGND VPWR VPWR sky130_fd_sc_hd__decap_3
X_4785_ _6576_/Q _4835_/S _4784_/Y _4787_/C1 VGND VGND VPWR VPWR _4788_/B sky130_fd_sc_hd__a211o_2
XFILLER_14_1235 VGND VGND VPWR VPWR sky130_fd_sc_hd__decap_3
XFILLER_53_1284 VGND VGND VPWR VPWR sky130_fd_sc_hd__decap_3
X_6524_ _6982_/CLK _6524_/D fanout745/X VGND VGND VPWR VPWR _6524_/Q sky130_fd_sc_hd__dfrtp_2
XFILLER_20_289 VGND VGND VPWR VPWR sky130_fd_sc_hd__decap_3
X_3736_ _6231_/Q _3948_/A2 _3948_/B1 _6223_/Q _3948_/C1 VGND VGND VPWR VPWR _3736_/X
+ sky130_fd_sc_hd__a221o_2
XFILLER_53_1295 VGND VGND VPWR VPWR sky130_fd_sc_hd__decap_3
XFILLER_14_1279 VGND VGND VPWR VPWR sky130_fd_sc_hd__decap_3
X_3667_ _3667_/A _3667_/B VGND VGND VPWR VPWR _3669_/B sky130_fd_sc_hd__xnor2_2
X_6455_ _6889_/CLK _6455_/D fanout708/X VGND VGND VPWR VPWR _6455_/Q sky130_fd_sc_hd__dfrtp_2
Xclkload60 _6772_/CLK VGND VGND VPWR VPWR clkload60/X sky130_fd_sc_hd__clkbuf_4
X_5406_ _5406_/A1 _5470_/A2 _4476_/X VGND VGND VPWR VPWR _6518_/D sky130_fd_sc_hd__a21o_2
X_6386_ _6988_/CLK _6386_/D load_slew813/X VGND VGND VPWR VPWR _6386_/Q sky130_fd_sc_hd__dfrtp_2
X_3598_ _3596_/X _3597_/X _4403_/A VGND VGND VPWR VPWR _3598_/X sky130_fd_sc_hd__mux2_1
X_5337_ _6461_/Q _5336_/X _5337_/S VGND VGND VPWR VPWR _6461_/D sky130_fd_sc_hd__mux2_1
XFILLER_0_617 VGND VGND VPWR VPWR sky130_fd_sc_hd__fill_1
X_5268_ _6769_/Q _5338_/S _5341_/S _5267_/Y VGND VGND VPWR VPWR _5268_/X sky130_fd_sc_hd__o211a_2
XFILLER_25_1331 VGND VGND VPWR VPWR sky130_fd_sc_hd__decap_3
XFILLER_64_1391 VGND VGND VPWR VPWR sky130_fd_sc_hd__decap_3
XFILLER_5_1425 VGND VGND VPWR VPWR sky130_fd_sc_hd__decap_3
X_4219_ _4292_/B _4230_/B VGND VGND VPWR VPWR _4302_/B sky130_fd_sc_hd__xnor2_2
X_7007_ _7007_/CLK _7007_/D fanout820/X VGND VGND VPWR VPWR _7007_/Q sky130_fd_sc_hd__dfrtp_2
XFILLER_60_1244 VGND VGND VPWR VPWR sky130_fd_sc_hd__decap_3
XFILLER_25_1375 VGND VGND VPWR VPWR sky130_fd_sc_hd__decap_3
X_5199_ _6746_/Q _5216_/A _5307_/S _5198_/Y VGND VGND VPWR VPWR _5199_/X sky130_fd_sc_hd__o211a_2
XFILLER_28_312 VGND VGND VPWR VPWR sky130_fd_sc_hd__decap_3
XFILLER_56_643 VGND VGND VPWR VPWR sky130_fd_sc_hd__fill_1
XFILLER_21_1239 VGND VGND VPWR VPWR sky130_fd_sc_hd__decap_3
XFILLER_56_654 VGND VGND VPWR VPWR sky130_fd_sc_hd__fill_1
XFILLER_60_1288 VGND VGND VPWR VPWR sky130_fd_sc_hd__decap_3
XFILLER_29_879 VGND VGND VPWR VPWR sky130_fd_sc_hd__fill_1
XFILLER_71_602 VGND VGND VPWR VPWR sky130_fd_sc_hd__decap_3
XFILLER_56_676 VGND VGND VPWR VPWR sky130_fd_sc_hd__decap_3
XFILLER_3_1160 VGND VGND VPWR VPWR sky130_fd_sc_hd__decap_3
XFILLER_16_518 VGND VGND VPWR VPWR sky130_fd_sc_hd__decap_3
XFILLER_44_827 VGND VGND VPWR VPWR sky130_fd_sc_hd__decap_3
XFILLER_55_186 VGND VGND VPWR VPWR sky130_fd_sc_hd__fill_2
XFILLER_43_337 VGND VGND VPWR VPWR sky130_fd_sc_hd__decap_3
XFILLER_70_134 VGND VGND VPWR VPWR sky130_fd_sc_hd__decap_3
XFILLER_71_668 VGND VGND VPWR VPWR sky130_fd_sc_hd__decap_3
XFILLER_71_679 VGND VGND VPWR VPWR sky130_fd_sc_hd__decap_3
XFILLER_19_1124 VGND VGND VPWR VPWR sky130_fd_sc_hd__decap_3
XFILLER_24_551 VGND VGND VPWR VPWR sky130_fd_sc_hd__decap_3
XFILLER_24_562 VGND VGND VPWR VPWR sky130_fd_sc_hd__decap_3
XFILLER_54_1015 VGND VGND VPWR VPWR sky130_fd_sc_hd__decap_3
XFILLER_58_1184 VGND VGND VPWR VPWR sky130_fd_sc_hd__decap_3
XFILLER_70_178 VGND VGND VPWR VPWR sky130_fd_sc_hd__decap_3
XFILLER_34_77 VGND VGND VPWR VPWR sky130_fd_sc_hd__decap_3
XFILLER_24_595 VGND VGND VPWR VPWR sky130_fd_sc_hd__decap_3
XFILLER_51_381 VGND VGND VPWR VPWR sky130_fd_sc_hd__decap_3
XFILLER_71_1340 VGND VGND VPWR VPWR sky130_fd_sc_hd__decap_3
XFILLER_12_757 VGND VGND VPWR VPWR sky130_fd_sc_hd__decap_3
XFILLER_71_1351 VGND VGND VPWR VPWR sky130_fd_sc_hd__decap_3
XTAP_TAPCELL_ROW_22_763 VGND VPWR sky130_fd_sc_hd__tapvpwrvgnd_1
XFILLER_71_1384 VGND VGND VPWR VPWR sky130_fd_sc_hd__decap_3
XTAP_TAPCELL_ROW_22_774 VGND VPWR sky130_fd_sc_hd__tapvpwrvgnd_1
XFILLER_32_1335 VGND VGND VPWR VPWR sky130_fd_sc_hd__decap_3
XTAP_TAPCELL_ROW_22_785 VGND VPWR sky130_fd_sc_hd__tapvpwrvgnd_1
XFILLER_50_32 VGND VGND VPWR VPWR sky130_fd_sc_hd__fill_1
XFILLER_32_1368 VGND VGND VPWR VPWR sky130_fd_sc_hd__decap_3
XFILLER_32_1379 VGND VGND VPWR VPWR sky130_fd_sc_hd__decap_3
XFILLER_4_912 VGND VGND VPWR VPWR sky130_fd_sc_hd__decap_3
XFILLER_4_934 VGND VGND VPWR VPWR sky130_fd_sc_hd__decap_3
XTAP_TAPCELL_ROW_76_2171 VGND VPWR sky130_fd_sc_hd__tapvpwrvgnd_1
XFILLER_3_411 VGND VGND VPWR VPWR sky130_fd_sc_hd__decap_3
XTAP_TAPCELL_ROW_76_2182 VGND VPWR sky130_fd_sc_hd__tapvpwrvgnd_1
XFILLER_3_444 VGND VGND VPWR VPWR sky130_fd_sc_hd__decap_3
XFILLER_3_455 VGND VGND VPWR VPWR sky130_fd_sc_hd__decap_3
XFILLER_79_713 VGND VGND VPWR VPWR sky130_fd_sc_hd__decap_3
XTAP_TAPCELL_ROW_72_2068 VGND VPWR sky130_fd_sc_hd__tapvpwrvgnd_1
XFILLER_3_477 VGND VGND VPWR VPWR sky130_fd_sc_hd__decap_3
Xload_slew108 _5221_/A2 VGND VGND VPWR VPWR _5269_/A2 sky130_fd_sc_hd__buf_4
XFILLER_79_735 VGND VGND VPWR VPWR sky130_fd_sc_hd__decap_3
Xload_slew119 _5287_/A2 VGND VGND VPWR VPWR _5278_/A2 sky130_fd_sc_hd__clkbuf_4
XTAP_TAPCELL_ROW_72_2079 VGND VPWR sky130_fd_sc_hd__tapvpwrvgnd_1
XFILLER_59_52 VGND VGND VPWR VPWR sky130_fd_sc_hd__decap_3
XFILLER_78_234 VGND VGND VPWR VPWR sky130_fd_sc_hd__fill_1
XFILLER_26_1128 VGND VGND VPWR VPWR sky130_fd_sc_hd__decap_3
XFILLER_65_1177 VGND VGND VPWR VPWR sky130_fd_sc_hd__decap_3
XFILLER_59_96 VGND VGND VPWR VPWR sky130_fd_sc_hd__decap_3
XFILLER_43_1431 VGND VGND VPWR VPWR sky130_fd_sc_hd__decap_3
XFILLER_66_429 VGND VGND VPWR VPWR sky130_fd_sc_hd__decap_3
XPHY_EDGE_ROW_3_Left_84 VGND VGND VPWR VPWR sky130_fd_sc_hd__decap_3
XFILLER_15_9 VGND VGND VPWR VPWR sky130_fd_sc_hd__decap_3
Xfanout291 fanout304/X VGND VGND VPWR VPWR _4781_/A2 sky130_fd_sc_hd__clkdlybuf4s25_1
XFILLER_8_1093 VGND VGND VPWR VPWR sky130_fd_sc_hd__decap_3
Xload_slew33 _4255_/B1 VGND VGND VPWR VPWR _4869_/B1 sky130_fd_sc_hd__clkbuf_4
XFILLER_47_676 VGND VGND VPWR VPWR sky130_fd_sc_hd__decap_3
XFILLER_34_326 VGND VGND VPWR VPWR sky130_fd_sc_hd__decap_3
XFILLER_34_359 VGND VGND VPWR VPWR sky130_fd_sc_hd__decap_3
XFILLER_15_540 VGND VGND VPWR VPWR sky130_fd_sc_hd__decap_3
XFILLER_43_860 VGND VGND VPWR VPWR sky130_fd_sc_hd__decap_3
XFILLER_62_679 VGND VGND VPWR VPWR sky130_fd_sc_hd__decap_3
XFILLER_76_1273 VGND VGND VPWR VPWR sky130_fd_sc_hd__decap_3
XFILLER_72_1126 VGND VGND VPWR VPWR sky130_fd_sc_hd__decap_3
XFILLER_15_573 VGND VGND VPWR VPWR sky130_fd_sc_hd__decap_3
XFILLER_43_893 VGND VGND VPWR VPWR sky130_fd_sc_hd__decap_3
XFILLER_61_189 VGND VGND VPWR VPWR sky130_fd_sc_hd__decap_3
XFILLER_37_1257 VGND VGND VPWR VPWR sky130_fd_sc_hd__decap_3
XFILLER_50_1424 VGND VGND VPWR VPWR sky130_fd_sc_hd__decap_3
XTAP_TAPCELL_ROW_61_1783 VGND VPWR sky130_fd_sc_hd__tapvpwrvgnd_1
XFILLER_50_1435 VGND VGND VPWR VPWR sky130_fd_sc_hd__decap_3
X_4570_ _6539_/Q _4547_/X _4769_/B1 VGND VGND VPWR VPWR _4570_/X sky130_fd_sc_hd__a21o_2
XTAP_TAPCELL_ROW_61_1794 VGND VPWR sky130_fd_sc_hd__tapvpwrvgnd_1
XFILLER_11_1419 VGND VGND VPWR VPWR sky130_fd_sc_hd__decap_3
XFILLER_50_1468 VGND VGND VPWR VPWR sky130_fd_sc_hd__fill_1
X_3521_ _3663_/A _3670_/A VGND VGND VPWR VPWR _3689_/A sky130_fd_sc_hd__xnor2_2
XFILLER_7_794 VGND VGND VPWR VPWR sky130_fd_sc_hd__decap_3
X_6240_ _7032_/CLK _6240_/D load_slew696/X VGND VGND VPWR VPWR _6240_/Q sky130_fd_sc_hd__dfrtp_2
X_3452_ _6337_/Q _6457_/Q VGND VGND VPWR VPWR _3452_/X sky130_fd_sc_hd__xor2_2
XFILLER_6_293 VGND VGND VPWR VPWR sky130_fd_sc_hd__decap_3
XFILLER_48_1320 VGND VGND VPWR VPWR sky130_fd_sc_hd__decap_3
X_6171_ _7022_/CLK _6171_/D fanout761/X VGND VGND VPWR VPWR _6171_/Q sky130_fd_sc_hd__dfrtp_2
XFILLER_48_1353 VGND VGND VPWR VPWR sky130_fd_sc_hd__decap_3
X_3383_ hold866/X _3382_/X _3447_/S VGND VGND VPWR VPWR _6165_/D sky130_fd_sc_hd__mux2_1
X_5122_ _5194_/B _5123_/B _5281_/A2 VGND VGND VPWR VPWR _5122_/X sky130_fd_sc_hd__a21o_2
XFILLER_48_1397 VGND VGND VPWR VPWR sky130_fd_sc_hd__decap_3
Xhold1406 _6833_/Q VGND VGND VPWR VPWR _5813_/A1 sky130_fd_sc_hd__dlygate4sd3_1
Xload_slew664 fanout663/X VGND VGND VPWR VPWR load_slew664/X sky130_fd_sc_hd__buf_2
X_5053_ _5051_/X _5052_/Y wire112/X VGND VGND VPWR VPWR _5055_/S sky130_fd_sc_hd__a21oi_2
Xhold1417 _6491_/Q VGND VGND VPWR VPWR _5379_/A1 sky130_fd_sc_hd__dlygate4sd3_1
XFILLER_57_429 VGND VGND VPWR VPWR sky130_fd_sc_hd__decap_3
Xhold1428 _6882_/Q VGND VGND VPWR VPWR _5871_/A1 sky130_fd_sc_hd__dlygate4sd3_1
XFILLER_38_610 VGND VGND VPWR VPWR sky130_fd_sc_hd__decap_3
XFILLER_69_289 VGND VGND VPWR VPWR sky130_fd_sc_hd__decap_3
Xhold1439 _7001_/Q VGND VGND VPWR VPWR _5997_/A1 sky130_fd_sc_hd__dlygate4sd3_1
X_4004_ _6535_/Q _4422_/A _4779_/A1 VGND VGND VPWR VPWR _4004_/X sky130_fd_sc_hd__a21bo_2
XFILLER_37_142 VGND VGND VPWR VPWR sky130_fd_sc_hd__decap_3
XFILLER_38_665 VGND VGND VPWR VPWR sky130_fd_sc_hd__fill_1
XFILLER_26_816 VGND VGND VPWR VPWR sky130_fd_sc_hd__fill_2
XFILLER_66_996 VGND VGND VPWR VPWR sky130_fd_sc_hd__decap_3
XFILLER_1_81 VGND VGND VPWR VPWR sky130_fd_sc_hd__decap_3
XFILLER_25_304 VGND VGND VPWR VPWR sky130_fd_sc_hd__decap_3
XFILLER_26_838 VGND VGND VPWR VPWR sky130_fd_sc_hd__decap_3
XFILLER_65_473 VGND VGND VPWR VPWR sky130_fd_sc_hd__decap_3
XFILLER_37_175 VGND VGND VPWR VPWR sky130_fd_sc_hd__decap_3
XFILLER_38_698 VGND VGND VPWR VPWR sky130_fd_sc_hd__fill_2
XTAP_TAPCELL_ROW_68_1959 VGND VPWR sky130_fd_sc_hd__tapvpwrvgnd_1
XFILLER_80_421 VGND VGND VPWR VPWR sky130_fd_sc_hd__fill_2
XFILLER_20_1261 VGND VGND VPWR VPWR sky130_fd_sc_hd__decap_3
XFILLER_80_454 VGND VGND VPWR VPWR sky130_fd_sc_hd__decap_3
XFILLER_20_1294 VGND VGND VPWR VPWR sky130_fd_sc_hd__decap_3
XFILLER_59_1460 VGND VGND VPWR VPWR sky130_fd_sc_hd__decap_3
XFILLER_0_1366 VGND VGND VPWR VPWR sky130_fd_sc_hd__decap_3
X_5955_ _5955_/A0 _6959_/Q _5955_/S VGND VGND VPWR VPWR _5955_/X sky130_fd_sc_hd__mux2_1
XFILLER_41_819 VGND VGND VPWR VPWR sky130_fd_sc_hd__decap_3
XFILLER_40_307 VGND VGND VPWR VPWR sky130_fd_sc_hd__fill_1
XFILLER_55_1313 VGND VGND VPWR VPWR sky130_fd_sc_hd__decap_3
XFILLER_0_1388 VGND VGND VPWR VPWR sky130_fd_sc_hd__decap_3
XFILLER_40_318 VGND VGND VPWR VPWR sky130_fd_sc_hd__decap_3
X_4906_ _4904_/X _4905_/Y wire105/X VGND VGND VPWR VPWR _4908_/S sky130_fd_sc_hd__a21oi_2
X_5886_ _5799_/C _5886_/A1 _5887_/S VGND VGND VPWR VPWR _6896_/D sky130_fd_sc_hd__mux2_1
XFILLER_55_1357 VGND VGND VPWR VPWR sky130_fd_sc_hd__decap_3
XFILLER_21_532 VGND VGND VPWR VPWR sky130_fd_sc_hd__decap_3
X_4837_ _6583_/Q _4894_/A _4838_/A1 VGND VGND VPWR VPWR _4837_/X sky130_fd_sc_hd__a21bo_2
XFILLER_14_1043 VGND VGND VPWR VPWR sky130_fd_sc_hd__decap_3
X_4768_ _4768_/A _4768_/B _4768_/C VGND VGND VPWR VPWR _4768_/X sky130_fd_sc_hd__and3_2
X_6507_ _7040_/CLK _6507_/D fanout716/X VGND VGND VPWR VPWR _6507_/Q sky130_fd_sc_hd__dfrtp_2
X_3719_ _6496_/Q _3089_/B _3711_/Y _4002_/A2 _4061_/A1 VGND VGND VPWR VPWR _3719_/X
+ sky130_fd_sc_hd__a221o_2
XFILLER_20_24 VGND VGND VPWR VPWR sky130_fd_sc_hd__decap_3
X_4699_ _6292_/Q wire507/X _3394_/X _4875_/B2 VGND VGND VPWR VPWR _4699_/X sky130_fd_sc_hd__a22o_2
XFILLER_31_1390 VGND VGND VPWR VPWR sky130_fd_sc_hd__decap_3
XFILLER_49_1117 VGND VGND VPWR VPWR sky130_fd_sc_hd__decap_3
XFILLER_20_46 VGND VGND VPWR VPWR sky130_fd_sc_hd__decap_3
X_6438_ _7064_/CLK _6438_/D load_slew720/X VGND VGND VPWR VPWR _6438_/Q sky130_fd_sc_hd__dfrtp_2
XFILLER_1_915 VGND VGND VPWR VPWR sky130_fd_sc_hd__decap_3
XFILLER_27_1404 VGND VGND VPWR VPWR sky130_fd_sc_hd__decap_3
XFILLER_66_1453 VGND VGND VPWR VPWR sky130_fd_sc_hd__decap_3
X_6369_ _7027_/CLK _6369_/D load_slew831/X VGND VGND VPWR VPWR _6369_/Q sky130_fd_sc_hd__dfrtp_2
XFILLER_0_414 VGND VGND VPWR VPWR sky130_fd_sc_hd__decap_3
XFILLER_1_948 VGND VGND VPWR VPWR sky130_fd_sc_hd__decap_3
XFILLER_62_1306 VGND VGND VPWR VPWR sky130_fd_sc_hd__decap_3
XFILLER_0_436 VGND VGND VPWR VPWR sky130_fd_sc_hd__decap_3
XFILLER_1_959 VGND VGND VPWR VPWR sky130_fd_sc_hd__decap_3
XFILLER_27_1437 VGND VGND VPWR VPWR sky130_fd_sc_hd__decap_3
XFILLER_62_1317 VGND VGND VPWR VPWR sky130_fd_sc_hd__decap_3
XFILLER_0_458 VGND VGND VPWR VPWR sky130_fd_sc_hd__decap_3
XFILLER_76_716 VGND VGND VPWR VPWR sky130_fd_sc_hd__fill_1
XFILLER_29_66 VGND VGND VPWR VPWR sky130_fd_sc_hd__decap_3
XFILLER_5_1222 VGND VGND VPWR VPWR sky130_fd_sc_hd__decap_3
XFILLER_5_1233 VGND VGND VPWR VPWR sky130_fd_sc_hd__decap_3
XFILLER_29_643 VGND VGND VPWR VPWR sky130_fd_sc_hd__decap_3
XFILLER_5_1266 VGND VGND VPWR VPWR sky130_fd_sc_hd__decap_3
XFILLER_56_440 VGND VGND VPWR VPWR sky130_fd_sc_hd__fill_2
XTAP_TAPCELL_ROW_3_274 VGND VPWR sky130_fd_sc_hd__tapvpwrvgnd_1
XFILLER_1_1119 VGND VGND VPWR VPWR sky130_fd_sc_hd__fill_1
XFILLER_56_462 VGND VGND VPWR VPWR sky130_fd_sc_hd__decap_3
XFILLER_60_1096 VGND VGND VPWR VPWR sky130_fd_sc_hd__decap_3
XTAP_TAPCELL_ROW_3_285 VGND VPWR sky130_fd_sc_hd__tapvpwrvgnd_1
XFILLER_57_996 VGND VGND VPWR VPWR sky130_fd_sc_hd__decap_3
XFILLER_16_315 VGND VGND VPWR VPWR sky130_fd_sc_hd__decap_3
XTAP_TAPCELL_ROW_80_2304 VGND VPWR sky130_fd_sc_hd__tapvpwrvgnd_1
XFILLER_28_197 VGND VGND VPWR VPWR sky130_fd_sc_hd__decap_3
XTAP_TAPCELL_ROW_80_2315 VGND VPWR sky130_fd_sc_hd__tapvpwrvgnd_1
XFILLER_72_966 VGND VGND VPWR VPWR sky130_fd_sc_hd__fill_1
XFILLER_71_443 VGND VGND VPWR VPWR sky130_fd_sc_hd__decap_3
XFILLER_73_1413 VGND VGND VPWR VPWR sky130_fd_sc_hd__decap_3
XFILLER_71_476 VGND VGND VPWR VPWR sky130_fd_sc_hd__fill_2
XFILLER_43_167 VGND VGND VPWR VPWR sky130_fd_sc_hd__fill_1
XFILLER_71_487 VGND VGND VPWR VPWR sky130_fd_sc_hd__decap_3
XTAP_TAPCELL_ROW_27_899 VGND VPWR sky130_fd_sc_hd__tapvpwrvgnd_1
XFILLER_73_1446 VGND VGND VPWR VPWR sky130_fd_sc_hd__decap_3
XFILLER_73_1457 VGND VGND VPWR VPWR sky130_fd_sc_hd__decap_3
XFILLER_61_42 VGND VGND VPWR VPWR sky130_fd_sc_hd__decap_3
XTAP_TAPCELL_ROW_78_2222 VGND VPWR sky130_fd_sc_hd__tapvpwrvgnd_1
XFILLER_8_536 VGND VGND VPWR VPWR sky130_fd_sc_hd__decap_3
XFILLER_12_598 VGND VGND VPWR VPWR sky130_fd_sc_hd__decap_3
XTAP_TAPCELL_ROW_78_2233 VGND VPWR sky130_fd_sc_hd__tapvpwrvgnd_1
XFILLER_71_1192 VGND VGND VPWR VPWR sky130_fd_sc_hd__decap_3
XFILLER_32_1143 VGND VGND VPWR VPWR sky130_fd_sc_hd__decap_3
XFILLER_8_569 VGND VGND VPWR VPWR sky130_fd_sc_hd__decap_3
XFILLER_6_15 VGND VGND VPWR VPWR sky130_fd_sc_hd__decap_3
XTAP_TAPCELL_ROW_74_2119 VGND VPWR sky130_fd_sc_hd__tapvpwrvgnd_1
XFILLER_32_1187 VGND VGND VPWR VPWR sky130_fd_sc_hd__decap_3
XANTENNA_8 _3202_/A VGND VGND VPWR VPWR sky130_fd_sc_hd__diode_2
XFILLER_10_1441 VGND VGND VPWR VPWR sky130_fd_sc_hd__decap_3
XFILLER_67_1228 VGND VGND VPWR VPWR sky130_fd_sc_hd__decap_3
XFILLER_67_1239 VGND VGND VPWR VPWR sky130_fd_sc_hd__decap_3
XFILLER_3_230 VGND VGND VPWR VPWR sky130_fd_sc_hd__decap_3
XFILLER_4_797 VGND VGND VPWR VPWR sky130_fd_sc_hd__decap_3
XFILLER_79_532 VGND VGND VPWR VPWR sky130_fd_sc_hd__decap_3
XFILLER_6_1008 VGND VGND VPWR VPWR sky130_fd_sc_hd__decap_3
XFILLER_39_407 VGND VGND VPWR VPWR sky130_fd_sc_hd__fill_2
XFILLER_0_981 VGND VGND VPWR VPWR sky130_fd_sc_hd__decap_3
XFILLER_13_6 VGND VGND VPWR VPWR sky130_fd_sc_hd__decap_3
XFILLER_43_1272 VGND VGND VPWR VPWR sky130_fd_sc_hd__decap_3
XFILLER_66_259 VGND VGND VPWR VPWR sky130_fd_sc_hd__decap_3
XFILLER_48_974 VGND VGND VPWR VPWR sky130_fd_sc_hd__decap_3
XFILLER_63_900 VGND VGND VPWR VPWR sky130_fd_sc_hd__decap_3
XTAP_TAPCELL_ROW_50_1495 VGND VPWR sky130_fd_sc_hd__tapvpwrvgnd_1
XFILLER_75_782 VGND VGND VPWR VPWR sky130_fd_sc_hd__fill_2
XFILLER_78_1335 VGND VGND VPWR VPWR sky130_fd_sc_hd__decap_3
XFILLER_19_197 VGND VGND VPWR VPWR sky130_fd_sc_hd__decap_3
XFILLER_62_432 VGND VGND VPWR VPWR sky130_fd_sc_hd__decap_3
XFILLER_78_1368 VGND VGND VPWR VPWR sky130_fd_sc_hd__decap_3
XFILLER_39_1319 VGND VGND VPWR VPWR sky130_fd_sc_hd__decap_3
XFILLER_78_1379 VGND VGND VPWR VPWR sky130_fd_sc_hd__decap_3
XFILLER_35_679 VGND VGND VPWR VPWR sky130_fd_sc_hd__decap_3
XFILLER_34_178 VGND VGND VPWR VPWR sky130_fd_sc_hd__decap_3
XFILLER_76_1070 VGND VGND VPWR VPWR sky130_fd_sc_hd__decap_3
XTAP_TAPCELL_ROW_63_1834 VGND VPWR sky130_fd_sc_hd__tapvpwrvgnd_1
XFILLER_62_498 VGND VGND VPWR VPWR sky130_fd_sc_hd__decap_3
XTAP_TAPCELL_ROW_63_1845 VGND VPWR sky130_fd_sc_hd__tapvpwrvgnd_1
X_5740_ _7066_/Q _7068_/Q _5740_/C _5758_/C VGND VGND VPWR VPWR _5747_/S sky130_fd_sc_hd__or4_2
XFILLER_31_852 VGND VGND VPWR VPWR sky130_fd_sc_hd__decap_3
X_5671_ hold875/X _5910_/A0 _5674_/S VGND VGND VPWR VPWR _6725_/D sky130_fd_sc_hd__mux2_1
XFILLER_37_1087 VGND VGND VPWR VPWR sky130_fd_sc_hd__decap_3
XFILLER_31_885 VGND VGND VPWR VPWR sky130_fd_sc_hd__decap_3
XFILLER_30_362 VGND VGND VPWR VPWR sky130_fd_sc_hd__fill_2
X_4622_ _6305_/Q _4621_/X _4622_/S VGND VGND VPWR VPWR _6305_/D sky130_fd_sc_hd__mux2_1
XFILLER_15_1363 VGND VGND VPWR VPWR sky130_fd_sc_hd__decap_3
XFILLER_50_1243 VGND VGND VPWR VPWR sky130_fd_sc_hd__decap_3
XFILLER_11_1216 VGND VGND VPWR VPWR sky130_fd_sc_hd__decap_3
X_4553_ _6874_/Q _4751_/A2 wire36/X _4552_/X VGND VGND VPWR VPWR _4553_/X sky130_fd_sc_hd__a211o_2
XFILLER_50_1276 VGND VGND VPWR VPWR sky130_fd_sc_hd__decap_3
XFILLER_15_1396 VGND VGND VPWR VPWR sky130_fd_sc_hd__decap_3
X_3504_ _6327_/Q _6335_/Q _6343_/Q _6247_/Q _3504_/S0 _4386_/A VGND VGND VPWR VPWR
+ _3504_/X sky130_fd_sc_hd__mux4_2
X_4484_ _6335_/Q wire503/X _3320_/X wire383/X VGND VGND VPWR VPWR _4484_/X sky130_fd_sc_hd__a22o_2
X_3435_ hold979/X _3434_/X _3435_/S VGND VGND VPWR VPWR _6191_/D sky130_fd_sc_hd__mux2_1
X_6223_ _7089_/CLK _6223_/D wire738/X VGND VGND VPWR VPWR _6223_/Q sky130_fd_sc_hd__dfrtp_2
XFILLER_44_1014 VGND VGND VPWR VPWR sky130_fd_sc_hd__decap_3
X_6154_ _7037_/CLK _6154_/D fanout683/X VGND VGND VPWR VPWR _6154_/Q sky130_fd_sc_hd__dfrtp_2
X_3366_ _6302_/Q _6414_/Q VGND VGND VPWR VPWR _3366_/X sky130_fd_sc_hd__xor2_2
X_5105_ _6404_/Q _5282_/B VGND VGND VPWR VPWR _5107_/B sky130_fd_sc_hd__xor2_2
Xhold1203 _6001_/X VGND VGND VPWR VPWR _7005_/D sky130_fd_sc_hd__dlygate4sd3_1
X_6085_ _7096_/Q _7111_/A _6085_/C VGND VGND VPWR VPWR _6085_/X sky130_fd_sc_hd__and3b_2
Xhold1214 _6954_/Q VGND VGND VPWR VPWR _5950_/A1 sky130_fd_sc_hd__dlygate4sd3_1
XFILLER_39_930 VGND VGND VPWR VPWR sky130_fd_sc_hd__fill_1
Xhold1225 _6844_/Q VGND VGND VPWR VPWR _5826_/A1 sky130_fd_sc_hd__dlygate4sd3_1
X_3297_ _5969_/A0 _3296_/X _7087_/D VGND VGND VPWR VPWR _6122_/D sky130_fd_sc_hd__mux2_1
XFILLER_22_1312 VGND VGND VPWR VPWR sky130_fd_sc_hd__decap_3
Xhold1236 _6716_/Q VGND VGND VPWR VPWR _5661_/A1 sky130_fd_sc_hd__dlygate4sd3_1
X_5036_ _6427_/Q _5036_/B VGND VGND VPWR VPWR _5255_/B sky130_fd_sc_hd__xnor2_2
XFILLER_22_1323 VGND VGND VPWR VPWR sky130_fd_sc_hd__decap_3
XFILLER_61_1372 VGND VGND VPWR VPWR sky130_fd_sc_hd__decap_3
Xhold1247 _6841_/Q VGND VGND VPWR VPWR _5822_/A0 sky130_fd_sc_hd__dlygate4sd3_1
XFILLER_2_1406 VGND VGND VPWR VPWR sky130_fd_sc_hd__decap_3
Xhold1258 _6778_/Q VGND VGND VPWR VPWR _5732_/A1 sky130_fd_sc_hd__dlygate4sd3_1
Xhold1269 _6935_/Q VGND VGND VPWR VPWR _5930_/A1 sky130_fd_sc_hd__dlygate4sd3_1
XFILLER_54_900 VGND VGND VPWR VPWR sky130_fd_sc_hd__decap_3
XFILLER_22_1356 VGND VGND VPWR VPWR sky130_fd_sc_hd__decap_3
XTAP_TAPCELL_ROW_0_200 VGND VPWR sky130_fd_sc_hd__tapvpwrvgnd_1
XTAP_TAPCELL_ROW_0_211 VGND VPWR sky130_fd_sc_hd__tapvpwrvgnd_1
XFILLER_26_657 VGND VGND VPWR VPWR sky130_fd_sc_hd__decap_3
XFILLER_65_292 VGND VGND VPWR VPWR sky130_fd_sc_hd__decap_3
XFILLER_0_1130 VGND VGND VPWR VPWR sky130_fd_sc_hd__decap_3
XFILLER_57_1419 VGND VGND VPWR VPWR sky130_fd_sc_hd__decap_3
XFILLER_14_819 VGND VGND VPWR VPWR sky130_fd_sc_hd__fill_2
XFILLER_0_1152 VGND VGND VPWR VPWR sky130_fd_sc_hd__decap_3
XFILLER_25_156 VGND VGND VPWR VPWR sky130_fd_sc_hd__decap_3
XFILLER_25_167 VGND VGND VPWR VPWR sky130_fd_sc_hd__fill_1
X_6987_ _6987_/CLK _6987_/D load_slew837/X VGND VGND VPWR VPWR _6987_/Q sky130_fd_sc_hd__dfrtp_2
XFILLER_80_262 VGND VGND VPWR VPWR sky130_fd_sc_hd__fill_2
XTAP_TAPCELL_ROW_24_814 VGND VPWR sky130_fd_sc_hd__tapvpwrvgnd_1
XTAP_TAPCELL_ROW_24_825 VGND VPWR sky130_fd_sc_hd__tapvpwrvgnd_1
XTAP_TAPCELL_ROW_24_836 VGND VPWR sky130_fd_sc_hd__tapvpwrvgnd_1
X_5938_ _5938_/A0 _6942_/Q _5997_/S VGND VGND VPWR VPWR _5938_/X sky130_fd_sc_hd__mux2_1
XFILLER_55_1132 VGND VGND VPWR VPWR sky130_fd_sc_hd__decap_3
XFILLER_34_690 VGND VGND VPWR VPWR sky130_fd_sc_hd__fill_1
XFILLER_22_841 VGND VGND VPWR VPWR sky130_fd_sc_hd__fill_2
XFILLER_51_1007 VGND VGND VPWR VPWR sky130_fd_sc_hd__fill_1
XFILLER_21_340 VGND VGND VPWR VPWR sky130_fd_sc_hd__fill_1
XFILLER_16_1138 VGND VGND VPWR VPWR sky130_fd_sc_hd__fill_1
X_5869_ _5868_/A _5868_/C _5781_/S VGND VGND VPWR VPWR _5924_/C sky130_fd_sc_hd__a21oi_2
XFILLER_16_1149 VGND VGND VPWR VPWR sky130_fd_sc_hd__decap_3
XFILLER_31_12 VGND VGND VPWR VPWR sky130_fd_sc_hd__fill_1
XFILLER_33_1452 VGND VGND VPWR VPWR sky130_fd_sc_hd__decap_3
XFILLER_33_1463 VGND VGND VPWR VPWR sky130_fd_sc_hd__decap_3
XFILLER_5_517 VGND VGND VPWR VPWR sky130_fd_sc_hd__decap_3
XFILLER_1_712 VGND VGND VPWR VPWR sky130_fd_sc_hd__decap_3
XFILLER_0_200 VGND VGND VPWR VPWR sky130_fd_sc_hd__decap_3
XFILLER_27_1201 VGND VGND VPWR VPWR sky130_fd_sc_hd__fill_2
XFILLER_66_1250 VGND VGND VPWR VPWR sky130_fd_sc_hd__decap_3
XFILLER_66_1261 VGND VGND VPWR VPWR sky130_fd_sc_hd__decap_3
XFILLER_1_756 VGND VGND VPWR VPWR sky130_fd_sc_hd__decap_3
XFILLER_27_1245 VGND VGND VPWR VPWR sky130_fd_sc_hd__decap_3
XFILLER_66_1294 VGND VGND VPWR VPWR sky130_fd_sc_hd__decap_3
XFILLER_62_1136 VGND VGND VPWR VPWR sky130_fd_sc_hd__decap_3
XTAP_TAPCELL_ROW_8_399 VGND VPWR sky130_fd_sc_hd__tapvpwrvgnd_1
XFILLER_7_1328 VGND VGND VPWR VPWR sky130_fd_sc_hd__decap_3
XFILLER_49_727 VGND VGND VPWR VPWR sky130_fd_sc_hd__fill_1
XFILLER_0_277 VGND VGND VPWR VPWR sky130_fd_sc_hd__decap_3
XFILLER_27_1278 VGND VGND VPWR VPWR sky130_fd_sc_hd__decap_3
XFILLER_49_738 VGND VGND VPWR VPWR sky130_fd_sc_hd__decap_3
XFILLER_27_1289 VGND VGND VPWR VPWR sky130_fd_sc_hd__decap_3
XFILLER_48_226 VGND VGND VPWR VPWR sky130_fd_sc_hd__decap_3
XFILLER_0_299 VGND VGND VPWR VPWR sky130_fd_sc_hd__decap_3
XFILLER_40_1412 VGND VGND VPWR VPWR sky130_fd_sc_hd__decap_3
XFILLER_48_259 VGND VGND VPWR VPWR sky130_fd_sc_hd__decap_3
XFILLER_5_1052 VGND VGND VPWR VPWR sky130_fd_sc_hd__decap_3
XFILLER_40_1456 VGND VGND VPWR VPWR sky130_fd_sc_hd__decap_3
XFILLER_45_911 VGND VGND VPWR VPWR sky130_fd_sc_hd__decap_3
XFILLER_5_1074 VGND VGND VPWR VPWR sky130_fd_sc_hd__decap_3
XFILLER_17_613 VGND VGND VPWR VPWR sky130_fd_sc_hd__decap_3
XFILLER_57_782 VGND VGND VPWR VPWR sky130_fd_sc_hd__fill_2
XFILLER_57_793 VGND VGND VPWR VPWR sky130_fd_sc_hd__decap_3
XFILLER_29_495 VGND VGND VPWR VPWR sky130_fd_sc_hd__decap_3
XFILLER_44_421 VGND VGND VPWR VPWR sky130_fd_sc_hd__decap_3
XFILLER_16_123 VGND VGND VPWR VPWR sky130_fd_sc_hd__decap_3
XFILLER_72_752 VGND VGND VPWR VPWR sky130_fd_sc_hd__decap_3
XFILLER_72_763 VGND VGND VPWR VPWR sky130_fd_sc_hd__decap_3
XFILLER_44_465 VGND VGND VPWR VPWR sky130_fd_sc_hd__decap_3
XFILLER_71_262 VGND VGND VPWR VPWR sky130_fd_sc_hd__decap_3
XFILLER_73_1210 VGND VGND VPWR VPWR sky130_fd_sc_hd__decap_3
XFILLER_72_41 VGND VGND VPWR VPWR sky130_fd_sc_hd__decap_3
XFILLER_77_1390 VGND VGND VPWR VPWR sky130_fd_sc_hd__decap_3
XFILLER_71_284 VGND VGND VPWR VPWR sky130_fd_sc_hd__decap_3
XFILLER_38_1341 VGND VGND VPWR VPWR sky130_fd_sc_hd__decap_3
XFILLER_31_137 VGND VGND VPWR VPWR sky130_fd_sc_hd__decap_3
XFILLER_73_1254 VGND VGND VPWR VPWR sky130_fd_sc_hd__decap_3
XFILLER_34_1205 VGND VGND VPWR VPWR sky130_fd_sc_hd__fill_1
XFILLER_72_85 VGND VGND VPWR VPWR sky130_fd_sc_hd__fill_2
XFILLER_38_1385 VGND VGND VPWR VPWR sky130_fd_sc_hd__decap_3
XFILLER_73_1287 VGND VGND VPWR VPWR sky130_fd_sc_hd__fill_1
XFILLER_73_1298 VGND VGND VPWR VPWR sky130_fd_sc_hd__decap_3
XFILLER_9_856 VGND VGND VPWR VPWR sky130_fd_sc_hd__decap_3
XFILLER_40_682 VGND VGND VPWR VPWR sky130_fd_sc_hd__decap_3
XFILLER_8_333 VGND VGND VPWR VPWR sky130_fd_sc_hd__decap_3
XFILLER_9_889 VGND VGND VPWR VPWR sky130_fd_sc_hd__decap_3
XFILLER_4_572 VGND VGND VPWR VPWR sky130_fd_sc_hd__decap_3
XFILLER_10_1282 VGND VGND VPWR VPWR sky130_fd_sc_hd__decap_3
XFILLER_45_1301 VGND VGND VPWR VPWR sky130_fd_sc_hd__decap_3
XTAP_TAPCELL_ROW_56_1660 VGND VPWR sky130_fd_sc_hd__tapvpwrvgnd_1
X_3220_ _3223_/A1 _3218_/X _3219_/X _3220_/C1 VGND VGND VPWR VPWR _3220_/X sky130_fd_sc_hd__a211o_2
XFILLER_80_1214 VGND VGND VPWR VPWR sky130_fd_sc_hd__decap_3
XFILLER_45_1334 VGND VGND VPWR VPWR sky130_fd_sc_hd__decap_3
XFILLER_45_1345 VGND VGND VPWR VPWR sky130_fd_sc_hd__decap_3
XFILLER_80_1236 VGND VGND VPWR VPWR sky130_fd_sc_hd__decap_3
XFILLER_39_204 VGND VGND VPWR VPWR sky130_fd_sc_hd__decap_3
XTAP_TAPCELL_ROW_52_1546 VGND VPWR sky130_fd_sc_hd__tapvpwrvgnd_1
XTAP_TAPCELL_ROW_52_1557 VGND VPWR sky130_fd_sc_hd__tapvpwrvgnd_1
X_3151_ _6996_/Q wire419/X _3150_/X VGND VGND VPWR VPWR _3151_/X sky130_fd_sc_hd__a21o_2
XFILLER_45_1378 VGND VGND VPWR VPWR sky130_fd_sc_hd__decap_3
XFILLER_39_237 VGND VGND VPWR VPWR sky130_fd_sc_hd__decap_3
XFILLER_11_3 VGND VGND VPWR VPWR sky130_fd_sc_hd__decap_3
XFILLER_39_259 VGND VGND VPWR VPWR sky130_fd_sc_hd__decap_3
X_3082_ _3601_/A _3550_/B VGND VGND VPWR VPWR _3082_/X sky130_fd_sc_hd__and2_2
X_6910_ _6910_/CLK _6910_/D fanout779/X VGND VGND VPWR VPWR _6910_/Q sky130_fd_sc_hd__dfrtp_2
XFILLER_78_1132 VGND VGND VPWR VPWR sky130_fd_sc_hd__decap_3
XFILLER_63_741 VGND VGND VPWR VPWR sky130_fd_sc_hd__decap_3
XFILLER_35_443 VGND VGND VPWR VPWR sky130_fd_sc_hd__decap_3
X_6841_ _6905_/CLK _6841_/D wire738/X VGND VGND VPWR VPWR _6841_/Q sky130_fd_sc_hd__dfrtp_2
XFILLER_78_1176 VGND VGND VPWR VPWR sky130_fd_sc_hd__decap_3
XTAP_TAPCELL_ROW_18_663 VGND VPWR sky130_fd_sc_hd__tapvpwrvgnd_1
XFILLER_63_785 VGND VGND VPWR VPWR sky130_fd_sc_hd__decap_3
XTAP_TAPCELL_ROW_18_674 VGND VPWR sky130_fd_sc_hd__tapvpwrvgnd_1
XFILLER_51_936 VGND VGND VPWR VPWR sky130_fd_sc_hd__decap_3
XFILLER_56_1441 VGND VGND VPWR VPWR sky130_fd_sc_hd__decap_3
X_6772_ _6772_/CLK _6772_/D fanout832/X VGND VGND VPWR VPWR _6772_/Q sky130_fd_sc_hd__dfrtp_2
X_3984_ _4088_/A1 _3717_/Y _4312_/B _3958_/Y _6532_/Q VGND VGND VPWR VPWR _3984_/X
+ sky130_fd_sc_hd__a32o_2
XFILLER_17_1425 VGND VGND VPWR VPWR sky130_fd_sc_hd__decap_3
X_5723_ _5889_/A0 _5723_/A1 _5730_/S VGND VGND VPWR VPWR _6770_/D sky130_fd_sc_hd__mux2_1
XFILLER_52_1338 VGND VGND VPWR VPWR sky130_fd_sc_hd__decap_3
X_5654_ _5654_/A0 _5902_/A0 _5657_/S VGND VGND VPWR VPWR _6710_/D sky130_fd_sc_hd__mux2_1
XFILLER_50_1040 VGND VGND VPWR VPWR sky130_fd_sc_hd__fill_1
X_4605_ _6327_/Q _5358_/D _3368_/X _4780_/B2 VGND VGND VPWR VPWR _4605_/X sky130_fd_sc_hd__a22o_2
X_5585_ _5591_/A2 _5569_/Y _5592_/B1 _5585_/B2 VGND VGND VPWR VPWR _6658_/D sky130_fd_sc_hd__a22o_2
X_4536_ _4532_/X _4533_/X _4535_/Y _4889_/A VGND VGND VPWR VPWR _4536_/X sky130_fd_sc_hd__o211a_2
X_4467_ _4526_/B wire31/X VGND VGND VPWR VPWR _4467_/Y sky130_fd_sc_hd__nor2_2
XFILLER_63_1401 VGND VGND VPWR VPWR sky130_fd_sc_hd__decap_3
Xfanout802 fanout803/X VGND VGND VPWR VPWR fanout802/X sky130_fd_sc_hd__clkdlybuf4s25_1
X_6206_ _6929_/CLK _6206_/D load_slew707/X VGND VGND VPWR VPWR _6206_/Q sky130_fd_sc_hd__dfrtp_2
X_3418_ _6320_/Q _6440_/Q VGND VGND VPWR VPWR _3418_/X sky130_fd_sc_hd__xor2_2
Xfanout824 wire827/A VGND VGND VPWR VPWR fanout824/X sky130_fd_sc_hd__clkdlybuf4s25_1
X_4398_ _3486_/B _4395_/X _4396_/Y _4397_/X _4582_/A VGND VGND VPWR VPWR _4398_/X
+ sky130_fd_sc_hd__o221a_2
XFILLER_63_1434 VGND VGND VPWR VPWR sky130_fd_sc_hd__decap_3
Xfanout835 fanout846/X VGND VGND VPWR VPWR fanout835/X sky130_fd_sc_hd__clkdlybuf4s25_1
Xfanout846 fanout847/X VGND VGND VPWR VPWR fanout846/X sky130_fd_sc_hd__clkdlybuf4s25_1
XTAP_TAPCELL_ROW_5_325 VGND VPWR sky130_fd_sc_hd__tapvpwrvgnd_1
XFILLER_58_513 VGND VGND VPWR VPWR sky130_fd_sc_hd__decap_3
XTAP_TAPCELL_ROW_5_336 VGND VPWR sky130_fd_sc_hd__tapvpwrvgnd_1
XFILLER_24_1418 VGND VGND VPWR VPWR sky130_fd_sc_hd__decap_3
X_6137_ _6988_/CLK _6137_/D load_slew808/X VGND VGND VPWR VPWR _6137_/Q sky130_fd_sc_hd__dfrtp_2
Xhold1000 _6200_/Q VGND VGND VPWR VPWR _6047_/A0 sky130_fd_sc_hd__dlygate4sd3_1
X_3349_ hold939/X _3348_/X _3413_/S VGND VGND VPWR VPWR _6148_/D sky130_fd_sc_hd__mux2_1
XFILLER_24_1429 VGND VGND VPWR VPWR sky130_fd_sc_hd__decap_3
Xhold1011 _6122_/Q VGND VGND VPWR VPWR _5969_/A0 sky130_fd_sc_hd__dlygate4sd3_1
Xhold1022 _6160_/Q VGND VGND VPWR VPWR _6007_/A0 sky130_fd_sc_hd__dlygate4sd3_1
Xload_slew280 _4405_/B VGND VGND VPWR VPWR _3991_/B sky130_fd_sc_hd__buf_2
Xhold1033 _6168_/Q VGND VGND VPWR VPWR _6015_/A0 sky130_fd_sc_hd__dlygate4sd3_1
XFILLER_6_1350 VGND VGND VPWR VPWR sky130_fd_sc_hd__decap_3
Xhold1044 _6636_/Q VGND VGND VPWR VPWR _5553_/B1 sky130_fd_sc_hd__dlygate4sd3_1
XFILLER_46_719 VGND VGND VPWR VPWR sky130_fd_sc_hd__decap_3
XFILLER_39_760 VGND VGND VPWR VPWR sky130_fd_sc_hd__fill_1
X_6068_ _6073_/D _6085_/C VGND VGND VPWR VPWR _6068_/X sky130_fd_sc_hd__and2_2
XFILLER_2_1203 VGND VGND VPWR VPWR sky130_fd_sc_hd__fill_1
Xhold1055 _6103_/Q VGND VGND VPWR VPWR _5950_/A0 sky130_fd_sc_hd__dlygate4sd3_1
XFILLER_2_1214 VGND VGND VPWR VPWR sky130_fd_sc_hd__decap_3
Xhold1066 _5955_/X VGND VGND VPWR VPWR _6959_/D sky130_fd_sc_hd__dlygate4sd3_1
XFILLER_6_1394 VGND VGND VPWR VPWR sky130_fd_sc_hd__decap_3
Xhold1077 _6966_/Q VGND VGND VPWR VPWR _5962_/A1 sky130_fd_sc_hd__dlygate4sd3_1
X_5019_ _6698_/Q _3064_/Y _5326_/S VGND VGND VPWR VPWR _5019_/X sky130_fd_sc_hd__mux2_1
XFILLER_27_933 VGND VGND VPWR VPWR sky130_fd_sc_hd__decap_3
Xhold1088 _6719_/Q VGND VGND VPWR VPWR _5664_/A1 sky130_fd_sc_hd__dlygate4sd3_1
XFILLER_26_421 VGND VGND VPWR VPWR sky130_fd_sc_hd__fill_1
Xhold1099 _6975_/Q VGND VGND VPWR VPWR _5971_/A1 sky130_fd_sc_hd__dlygate4sd3_1
XFILLER_2_1247 VGND VGND VPWR VPWR sky130_fd_sc_hd__decap_3
XFILLER_38_281 VGND VGND VPWR VPWR sky130_fd_sc_hd__decap_3
XFILLER_54_741 VGND VGND VPWR VPWR sky130_fd_sc_hd__decap_3
XFILLER_26_454 VGND VGND VPWR VPWR sky130_fd_sc_hd__decap_3
XFILLER_53_240 VGND VGND VPWR VPWR sky130_fd_sc_hd__decap_3
XFILLER_14_605 VGND VGND VPWR VPWR sky130_fd_sc_hd__decap_3
XFILLER_26_465 VGND VGND VPWR VPWR sky130_fd_sc_hd__fill_2
XFILLER_42_925 VGND VGND VPWR VPWR sky130_fd_sc_hd__fill_1
XFILLER_41_424 VGND VGND VPWR VPWR sky130_fd_sc_hd__decap_3
XFILLER_42_958 VGND VGND VPWR VPWR sky130_fd_sc_hd__decap_3
XFILLER_13_148 VGND VGND VPWR VPWR sky130_fd_sc_hd__decap_3
XFILLER_41_479 VGND VGND VPWR VPWR sky130_fd_sc_hd__fill_2
XFILLER_70_1427 VGND VGND VPWR VPWR sky130_fd_sc_hd__fill_1
XFILLER_70_1438 VGND VGND VPWR VPWR sky130_fd_sc_hd__decap_3
XFILLER_42_55 VGND VGND VPWR VPWR sky130_fd_sc_hd__decap_3
XFILLER_10_833 VGND VGND VPWR VPWR sky130_fd_sc_hd__fill_2
XFILLER_42_77 VGND VGND VPWR VPWR sky130_fd_sc_hd__decap_3
XFILLER_6_804 VGND VGND VPWR VPWR sky130_fd_sc_hd__fill_1
XFILLER_42_88 VGND VGND VPWR VPWR sky130_fd_sc_hd__decap_3
XFILLER_33_1260 VGND VGND VPWR VPWR sky130_fd_sc_hd__decap_3
XFILLER_68_1312 VGND VGND VPWR VPWR sky130_fd_sc_hd__decap_3
XFILLER_68_1323 VGND VGND VPWR VPWR sky130_fd_sc_hd__decap_3
XFILLER_29_1307 VGND VGND VPWR VPWR sky130_fd_sc_hd__decap_3
XFILLER_68_1356 VGND VGND VPWR VPWR sky130_fd_sc_hd__decap_3
XFILLER_1_520 VGND VGND VPWR VPWR sky130_fd_sc_hd__decap_3
XFILLER_3_27 VGND VGND VPWR VPWR sky130_fd_sc_hd__decap_3
XFILLER_1_564 VGND VGND VPWR VPWR sky130_fd_sc_hd__decap_3
XFILLER_27_1042 VGND VGND VPWR VPWR sky130_fd_sc_hd__fill_1
XFILLER_49_502 VGND VGND VPWR VPWR sky130_fd_sc_hd__fill_2
XFILLER_66_1091 VGND VGND VPWR VPWR sky130_fd_sc_hd__fill_1
XFILLER_67_30 VGND VGND VPWR VPWR sky130_fd_sc_hd__decap_3
XFILLER_7_1136 VGND VGND VPWR VPWR sky130_fd_sc_hd__decap_3
XFILLER_49_535 VGND VGND VPWR VPWR sky130_fd_sc_hd__decap_3
XTAP_TAPCELL_ROW_69_2007 VGND VPWR sky130_fd_sc_hd__tapvpwrvgnd_1
XFILLER_67_63 VGND VGND VPWR VPWR sky130_fd_sc_hd__decap_3
XFILLER_7_1169 VGND VGND VPWR VPWR sky130_fd_sc_hd__decap_3
XFILLER_37_708 VGND VGND VPWR VPWR sky130_fd_sc_hd__decap_3
XFILLER_36_218 VGND VGND VPWR VPWR sky130_fd_sc_hd__decap_3
XFILLER_76_398 VGND VGND VPWR VPWR sky130_fd_sc_hd__decap_3
XFILLER_40_1264 VGND VGND VPWR VPWR sky130_fd_sc_hd__decap_3
XFILLER_29_281 VGND VGND VPWR VPWR sky130_fd_sc_hd__decap_3
XFILLER_79_1452 VGND VGND VPWR VPWR sky130_fd_sc_hd__decap_3
XFILLER_45_741 VGND VGND VPWR VPWR sky130_fd_sc_hd__decap_3
XFILLER_79_1463 VGND VGND VPWR VPWR sky130_fd_sc_hd__decap_3
XFILLER_40_1297 VGND VGND VPWR VPWR sky130_fd_sc_hd__decap_3
XFILLER_45_763 VGND VGND VPWR VPWR sky130_fd_sc_hd__decap_3
XFILLER_75_1316 VGND VGND VPWR VPWR sky130_fd_sc_hd__decap_3
XFILLER_44_251 VGND VGND VPWR VPWR sky130_fd_sc_hd__fill_1
XFILLER_17_476 VGND VGND VPWR VPWR sky130_fd_sc_hd__decap_3
XFILLER_32_402 VGND VGND VPWR VPWR sky130_fd_sc_hd__decap_3
XFILLER_45_785 VGND VGND VPWR VPWR sky130_fd_sc_hd__decap_3
XTAP_TAPCELL_ROW_15_600 VGND VPWR sky130_fd_sc_hd__tapvpwrvgnd_1
XFILLER_33_947 VGND VGND VPWR VPWR sky130_fd_sc_hd__decap_3
XFILLER_32_435 VGND VGND VPWR VPWR sky130_fd_sc_hd__decap_3
XTAP_TAPCELL_ROW_45_1361 VGND VPWR sky130_fd_sc_hd__tapvpwrvgnd_1
XFILLER_34_1013 VGND VGND VPWR VPWR sky130_fd_sc_hd__fill_1
XTAP_TAPCELL_ROW_45_1372 VGND VPWR sky130_fd_sc_hd__tapvpwrvgnd_1
XTAP_TAPCELL_ROW_45_1383 VGND VPWR sky130_fd_sc_hd__tapvpwrvgnd_1
XFILLER_80_6 VGND VGND VPWR VPWR sky130_fd_sc_hd__decap_3
XFILLER_34_1046 VGND VGND VPWR VPWR sky130_fd_sc_hd__decap_3
XFILLER_9_664 VGND VGND VPWR VPWR sky130_fd_sc_hd__decap_3
XTAP_TAPCELL_ROW_41_1258 VGND VPWR sky130_fd_sc_hd__tapvpwrvgnd_1
XFILLER_12_1300 VGND VGND VPWR VPWR sky130_fd_sc_hd__decap_3
XFILLER_8_141 VGND VGND VPWR VPWR sky130_fd_sc_hd__fill_2
XTAP_TAPCELL_ROW_41_1269 VGND VPWR sky130_fd_sc_hd__tapvpwrvgnd_1
XFILLER_51_1360 VGND VGND VPWR VPWR sky130_fd_sc_hd__decap_3
XFILLER_8_163 VGND VGND VPWR VPWR sky130_fd_sc_hd__decap_3
XTAP_TAPCELL_ROW_58_1700 VGND VPWR sky130_fd_sc_hd__tapvpwrvgnd_1
XFILLER_12_1344 VGND VGND VPWR VPWR sky130_fd_sc_hd__decap_3
XFILLER_51_1393 VGND VGND VPWR VPWR sky130_fd_sc_hd__decap_3
XTAP_TAPCELL_ROW_58_1711 VGND VPWR sky130_fd_sc_hd__tapvpwrvgnd_1
X_5370_ _5370_/A1 _5465_/A2 _4214_/X VGND VGND VPWR VPWR _6482_/D sky130_fd_sc_hd__a21o_2
XFILLER_59_3 VGND VGND VPWR VPWR sky130_fd_sc_hd__decap_3
XFILLER_12_1388 VGND VGND VPWR VPWR sky130_fd_sc_hd__decap_3
XFILLER_47_1407 VGND VGND VPWR VPWR sky130_fd_sc_hd__decap_3
X_4321_ _6340_/Q wire507/X _3266_/X _4875_/B2 VGND VGND VPWR VPWR _4321_/X sky130_fd_sc_hd__a22o_2
XTAP_TAPCELL_ROW_54_1608 VGND VPWR sky130_fd_sc_hd__tapvpwrvgnd_1
XFILLER_10_1090 VGND VGND VPWR VPWR sky130_fd_sc_hd__fill_2
Xfanout109 fanout121/X VGND VGND VPWR VPWR _5293_/A2 sky130_fd_sc_hd__clkdlybuf4s25_1
X_4252_ _6486_/Q _3483_/A _4788_/A _4251_/Y VGND VGND VPWR VPWR _4252_/X sky130_fd_sc_hd__o211a_2
X_7040_ _7040_/CLK _7040_/D fanout716/X VGND VGND VPWR VPWR _7040_/Q sky130_fd_sc_hd__dfrtp_2
X_3203_ _7016_/Q _7024_/Q _3203_/S VGND VGND VPWR VPWR _3203_/X sky130_fd_sc_hd__mux2_1
X_4183_ _4230_/B _4183_/B VGND VGND VPWR VPWR _4777_/B sky130_fd_sc_hd__xnor2_2
XFILLER_80_1055 VGND VGND VPWR VPWR sky130_fd_sc_hd__decap_3
XFILLER_41_1006 VGND VGND VPWR VPWR sky130_fd_sc_hd__fill_2
XFILLER_41_1017 VGND VGND VPWR VPWR sky130_fd_sc_hd__decap_3
XFILLER_45_1186 VGND VGND VPWR VPWR sky130_fd_sc_hd__decap_3
XFILLER_80_1077 VGND VGND VPWR VPWR sky130_fd_sc_hd__decap_3
XFILLER_67_343 VGND VGND VPWR VPWR sky130_fd_sc_hd__decap_3
X_3134_ _3193_/A1 _3132_/X _3133_/X _3213_/C1 VGND VGND VPWR VPWR _3134_/X sky130_fd_sc_hd__a211o_2
XFILLER_55_505 VGND VGND VPWR VPWR sky130_fd_sc_hd__fill_1
XFILLER_80_1099 VGND VGND VPWR VPWR sky130_fd_sc_hd__decap_3
XFILLER_23_1440 VGND VGND VPWR VPWR sky130_fd_sc_hd__decap_3
X_3065_ _6361_/Q VGND VGND VPWR VPWR _3065_/Y sky130_fd_sc_hd__inv_2
XFILLER_55_549 VGND VGND VPWR VPWR sky130_fd_sc_hd__decap_3
XFILLER_35_240 VGND VGND VPWR VPWR sky130_fd_sc_hd__decap_3
XFILLER_51_700 VGND VGND VPWR VPWR sky130_fd_sc_hd__decap_3
XFILLER_23_402 VGND VGND VPWR VPWR sky130_fd_sc_hd__decap_3
XFILLER_24_925 VGND VGND VPWR VPWR sky130_fd_sc_hd__decap_3
X_6824_ _6888_/CLK _6824_/D load_slew664/X VGND VGND VPWR VPWR _6824_/Q sky130_fd_sc_hd__dfrtp_2
XFILLER_35_284 VGND VGND VPWR VPWR sky130_fd_sc_hd__fill_2
XFILLER_50_210 VGND VGND VPWR VPWR sky130_fd_sc_hd__decap_3
XFILLER_50_221 VGND VGND VPWR VPWR sky130_fd_sc_hd__decap_3
XFILLER_11_608 VGND VGND VPWR VPWR sky130_fd_sc_hd__decap_3
XFILLER_17_1211 VGND VGND VPWR VPWR sky130_fd_sc_hd__decap_3
XFILLER_51_777 VGND VGND VPWR VPWR sky130_fd_sc_hd__fill_2
XFILLER_52_1102 VGND VGND VPWR VPWR sky130_fd_sc_hd__decap_3
X_6755_ _7011_/CLK _6755_/D fanout816/X VGND VGND VPWR VPWR _6755_/Q sky130_fd_sc_hd__dfrtp_2
XFILLER_51_788 VGND VGND VPWR VPWR sky130_fd_sc_hd__decap_3
XFILLER_17_1233 VGND VGND VPWR VPWR sky130_fd_sc_hd__decap_3
XFILLER_56_1282 VGND VGND VPWR VPWR sky130_fd_sc_hd__decap_3
X_3967_ _4065_/B _3991_/B VGND VGND VPWR VPWR _3967_/Y sky130_fd_sc_hd__nor2_2
XFILLER_17_1266 VGND VGND VPWR VPWR sky130_fd_sc_hd__decap_3
X_5706_ _5908_/A0 _5706_/A1 wire89/X VGND VGND VPWR VPWR _6755_/D sky130_fd_sc_hd__mux2_1
X_6686_ _7009_/CLK _6686_/D fanout765/X VGND VGND VPWR VPWR _6686_/Q sky130_fd_sc_hd__dfrtp_2
Xclkbuf_leaf_30_clk clkbuf_4_6__f_clk/X VGND VGND VPWR VPWR _7089_/CLK sky130_fd_sc_hd__clkbuf_8
XFILLER_13_1119 VGND VGND VPWR VPWR sky130_fd_sc_hd__fill_1
X_3898_ _3927_/A_N _6301_/Q VGND VGND VPWR VPWR _3898_/X sky130_fd_sc_hd__and2b_2
XFILLER_30_1400 VGND VGND VPWR VPWR sky130_fd_sc_hd__decap_3
XFILLER_52_1179 VGND VGND VPWR VPWR sky130_fd_sc_hd__decap_3
X_5637_ _5913_/A0 _5637_/A1 wire93/A VGND VGND VPWR VPWR _6696_/D sky130_fd_sc_hd__mux2_1
XFILLER_30_1444 VGND VGND VPWR VPWR sky130_fd_sc_hd__decap_3
XFILLER_3_818 VGND VGND VPWR VPWR sky130_fd_sc_hd__decap_3
X_5568_ _5567_/A _5574_/A2 _5567_/Y VGND VGND VPWR VPWR _5568_/Y sky130_fd_sc_hd__a21oi_2
XFILLER_2_306 VGND VGND VPWR VPWR sky130_fd_sc_hd__fill_2
X_4519_ _6524_/Q _4518_/A _4817_/A1 VGND VGND VPWR VPWR _4519_/X sky130_fd_sc_hd__a21bo_2
XFILLER_2_339 VGND VGND VPWR VPWR sky130_fd_sc_hd__decap_3
X_5499_ _6603_/Q _5499_/B VGND VGND VPWR VPWR _5499_/Y sky130_fd_sc_hd__nor2_2
Xfanout610 wire613/X VGND VGND VPWR VPWR _5664_/A0 sky130_fd_sc_hd__clkdlybuf4s25_1
Xfanout621 input5/X VGND VGND VPWR VPWR _5928_/A0 sky130_fd_sc_hd__clkdlybuf4s25_1
XFILLER_8_1412 VGND VGND VPWR VPWR sky130_fd_sc_hd__decap_3
XFILLER_63_1242 VGND VGND VPWR VPWR sky130_fd_sc_hd__decap_3
XFILLER_28_1362 VGND VGND VPWR VPWR sky130_fd_sc_hd__decap_3
XFILLER_28_1373 VGND VGND VPWR VPWR sky130_fd_sc_hd__decap_3
Xfanout654 fanout666/X VGND VGND VPWR VPWR wire655/A sky130_fd_sc_hd__clkdlybuf4s25_1
XFILLER_8_1456 VGND VGND VPWR VPWR sky130_fd_sc_hd__decap_3
Xfanout665 fanout666/X VGND VGND VPWR VPWR fanout665/X sky130_fd_sc_hd__clkdlybuf4s25_1
XFILLER_63_1275 VGND VGND VPWR VPWR sky130_fd_sc_hd__decap_3
Xfanout676 fanout678/X VGND VGND VPWR VPWR fanout676/X sky130_fd_sc_hd__clkdlybuf4s25_1
XFILLER_59_866 VGND VGND VPWR VPWR sky130_fd_sc_hd__decap_3
XFILLER_4_1309 VGND VGND VPWR VPWR sky130_fd_sc_hd__decap_3
XFILLER_58_354 VGND VGND VPWR VPWR sky130_fd_sc_hd__decap_3
Xfanout698 fanout848/X VGND VGND VPWR VPWR fanout698/X sky130_fd_sc_hd__clkdlybuf4s25_1
XFILLER_24_1259 VGND VGND VPWR VPWR sky130_fd_sc_hd__fill_1
XFILLER_46_505 VGND VGND VPWR VPWR sky130_fd_sc_hd__decap_3
XFILLER_74_825 VGND VGND VPWR VPWR sky130_fd_sc_hd__fill_1
XFILLER_74_847 VGND VGND VPWR VPWR sky130_fd_sc_hd__fill_2
XFILLER_37_55 VGND VGND VPWR VPWR sky130_fd_sc_hd__fill_1
XFILLER_2_1011 VGND VGND VPWR VPWR sky130_fd_sc_hd__decap_3
XFILLER_6_1191 VGND VGND VPWR VPWR sky130_fd_sc_hd__decap_3
XFILLER_74_869 VGND VGND VPWR VPWR sky130_fd_sc_hd__decap_3
XFILLER_37_88 VGND VGND VPWR VPWR sky130_fd_sc_hd__decap_3
XFILLER_2_1055 VGND VGND VPWR VPWR sky130_fd_sc_hd__decap_3
XFILLER_73_368 VGND VGND VPWR VPWR sky130_fd_sc_hd__decap_3
XFILLER_15_903 VGND VGND VPWR VPWR sky130_fd_sc_hd__fill_2
XFILLER_27_785 VGND VGND VPWR VPWR sky130_fd_sc_hd__decap_3
XFILLER_54_560 VGND VGND VPWR VPWR sky130_fd_sc_hd__fill_1
XFILLER_2_1088 VGND VGND VPWR VPWR sky130_fd_sc_hd__decap_3
XFILLER_2_1099 VGND VGND VPWR VPWR sky130_fd_sc_hd__decap_3
XFILLER_14_424 VGND VGND VPWR VPWR sky130_fd_sc_hd__decap_3
XFILLER_15_969 VGND VGND VPWR VPWR sky130_fd_sc_hd__decap_3
XFILLER_53_43 VGND VGND VPWR VPWR sky130_fd_sc_hd__decap_3
XFILLER_57_1057 VGND VGND VPWR VPWR sky130_fd_sc_hd__decap_3
XFILLER_57_1068 VGND VGND VPWR VPWR sky130_fd_sc_hd__decap_3
XFILLER_41_243 VGND VGND VPWR VPWR sky130_fd_sc_hd__decap_3
XFILLER_30_917 VGND VGND VPWR VPWR sky130_fd_sc_hd__decap_3
XFILLER_74_1371 VGND VGND VPWR VPWR sky130_fd_sc_hd__fill_1
XFILLER_35_1322 VGND VGND VPWR VPWR sky130_fd_sc_hd__decap_3
XFILLER_74_1382 VGND VGND VPWR VPWR sky130_fd_sc_hd__decap_3
XFILLER_70_1235 VGND VGND VPWR VPWR sky130_fd_sc_hd__decap_3
XFILLER_35_1366 VGND VGND VPWR VPWR sky130_fd_sc_hd__decap_3
Xclkbuf_leaf_21_clk clkload2/A VGND VGND VPWR VPWR _7096_/CLK sky130_fd_sc_hd__clkbuf_8
XFILLER_70_1279 VGND VGND VPWR VPWR sky130_fd_sc_hd__decap_3
XFILLER_35_1399 VGND VGND VPWR VPWR sky130_fd_sc_hd__fill_1
XFILLER_6_623 VGND VGND VPWR VPWR sky130_fd_sc_hd__decap_3
XFILLER_5_111 VGND VGND VPWR VPWR sky130_fd_sc_hd__fill_1
XFILLER_10_696 VGND VGND VPWR VPWR sky130_fd_sc_hd__decap_3
XFILLER_6_656 VGND VGND VPWR VPWR sky130_fd_sc_hd__decap_3
XFILLER_45_9 VGND VGND VPWR VPWR sky130_fd_sc_hd__fill_1
XFILLER_68_1175 VGND VGND VPWR VPWR sky130_fd_sc_hd__decap_3
XFILLER_2_840 VGND VGND VPWR VPWR sky130_fd_sc_hd__decap_3
XFILLER_29_1148 VGND VGND VPWR VPWR sky130_fd_sc_hd__decap_3
XFILLER_78_62 VGND VGND VPWR VPWR sky130_fd_sc_hd__decap_3
XFILLER_2_884 VGND VGND VPWR VPWR sky130_fd_sc_hd__decap_3
XFILLER_1_361 VGND VGND VPWR VPWR sky130_fd_sc_hd__decap_3
XFILLER_46_1462 VGND VGND VPWR VPWR sky130_fd_sc_hd__decap_3
XFILLER_68_129 VGND VGND VPWR VPWR sky130_fd_sc_hd__decap_3
XFILLER_42_1315 VGND VGND VPWR VPWR sky130_fd_sc_hd__fill_1
XFILLER_77_641 VGND VGND VPWR VPWR sky130_fd_sc_hd__decap_3
XFILLER_42_1326 VGND VGND VPWR VPWR sky130_fd_sc_hd__decap_3
XTAP_TAPCELL_ROW_34_1073 VGND VPWR sky130_fd_sc_hd__tapvpwrvgnd_1
XTAP_TAPCELL_ROW_34_1084 VGND VPWR sky130_fd_sc_hd__tapvpwrvgnd_1
XFILLER_37_505 VGND VGND VPWR VPWR sky130_fd_sc_hd__decap_3
XFILLER_65_814 VGND VGND VPWR VPWR sky130_fd_sc_hd__decap_3
XTAP_TAPCELL_ROW_34_1095 VGND VPWR sky130_fd_sc_hd__tapvpwrvgnd_1
XFILLER_42_1359 VGND VGND VPWR VPWR sky130_fd_sc_hd__decap_3
XFILLER_64_302 VGND VGND VPWR VPWR sky130_fd_sc_hd__decap_3
XFILLER_37_527 VGND VGND VPWR VPWR sky130_fd_sc_hd__fill_2
XFILLER_18_730 VGND VGND VPWR VPWR sky130_fd_sc_hd__decap_3
XFILLER_79_1260 VGND VGND VPWR VPWR sky130_fd_sc_hd__decap_3
XFILLER_75_1102 VGND VGND VPWR VPWR sky130_fd_sc_hd__decap_3
XTAP_TAPCELL_ROW_47_1412 VGND VPWR sky130_fd_sc_hd__tapvpwrvgnd_1
XTAP_TAPCELL_ROW_47_1423 VGND VPWR sky130_fd_sc_hd__tapvpwrvgnd_1
XFILLER_75_1124 VGND VGND VPWR VPWR sky130_fd_sc_hd__decap_3
XTAP_TAPCELL_ROW_47_1434 VGND VPWR sky130_fd_sc_hd__tapvpwrvgnd_1
XFILLER_17_284 VGND VGND VPWR VPWR sky130_fd_sc_hd__fill_2
XFILLER_75_1157 VGND VGND VPWR VPWR sky130_fd_sc_hd__decap_3
X_4870_ _6339_/Q wire49/X _4867_/X _4869_/X VGND VGND VPWR VPWR _6339_/D sky130_fd_sc_hd__o22a_2
XFILLER_21_906 VGND VGND VPWR VPWR sky130_fd_sc_hd__decap_3
XTAP_TAPCELL_ROW_43_1309 VGND VPWR sky130_fd_sc_hd__tapvpwrvgnd_1
X_3821_ _3822_/A _3822_/B _3822_/C _3822_/D VGND VGND VPWR VPWR _3821_/Y sky130_fd_sc_hd__a31oi_2
XFILLER_32_265 VGND VGND VPWR VPWR sky130_fd_sc_hd__decap_3
XFILLER_53_1422 VGND VGND VPWR VPWR sky130_fd_sc_hd__decap_3
XFILLER_33_799 VGND VGND VPWR VPWR sky130_fd_sc_hd__fill_1
XFILLER_14_1406 VGND VGND VPWR VPWR sky130_fd_sc_hd__decap_3
X_6540_ _6974_/CLK _6540_/D load_slew767/X VGND VGND VPWR VPWR _6540_/Q sky130_fd_sc_hd__dfrtp_2
XFILLER_53_1455 VGND VGND VPWR VPWR sky130_fd_sc_hd__fill_1
X_3752_ _3752_/A _3822_/B _3822_/C VGND VGND VPWR VPWR _3879_/C sky130_fd_sc_hd__nand3_2
XFILLER_53_1466 VGND VGND VPWR VPWR sky130_fd_sc_hd__decap_3
Xclkbuf_leaf_12_clk clkbuf_4_6__f_clk/X VGND VGND VPWR VPWR _7040_/CLK sky130_fd_sc_hd__clkbuf_8
XFILLER_9_472 VGND VGND VPWR VPWR sky130_fd_sc_hd__decap_3
X_6471_ _7065_/CLK _6471_/D load_slew732/X VGND VGND VPWR VPWR _6471_/Q sky130_fd_sc_hd__dfrtp_2
X_3683_ _3683_/A _3683_/B VGND VGND VPWR VPWR _3683_/Y sky130_fd_sc_hd__nor2_2
XFILLER_51_1190 VGND VGND VPWR VPWR sky130_fd_sc_hd__decap_3
X_5422_ _5422_/A1 _5480_/A2 _3999_/X VGND VGND VPWR VPWR _6534_/D sky130_fd_sc_hd__a21o_2
XFILLER_12_1174 VGND VGND VPWR VPWR sky130_fd_sc_hd__decap_3
X_5353_ _6469_/Q _5352_/X _5353_/S VGND VGND VPWR VPWR _6469_/D sky130_fd_sc_hd__mux2_1
X_4304_ _4304_/A _4304_/B VGND VGND VPWR VPWR _4305_/B sky130_fd_sc_hd__xnor2_2
XFILLER_47_1248 VGND VGND VPWR VPWR sky130_fd_sc_hd__decap_3
X_5284_ _6436_/Q _5284_/A2 _5283_/X VGND VGND VPWR VPWR _6436_/D sky130_fd_sc_hd__a21o_2
X_7023_ _7055_/CLK _7023_/D fanout803/X VGND VGND VPWR VPWR _7023_/Q sky130_fd_sc_hd__dfrtp_2
X_4235_ _6484_/Q _4319_/A2 _4874_/C1 _4234_/X VGND VGND VPWR VPWR _4235_/X sky130_fd_sc_hd__o211a_2
Xclkbuf_leaf_79_clk clkbuf_leaf_3_clk/A VGND VGND VPWR VPWR _6929_/CLK sky130_fd_sc_hd__clkbuf_8
XFILLER_60_1415 VGND VGND VPWR VPWR sky130_fd_sc_hd__decap_3
X_4166_ _6277_/Q _4765_/A2 _3236_/X _4765_/B2 VGND VGND VPWR VPWR _4166_/X sky130_fd_sc_hd__a22o_2
XFILLER_60_1459 VGND VGND VPWR VPWR sky130_fd_sc_hd__decap_3
XFILLER_3_1331 VGND VGND VPWR VPWR sky130_fd_sc_hd__decap_3
X_3117_ _6076_/A1 _3115_/X _3116_/X _3213_/C1 VGND VGND VPWR VPWR _3117_/X sky130_fd_sc_hd__a211o_2
XFILLER_56_869 VGND VGND VPWR VPWR sky130_fd_sc_hd__decap_3
X_4097_ _4097_/A1 _4094_/X _4095_/Y _4096_/X _4772_/C1 VGND VGND VPWR VPWR _4097_/X
+ sky130_fd_sc_hd__o221a_2
XFILLER_23_1281 VGND VGND VPWR VPWR sky130_fd_sc_hd__decap_3
XFILLER_23_1292 VGND VGND VPWR VPWR sky130_fd_sc_hd__decap_3
XFILLER_58_1300 VGND VGND VPWR VPWR sky130_fd_sc_hd__decap_3
XFILLER_3_1375 VGND VGND VPWR VPWR sky130_fd_sc_hd__decap_3
X_3048_ _6344_/Q VGND VGND VPWR VPWR _3048_/Y sky130_fd_sc_hd__inv_2
XFILLER_43_519 VGND VGND VPWR VPWR sky130_fd_sc_hd__fill_1
XFILLER_58_1344 VGND VGND VPWR VPWR sky130_fd_sc_hd__decap_3
XFILLER_64_891 VGND VGND VPWR VPWR sky130_fd_sc_hd__decap_3
XFILLER_19_1328 VGND VGND VPWR VPWR sky130_fd_sc_hd__decap_3
XFILLER_24_755 VGND VGND VPWR VPWR sky130_fd_sc_hd__fill_1
XFILLER_58_1388 VGND VGND VPWR VPWR sky130_fd_sc_hd__decap_3
X_6807_ _6807_/CLK _6807_/D fanout787/X VGND VGND VPWR VPWR _6807_/Q sky130_fd_sc_hd__dfrtp_2
XFILLER_11_416 VGND VGND VPWR VPWR sky130_fd_sc_hd__decap_3
X_4999_ _6357_/Q _4998_/X _4999_/S VGND VGND VPWR VPWR _6357_/D sky130_fd_sc_hd__mux2_1
XFILLER_17_1041 VGND VGND VPWR VPWR sky130_fd_sc_hd__fill_2
X_6738_ _7096_/CLK _6738_/D fanout676/X VGND VGND VPWR VPWR _6738_/Q sky130_fd_sc_hd__dfrtp_2
XFILLER_20_961 VGND VGND VPWR VPWR sky130_fd_sc_hd__decap_3
X_6669_ _6925_/CLK _6669_/D wire641/A VGND VGND VPWR VPWR _6669_/Q sky130_fd_sc_hd__dfrtp_2
XFILLER_30_1241 VGND VGND VPWR VPWR sky130_fd_sc_hd__decap_3
XFILLER_69_1440 VGND VGND VPWR VPWR sky130_fd_sc_hd__decap_3
XFILLER_3_615 VGND VGND VPWR VPWR sky130_fd_sc_hd__fill_1
XFILLER_3_626 VGND VGND VPWR VPWR sky130_fd_sc_hd__fill_1
XFILLER_2_103 VGND VGND VPWR VPWR sky130_fd_sc_hd__decap_3
XFILLER_30_1285 VGND VGND VPWR VPWR sky130_fd_sc_hd__decap_3
XFILLER_65_1304 VGND VGND VPWR VPWR sky130_fd_sc_hd__decap_3
XFILLER_79_906 VGND VGND VPWR VPWR sky130_fd_sc_hd__decap_3
XFILLER_2_136 VGND VGND VPWR VPWR sky130_fd_sc_hd__decap_3
XFILLER_2_147 VGND VGND VPWR VPWR sky130_fd_sc_hd__decap_3
XFILLER_65_1337 VGND VGND VPWR VPWR sky130_fd_sc_hd__decap_3
XFILLER_65_1348 VGND VGND VPWR VPWR sky130_fd_sc_hd__decap_3
XFILLER_79_939 VGND VGND VPWR VPWR sky130_fd_sc_hd__decap_3
XFILLER_78_405 VGND VGND VPWR VPWR sky130_fd_sc_hd__decap_3
XFILLER_8_1220 VGND VGND VPWR VPWR sky130_fd_sc_hd__decap_3
Xfanout440 _5502_/C VGND VGND VPWR VPWR _5107_/A sky130_fd_sc_hd__clkdlybuf4s25_1
XFILLER_59_641 VGND VGND VPWR VPWR sky130_fd_sc_hd__decap_3
XFILLER_8_1253 VGND VGND VPWR VPWR sky130_fd_sc_hd__decap_3
Xfanout451 _3043_/Y VGND VGND VPWR VPWR _4842_/B sky130_fd_sc_hd__clkdlybuf4s25_1
XFILLER_48_54 VGND VGND VPWR VPWR sky130_fd_sc_hd__decap_3
XFILLER_8_1264 VGND VGND VPWR VPWR sky130_fd_sc_hd__decap_3
Xfanout462 _4838_/A1 VGND VGND VPWR VPWR _4896_/A1 sky130_fd_sc_hd__clkdlybuf4s25_1
Xfanout473 fanout488/X VGND VGND VPWR VPWR _4874_/A1 sky130_fd_sc_hd__clkdlybuf4s25_1
XFILLER_47_803 VGND VGND VPWR VPWR sky130_fd_sc_hd__decap_3
XFILLER_63_1083 VGND VGND VPWR VPWR sky130_fd_sc_hd__decap_3
XFILLER_4_1117 VGND VGND VPWR VPWR sky130_fd_sc_hd__decap_3
XFILLER_58_151 VGND VGND VPWR VPWR sky130_fd_sc_hd__decap_3
Xfanout484 _4091_/A1 VGND VGND VPWR VPWR _3485_/B sky130_fd_sc_hd__clkdlybuf4s25_1
XFILLER_46_302 VGND VGND VPWR VPWR sky130_fd_sc_hd__decap_3
Xfanout495 _7088_/Q VGND VGND VPWR VPWR _5506_/A sky130_fd_sc_hd__clkdlybuf4s25_1
XFILLER_8_1297 VGND VGND VPWR VPWR sky130_fd_sc_hd__decap_3
XFILLER_19_527 VGND VGND VPWR VPWR sky130_fd_sc_hd__decap_3
XFILLER_47_869 VGND VGND VPWR VPWR sky130_fd_sc_hd__decap_3
XFILLER_41_1381 VGND VGND VPWR VPWR sky130_fd_sc_hd__decap_3
XFILLER_76_1400 VGND VGND VPWR VPWR sky130_fd_sc_hd__decap_3
XFILLER_46_379 VGND VGND VPWR VPWR sky130_fd_sc_hd__fill_1
XFILLER_15_711 VGND VGND VPWR VPWR sky130_fd_sc_hd__decap_3
XFILLER_55_891 VGND VGND VPWR VPWR sky130_fd_sc_hd__decap_3
XFILLER_76_1444 VGND VGND VPWR VPWR sky130_fd_sc_hd__decap_3
XFILLER_14_221 VGND VGND VPWR VPWR sky130_fd_sc_hd__decap_3
XFILLER_37_1428 VGND VGND VPWR VPWR sky130_fd_sc_hd__decap_3
XFILLER_9_15 VGND VGND VPWR VPWR sky130_fd_sc_hd__decap_3
XFILLER_70_872 VGND VGND VPWR VPWR sky130_fd_sc_hd__fill_1
XFILLER_15_777 VGND VGND VPWR VPWR sky130_fd_sc_hd__decap_3
XFILLER_30_725 VGND VGND VPWR VPWR sky130_fd_sc_hd__decap_3
XFILLER_14_276 VGND VGND VPWR VPWR sky130_fd_sc_hd__decap_3
XFILLER_80_41 VGND VGND VPWR VPWR sky130_fd_sc_hd__decap_3
XFILLER_30_747 VGND VGND VPWR VPWR sky130_fd_sc_hd__decap_3
XFILLER_31_1038 VGND VGND VPWR VPWR sky130_fd_sc_hd__decap_3
XFILLER_6_464 VGND VGND VPWR VPWR sky130_fd_sc_hd__decap_3
XFILLER_6_475 VGND VGND VPWR VPWR sky130_fd_sc_hd__fill_1
XFILLER_6_486 VGND VGND VPWR VPWR sky130_fd_sc_hd__decap_3
XFILLER_43_6 VGND VGND VPWR VPWR sky130_fd_sc_hd__decap_3
XFILLER_9_1006 VGND VGND VPWR VPWR sky130_fd_sc_hd__fill_2
XTAP_TAPCELL_ROW_36_1124 VGND VPWR sky130_fd_sc_hd__tapvpwrvgnd_1
Xload_slew813 fanout812/X VGND VGND VPWR VPWR load_slew813/X sky130_fd_sc_hd__buf_2
XTAP_TAPCELL_ROW_36_1135 VGND VPWR sky130_fd_sc_hd__tapvpwrvgnd_1
XTAP_TAPCELL_ROW_36_1146 VGND VPWR sky130_fd_sc_hd__tapvpwrvgnd_1
XFILLER_2_681 VGND VGND VPWR VPWR sky130_fd_sc_hd__decap_3
XFILLER_69_449 VGND VGND VPWR VPWR sky130_fd_sc_hd__decap_3
XFILLER_46_1270 VGND VGND VPWR VPWR sky130_fd_sc_hd__decap_3
X_4020_ _3404_/X _4765_/B2 _4766_/A2 _6899_/Q _4068_/C1 VGND VGND VPWR VPWR _4020_/X
+ sky130_fd_sc_hd__a221o_2
XFILLER_49_140 VGND VGND VPWR VPWR sky130_fd_sc_hd__decap_3
Xclkbuf_leaf_1_clk clkbuf_leaf_2_clk/A VGND VGND VPWR VPWR clkload8/A sky130_fd_sc_hd__clkbuf_8
XFILLER_38_825 VGND VGND VPWR VPWR sky130_fd_sc_hd__decap_3
XFILLER_42_1145 VGND VGND VPWR VPWR sky130_fd_sc_hd__decap_3
XFILLER_37_302 VGND VGND VPWR VPWR sky130_fd_sc_hd__decap_3
XFILLER_77_493 VGND VGND VPWR VPWR sky130_fd_sc_hd__fill_2
XFILLER_49_184 VGND VGND VPWR VPWR sky130_fd_sc_hd__decap_3
XFILLER_38_858 VGND VGND VPWR VPWR sky130_fd_sc_hd__decap_3
XFILLER_38_869 VGND VGND VPWR VPWR sky130_fd_sc_hd__decap_3
XFILLER_20_1421 VGND VGND VPWR VPWR sky130_fd_sc_hd__decap_3
XFILLER_77_1219 VGND VGND VPWR VPWR sky130_fd_sc_hd__decap_3
XFILLER_20_1432 VGND VGND VPWR VPWR sky130_fd_sc_hd__decap_3
XFILLER_25_508 VGND VGND VPWR VPWR sky130_fd_sc_hd__decap_3
XFILLER_65_677 VGND VGND VPWR VPWR sky130_fd_sc_hd__fill_2
X_5971_ _5971_/A0 _5971_/A1 _5971_/S VGND VGND VPWR VPWR _6975_/D sky130_fd_sc_hd__mux2_1
XFILLER_20_1465 VGND VGND VPWR VPWR sky130_fd_sc_hd__decap_3
XFILLER_46_891 VGND VGND VPWR VPWR sky130_fd_sc_hd__decap_3
X_4922_ _6346_/Q _4921_/X _4922_/S VGND VGND VPWR VPWR _6346_/D sky130_fd_sc_hd__mux2_1
XFILLER_61_850 VGND VGND VPWR VPWR sky130_fd_sc_hd__decap_3
X_4853_ _4793_/A _4850_/X _4851_/Y _4852_/X _4853_/C1 VGND VGND VPWR VPWR _4853_/X
+ sky130_fd_sc_hd__o221a_2
XFILLER_33_574 VGND VGND VPWR VPWR sky130_fd_sc_hd__decap_3
XFILLER_60_360 VGND VGND VPWR VPWR sky130_fd_sc_hd__decap_3
XFILLER_18_1350 VGND VGND VPWR VPWR sky130_fd_sc_hd__decap_3
X_3804_ _4302_/A _4292_/A VGND VGND VPWR VPWR _4210_/A sky130_fd_sc_hd__xnor2_2
XFILLER_20_235 VGND VGND VPWR VPWR sky130_fd_sc_hd__decap_3
XFILLER_21_769 VGND VGND VPWR VPWR sky130_fd_sc_hd__decap_3
X_4784_ wire25/X _4835_/S VGND VGND VPWR VPWR _4784_/Y sky130_fd_sc_hd__nor2_2
XFILLER_14_1214 VGND VGND VPWR VPWR sky130_fd_sc_hd__decap_3
XFILLER_53_1263 VGND VGND VPWR VPWR sky130_fd_sc_hd__decap_3
XFILLER_18_1394 VGND VGND VPWR VPWR sky130_fd_sc_hd__decap_3
X_6523_ _6897_/CLK _6523_/D fanout703/X VGND VGND VPWR VPWR _6523_/Q sky130_fd_sc_hd__dfrtp_2
XFILLER_14_1247 VGND VGND VPWR VPWR sky130_fd_sc_hd__decap_3
X_3735_ _5517_/B2 _6239_/Q VGND VGND VPWR VPWR _3735_/X sky130_fd_sc_hd__and2b_2
X_6454_ _6925_/CLK _6454_/D wire655/X VGND VGND VPWR VPWR _6454_/Q sky130_fd_sc_hd__dfrtp_2
X_3666_ _3673_/A _3666_/B VGND VGND VPWR VPWR _3667_/B sky130_fd_sc_hd__xnor2_2
Xclkload50 _7051_/CLK VGND VGND VPWR VPWR clkload50/X sky130_fd_sc_hd__clkbuf_8
X_5405_ _5405_/A1 _5477_/A2 _4469_/X VGND VGND VPWR VPWR _6517_/D sky130_fd_sc_hd__a21o_2
Xclkload61 _7027_/CLK VGND VGND VPWR VPWR clkload61/X sky130_fd_sc_hd__clkbuf_8
X_6385_ _7019_/CLK _6385_/D load_slew815/X VGND VGND VPWR VPWR _6385_/Q sky130_fd_sc_hd__dfrtp_2
X_3597_ _6301_/Q _6309_/Q _6317_/Q _6237_/Q _3597_/S0 _3601_/A VGND VGND VPWR VPWR
+ _3597_/X sky130_fd_sc_hd__mux4_2
X_5336_ _6799_/Q _5050_/B _5336_/S VGND VGND VPWR VPWR _5336_/X sky130_fd_sc_hd__mux2_1
XFILLER_0_607 VGND VGND VPWR VPWR sky130_fd_sc_hd__decap_3
XFILLER_76_909 VGND VGND VPWR VPWR sky130_fd_sc_hd__decap_3
X_5267_ _5338_/S _5267_/B VGND VGND VPWR VPWR _5267_/Y sky130_fd_sc_hd__nand2_2
XFILLER_25_1310 VGND VGND VPWR VPWR sky130_fd_sc_hd__decap_3
XFILLER_75_408 VGND VGND VPWR VPWR sky130_fd_sc_hd__decap_3
XFILLER_5_1404 VGND VGND VPWR VPWR sky130_fd_sc_hd__decap_3
XFILLER_25_1343 VGND VGND VPWR VPWR sky130_fd_sc_hd__fill_1
XFILLER_29_803 VGND VGND VPWR VPWR sky130_fd_sc_hd__fill_2
X_7006_ _7088_/CLK _7006_/D load_slew773/X VGND VGND VPWR VPWR _7006_/Q sky130_fd_sc_hd__dfrtp_2
X_4218_ _4300_/B _6483_/Q _4257_/S VGND VGND VPWR VPWR _4218_/X sky130_fd_sc_hd__mux2_1
XFILLER_25_1354 VGND VGND VPWR VPWR sky130_fd_sc_hd__decap_3
XFILLER_5_1437 VGND VGND VPWR VPWR sky130_fd_sc_hd__decap_3
X_5198_ _5216_/A _5198_/B VGND VGND VPWR VPWR _5198_/Y sky130_fd_sc_hd__nand2_2
XFILLER_60_1256 VGND VGND VPWR VPWR sky130_fd_sc_hd__decap_3
XFILLER_25_1387 VGND VGND VPWR VPWR sky130_fd_sc_hd__decap_3
XFILLER_29_847 VGND VGND VPWR VPWR sky130_fd_sc_hd__decap_3
XFILLER_60_1267 VGND VGND VPWR VPWR sky130_fd_sc_hd__decap_3
XFILLER_21_1229 VGND VGND VPWR VPWR sky130_fd_sc_hd__decap_3
X_4149_ _6476_/Q _5589_/A3 _4265_/B VGND VGND VPWR VPWR _4149_/X sky130_fd_sc_hd__mux2_1
XFILLER_28_368 VGND VGND VPWR VPWR sky130_fd_sc_hd__fill_2
XFILLER_3_1172 VGND VGND VPWR VPWR sky130_fd_sc_hd__decap_3
XFILLER_3_1183 VGND VGND VPWR VPWR sky130_fd_sc_hd__decap_3
XFILLER_58_1141 VGND VGND VPWR VPWR sky130_fd_sc_hd__decap_3
XFILLER_34_12 VGND VGND VPWR VPWR sky130_fd_sc_hd__fill_1
XFILLER_43_349 VGND VGND VPWR VPWR sky130_fd_sc_hd__decap_3
XFILLER_52_872 VGND VGND VPWR VPWR sky130_fd_sc_hd__decap_3
XFILLER_12_714 VGND VGND VPWR VPWR sky130_fd_sc_hd__decap_3
XFILLER_19_1169 VGND VGND VPWR VPWR sky130_fd_sc_hd__decap_3
XFILLER_36_1450 VGND VGND VPWR VPWR sky130_fd_sc_hd__decap_3
XFILLER_51_393 VGND VGND VPWR VPWR sky130_fd_sc_hd__decap_3
XFILLER_12_769 VGND VGND VPWR VPWR sky130_fd_sc_hd__decap_3
XFILLER_32_1303 VGND VGND VPWR VPWR sky130_fd_sc_hd__decap_3
XFILLER_71_1363 VGND VGND VPWR VPWR sky130_fd_sc_hd__decap_3
XTAP_TAPCELL_ROW_22_764 VGND VPWR sky130_fd_sc_hd__tapvpwrvgnd_1
Xclkload0 clkload0/A VGND VGND VPWR VPWR clkload0/X sky130_fd_sc_hd__clkbuf_8
Xwire137 wire137/A VGND VGND VPWR VPWR _5331_/S sky130_fd_sc_hd__buf_4
XTAP_TAPCELL_ROW_22_775 VGND VPWR sky130_fd_sc_hd__tapvpwrvgnd_1
XFILLER_71_1396 VGND VGND VPWR VPWR sky130_fd_sc_hd__decap_3
XFILLER_32_1347 VGND VGND VPWR VPWR sky130_fd_sc_hd__decap_3
Xwire148 _3865_/Y VGND VGND VPWR VPWR _4152_/A sky130_fd_sc_hd__buf_2
Xwire159 wire159/A VGND VGND VPWR VPWR _5782_/S sky130_fd_sc_hd__buf_4
XFILLER_50_88 VGND VGND VPWR VPWR sky130_fd_sc_hd__fill_2
XTAP_TAPCELL_ROW_76_2172 VGND VPWR sky130_fd_sc_hd__tapvpwrvgnd_1
XTAP_TAPCELL_ROW_76_2183 VGND VPWR sky130_fd_sc_hd__tapvpwrvgnd_1
XFILLER_4_968 VGND VGND VPWR VPWR sky130_fd_sc_hd__decap_3
XFILLER_69_1281 VGND VGND VPWR VPWR sky130_fd_sc_hd__decap_3
XFILLER_69_1292 VGND VGND VPWR VPWR sky130_fd_sc_hd__decap_3
XTAP_TAPCELL_ROW_72_2069 VGND VPWR sky130_fd_sc_hd__tapvpwrvgnd_1
XFILLER_79_725 VGND VGND VPWR VPWR sky130_fd_sc_hd__decap_3
XFILLER_3_489 VGND VGND VPWR VPWR sky130_fd_sc_hd__decap_3
XFILLER_79_747 VGND VGND VPWR VPWR sky130_fd_sc_hd__decap_3
XFILLER_65_1167 VGND VGND VPWR VPWR sky130_fd_sc_hd__decap_3
XFILLER_67_909 VGND VGND VPWR VPWR sky130_fd_sc_hd__decap_3
XFILLER_43_1410 VGND VGND VPWR VPWR sky130_fd_sc_hd__decap_3
XTAP_TAPCELL_ROW_31_1010 VGND VPWR sky130_fd_sc_hd__tapvpwrvgnd_1
XFILLER_43_1443 VGND VGND VPWR VPWR sky130_fd_sc_hd__decap_3
Xfanout270 _3960_/Y VGND VGND VPWR VPWR wire271/A sky130_fd_sc_hd__clkdlybuf4s25_1
Xfanout281 _3960_/Y VGND VGND VPWR VPWR _4396_/A sky130_fd_sc_hd__clkdlybuf4s25_1
XFILLER_75_30 VGND VGND VPWR VPWR sky130_fd_sc_hd__decap_3
Xfanout292 _4758_/A2 VGND VGND VPWR VPWR _3877_/B1 sky130_fd_sc_hd__clkdlybuf4s25_1
XFILLER_19_324 VGND VGND VPWR VPWR sky130_fd_sc_hd__decap_3
XFILLER_75_997 VGND VGND VPWR VPWR sky130_fd_sc_hd__fill_1
XFILLER_19_379 VGND VGND VPWR VPWR sky130_fd_sc_hd__decap_3
Xload_slew56 _4427_/S VGND VGND VPWR VPWR _4899_/S sky130_fd_sc_hd__clkbuf_4
XFILLER_47_688 VGND VGND VPWR VPWR sky130_fd_sc_hd__decap_3
XFILLER_74_485 VGND VGND VPWR VPWR sky130_fd_sc_hd__decap_3
XFILLER_34_338 VGND VGND VPWR VPWR sky130_fd_sc_hd__decap_3
XFILLER_76_1241 VGND VGND VPWR VPWR sky130_fd_sc_hd__decap_3
XFILLER_27_390 VGND VGND VPWR VPWR sky130_fd_sc_hd__fill_2
XFILLER_43_872 VGND VGND VPWR VPWR sky130_fd_sc_hd__fill_1
XFILLER_76_1285 VGND VGND VPWR VPWR sky130_fd_sc_hd__decap_3
XFILLER_37_1236 VGND VGND VPWR VPWR sky130_fd_sc_hd__decap_3
XFILLER_15_585 VGND VGND VPWR VPWR sky130_fd_sc_hd__decap_3
XFILLER_42_360 VGND VGND VPWR VPWR sky130_fd_sc_hd__decap_3
XFILLER_72_1138 VGND VGND VPWR VPWR sky130_fd_sc_hd__decap_3
XFILLER_72_1149 VGND VGND VPWR VPWR sky130_fd_sc_hd__decap_3
XFILLER_37_1269 VGND VGND VPWR VPWR sky130_fd_sc_hd__decap_3
XFILLER_42_393 VGND VGND VPWR VPWR sky130_fd_sc_hd__fill_1
XFILLER_50_1403 VGND VGND VPWR VPWR sky130_fd_sc_hd__decap_3
XTAP_TAPCELL_ROW_61_1784 VGND VPWR sky130_fd_sc_hd__tapvpwrvgnd_1
XTAP_TAPCELL_ROW_61_1795 VGND VPWR sky130_fd_sc_hd__tapvpwrvgnd_1
XFILLER_50_1447 VGND VGND VPWR VPWR sky130_fd_sc_hd__decap_3
XFILLER_7_740 VGND VGND VPWR VPWR sky130_fd_sc_hd__fill_1
X_3520_ _5569_/A _3517_/Y _3519_/Y _3512_/Y _3516_/Y VGND VGND VPWR VPWR _3670_/A
+ sky130_fd_sc_hd__o32a_2
XFILLER_10_290 VGND VGND VPWR VPWR sky130_fd_sc_hd__decap_3
XFILLER_7_762 VGND VGND VPWR VPWR sky130_fd_sc_hd__decap_3
XFILLER_6_250 VGND VGND VPWR VPWR sky130_fd_sc_hd__fill_2
X_3451_ hold941/X _3450_/X _3457_/S VGND VGND VPWR VPWR _6199_/D sky130_fd_sc_hd__mux2_1
XFILLER_48_1332 VGND VGND VPWR VPWR sky130_fd_sc_hd__decap_3
XFILLER_41_3 VGND VGND VPWR VPWR sky130_fd_sc_hd__decap_3
X_6170_ clkload9/A _6170_/D load_slew643/X VGND VGND VPWR VPWR _6170_/Q sky130_fd_sc_hd__dfrtp_2
X_3382_ _6310_/Q _6422_/Q VGND VGND VPWR VPWR _3382_/X sky130_fd_sc_hd__xor2_2
XFILLER_48_1365 VGND VGND VPWR VPWR sky130_fd_sc_hd__decap_3
XFILLER_48_1376 VGND VGND VPWR VPWR sky130_fd_sc_hd__decap_3
XFILLER_69_213 VGND VGND VPWR VPWR sky130_fd_sc_hd__decap_3
X_5121_ _6406_/Q _5288_/B VGND VGND VPWR VPWR _5123_/B sky130_fd_sc_hd__xor2_2
Xload_slew643 fanout642/X VGND VGND VPWR VPWR load_slew643/X sky130_fd_sc_hd__clkbuf_4
Xhold1407 _6481_/Q VGND VGND VPWR VPWR _5369_/A1 sky130_fd_sc_hd__dlygate4sd3_1
XFILLER_57_408 VGND VGND VPWR VPWR sky130_fd_sc_hd__decap_3
Xhold1418 _6777_/Q VGND VGND VPWR VPWR _5730_/A1 sky130_fd_sc_hd__dlygate4sd3_1
X_5052_ _6397_/Q _5261_/B _5052_/B1 VGND VGND VPWR VPWR _5052_/Y sky130_fd_sc_hd__a21oi_2
XFILLER_57_419 VGND VGND VPWR VPWR sky130_fd_sc_hd__fill_2
Xhold1429 _6513_/Q VGND VGND VPWR VPWR _5401_/A1 sky130_fd_sc_hd__dlygate4sd3_1
XFILLER_78_780 VGND VGND VPWR VPWR sky130_fd_sc_hd__decap_3
X_4003_ _4101_/B _4422_/A VGND VGND VPWR VPWR _4003_/Y sky130_fd_sc_hd__nor2_2
XFILLER_66_953 VGND VGND VPWR VPWR sky130_fd_sc_hd__decap_3
XFILLER_65_430 VGND VGND VPWR VPWR sky130_fd_sc_hd__decap_3
XFILLER_1_60 VGND VGND VPWR VPWR sky130_fd_sc_hd__decap_3
XFILLER_37_154 VGND VGND VPWR VPWR sky130_fd_sc_hd__fill_1
XFILLER_0_1301 VGND VGND VPWR VPWR sky130_fd_sc_hd__decap_3
XFILLER_20_1240 VGND VGND VPWR VPWR sky130_fd_sc_hd__decap_3
XFILLER_1_93 VGND VGND VPWR VPWR sky130_fd_sc_hd__decap_3
XFILLER_0_1323 VGND VGND VPWR VPWR sky130_fd_sc_hd__decap_3
XFILLER_20_1273 VGND VGND VPWR VPWR sky130_fd_sc_hd__decap_3
XFILLER_52_124 VGND VGND VPWR VPWR sky130_fd_sc_hd__decap_3
XFILLER_0_1345 VGND VGND VPWR VPWR sky130_fd_sc_hd__decap_3
X_5954_ _5954_/A0 _6958_/Q _6050_/S VGND VGND VPWR VPWR _5954_/X sky130_fd_sc_hd__mux2_1
XFILLER_80_466 VGND VGND VPWR VPWR sky130_fd_sc_hd__decap_3
XFILLER_80_477 VGND VGND VPWR VPWR sky130_fd_sc_hd__decap_3
X_4905_ _6376_/Q _5198_/B _5075_/A VGND VGND VPWR VPWR _4905_/Y sky130_fd_sc_hd__a21oi_2
XFILLER_55_1325 VGND VGND VPWR VPWR sky130_fd_sc_hd__decap_3
X_5885_ _5797_/C _5885_/A1 _5887_/S VGND VGND VPWR VPWR _6895_/D sky130_fd_sc_hd__mux2_1
XFILLER_16_1309 VGND VGND VPWR VPWR sky130_fd_sc_hd__decap_3
XFILLER_55_1369 VGND VGND VPWR VPWR sky130_fd_sc_hd__decap_3
XFILLER_33_393 VGND VGND VPWR VPWR sky130_fd_sc_hd__fill_1
X_4836_ _4894_/A _4836_/B VGND VGND VPWR VPWR _4836_/Y sky130_fd_sc_hd__nor2_2
XFILLER_14_1022 VGND VGND VPWR VPWR sky130_fd_sc_hd__decap_3
X_4767_ _6325_/Q _4622_/S _4764_/X _4766_/X VGND VGND VPWR VPWR _6325_/D sky130_fd_sc_hd__o22a_2
XFILLER_14_1055 VGND VGND VPWR VPWR sky130_fd_sc_hd__decap_3
X_6506_ _6847_/CLK _6506_/D load_slew778/X VGND VGND VPWR VPWR _6506_/Q sky130_fd_sc_hd__dfrtp_2
X_3718_ _4738_/A _4108_/B VGND VGND VPWR VPWR _4444_/A sky130_fd_sc_hd__nand2_2
XFILLER_4_209 VGND VGND VPWR VPWR sky130_fd_sc_hd__decap_3
X_4698_ _4694_/X _4695_/X _4697_/Y _4874_/C1 VGND VGND VPWR VPWR _4698_/X sky130_fd_sc_hd__o211a_2
X_6437_ _6900_/CLK _6437_/D load_slew825/X VGND VGND VPWR VPWR _6437_/Q sky130_fd_sc_hd__dfrtp_2
X_3649_ _3673_/A _3649_/B _3636_/A VGND VGND VPWR VPWR _3652_/C sky130_fd_sc_hd__or3b_2
XFILLER_20_58 VGND VGND VPWR VPWR sky130_fd_sc_hd__decap_3
XFILLER_66_1421 VGND VGND VPWR VPWR sky130_fd_sc_hd__decap_3
XFILLER_66_1432 VGND VGND VPWR VPWR sky130_fd_sc_hd__decap_3
XFILLER_1_927 VGND VGND VPWR VPWR sky130_fd_sc_hd__decap_3
X_6368_ _7077_/CLK _6368_/D load_slew692/X VGND VGND VPWR VPWR _6368_/Q sky130_fd_sc_hd__dfrtp_2
XFILLER_27_1416 VGND VGND VPWR VPWR sky130_fd_sc_hd__decap_3
XFILLER_66_1465 VGND VGND VPWR VPWR sky130_fd_sc_hd__decap_3
X_5319_ _6452_/Q _5318_/X _5335_/S VGND VGND VPWR VPWR _6452_/D sky130_fd_sc_hd__mux2_1
XFILLER_27_1449 VGND VGND VPWR VPWR sky130_fd_sc_hd__decap_3
XFILLER_62_1329 VGND VGND VPWR VPWR sky130_fd_sc_hd__decap_3
X_6299_ _7040_/CLK _6299_/D fanout688/X VGND VGND VPWR VPWR _6299_/Q sky130_fd_sc_hd__dfrtp_2
XFILLER_48_408 VGND VGND VPWR VPWR sky130_fd_sc_hd__fill_1
XFILLER_5_1201 VGND VGND VPWR VPWR sky130_fd_sc_hd__decap_3
XFILLER_9_1381 VGND VGND VPWR VPWR sky130_fd_sc_hd__decap_3
XFILLER_25_1151 VGND VGND VPWR VPWR sky130_fd_sc_hd__decap_3
XFILLER_21_1004 VGND VGND VPWR VPWR sky130_fd_sc_hd__decap_3
XFILLER_5_1245 VGND VGND VPWR VPWR sky130_fd_sc_hd__decap_3
XFILLER_29_655 VGND VGND VPWR VPWR sky130_fd_sc_hd__decap_3
XFILLER_72_912 VGND VGND VPWR VPWR sky130_fd_sc_hd__fill_1
XFILLER_5_1278 VGND VGND VPWR VPWR sky130_fd_sc_hd__decap_3
XTAP_TAPCELL_ROW_3_275 VGND VPWR sky130_fd_sc_hd__tapvpwrvgnd_1
XFILLER_5_1289 VGND VGND VPWR VPWR sky130_fd_sc_hd__decap_3
XFILLER_17_828 VGND VGND VPWR VPWR sky130_fd_sc_hd__decap_3
XTAP_TAPCELL_ROW_3_286 VGND VPWR sky130_fd_sc_hd__tapvpwrvgnd_1
XFILLER_16_305 VGND VGND VPWR VPWR sky130_fd_sc_hd__decap_3
XFILLER_56_485 VGND VGND VPWR VPWR sky130_fd_sc_hd__decap_3
XFILLER_16_327 VGND VGND VPWR VPWR sky130_fd_sc_hd__decap_3
XFILLER_43_113 VGND VGND VPWR VPWR sky130_fd_sc_hd__fill_1
XTAP_TAPCELL_ROW_80_2305 VGND VPWR sky130_fd_sc_hd__tapvpwrvgnd_1
XFILLER_45_55 VGND VGND VPWR VPWR sky130_fd_sc_hd__fill_1
XTAP_TAPCELL_ROW_80_2316 VGND VPWR sky130_fd_sc_hd__tapvpwrvgnd_1
XFILLER_71_455 VGND VGND VPWR VPWR sky130_fd_sc_hd__fill_2
XFILLER_73_1425 VGND VGND VPWR VPWR sky130_fd_sc_hd__decap_3
XFILLER_31_319 VGND VGND VPWR VPWR sky130_fd_sc_hd__decap_3
XFILLER_24_371 VGND VGND VPWR VPWR sky130_fd_sc_hd__decap_3
XFILLER_34_1409 VGND VGND VPWR VPWR sky130_fd_sc_hd__decap_3
XFILLER_12_555 VGND VGND VPWR VPWR sky130_fd_sc_hd__decap_3
XFILLER_8_504 VGND VGND VPWR VPWR sky130_fd_sc_hd__decap_3
XTAP_TAPCELL_ROW_78_2223 VGND VPWR sky130_fd_sc_hd__tapvpwrvgnd_1
XFILLER_71_1171 VGND VGND VPWR VPWR sky130_fd_sc_hd__decap_3
XFILLER_32_1122 VGND VGND VPWR VPWR sky130_fd_sc_hd__decap_3
XFILLER_36_1291 VGND VGND VPWR VPWR sky130_fd_sc_hd__decap_3
XTAP_TAPCELL_ROW_78_2234 VGND VPWR sky130_fd_sc_hd__tapvpwrvgnd_1
XFILLER_8_548 VGND VGND VPWR VPWR sky130_fd_sc_hd__decap_3
XFILLER_6_27 VGND VGND VPWR VPWR sky130_fd_sc_hd__fill_1
XFILLER_6_38 VGND VGND VPWR VPWR sky130_fd_sc_hd__decap_3
XANTENNA_9 _3202_/A VGND VGND VPWR VPWR sky130_fd_sc_hd__diode_2
XFILLER_67_1207 VGND VGND VPWR VPWR sky130_fd_sc_hd__decap_3
XFILLER_10_1453 VGND VGND VPWR VPWR sky130_fd_sc_hd__decap_3
XFILLER_3_242 VGND VGND VPWR VPWR sky130_fd_sc_hd__decap_3
XFILLER_79_511 VGND VGND VPWR VPWR sky130_fd_sc_hd__decap_3
XFILLER_80_1407 VGND VGND VPWR VPWR sky130_fd_sc_hd__decap_3
XFILLER_10_91 VGND VGND VPWR VPWR sky130_fd_sc_hd__decap_3
XFILLER_80_1429 VGND VGND VPWR VPWR sky130_fd_sc_hd__decap_3
XFILLER_0_971 VGND VGND VPWR VPWR sky130_fd_sc_hd__decap_3
XFILLER_0_993 VGND VGND VPWR VPWR sky130_fd_sc_hd__decap_3
XFILLER_43_1251 VGND VGND VPWR VPWR sky130_fd_sc_hd__decap_3
XFILLER_66_238 VGND VGND VPWR VPWR sky130_fd_sc_hd__decap_3
XFILLER_43_1284 VGND VGND VPWR VPWR sky130_fd_sc_hd__decap_3
XFILLER_78_1303 VGND VGND VPWR VPWR sky130_fd_sc_hd__decap_3
XFILLER_43_1295 VGND VGND VPWR VPWR sky130_fd_sc_hd__decap_3
XFILLER_75_761 VGND VGND VPWR VPWR sky130_fd_sc_hd__decap_3
XTAP_TAPCELL_ROW_50_1496 VGND VPWR sky130_fd_sc_hd__tapvpwrvgnd_1
XFILLER_35_614 VGND VGND VPWR VPWR sky130_fd_sc_hd__fill_2
XFILLER_63_923 VGND VGND VPWR VPWR sky130_fd_sc_hd__decap_3
XFILLER_78_1347 VGND VGND VPWR VPWR sky130_fd_sc_hd__decap_3
XFILLER_74_271 VGND VGND VPWR VPWR sky130_fd_sc_hd__fill_2
XFILLER_47_496 VGND VGND VPWR VPWR sky130_fd_sc_hd__decap_3
XFILLER_62_444 VGND VGND VPWR VPWR sky130_fd_sc_hd__fill_2
XFILLER_16_850 VGND VGND VPWR VPWR sky130_fd_sc_hd__decap_3
XFILLER_50_606 VGND VGND VPWR VPWR sky130_fd_sc_hd__decap_3
XFILLER_37_1000 VGND VGND VPWR VPWR sky130_fd_sc_hd__fill_1
XFILLER_50_628 VGND VGND VPWR VPWR sky130_fd_sc_hd__decap_3
XFILLER_15_360 VGND VGND VPWR VPWR sky130_fd_sc_hd__decap_3
XTAP_TAPCELL_ROW_63_1835 VGND VPWR sky130_fd_sc_hd__tapvpwrvgnd_1
XFILLER_76_1082 VGND VGND VPWR VPWR sky130_fd_sc_hd__decap_3
XTAP_TAPCELL_ROW_63_1846 VGND VPWR sky130_fd_sc_hd__tapvpwrvgnd_1
XFILLER_76_1093 VGND VGND VPWR VPWR sky130_fd_sc_hd__decap_3
XFILLER_15_393 VGND VGND VPWR VPWR sky130_fd_sc_hd__decap_3
X_5670_ hold944/X _5909_/A0 _5675_/S VGND VGND VPWR VPWR _6724_/D sky130_fd_sc_hd__mux2_1
XFILLER_30_330 VGND VGND VPWR VPWR sky130_fd_sc_hd__decap_3
XTAP_TAPCELL_ROW_13_550 VGND VPWR sky130_fd_sc_hd__tapvpwrvgnd_1
XFILLER_15_1331 VGND VGND VPWR VPWR sky130_fd_sc_hd__decap_3
XFILLER_31_897 VGND VGND VPWR VPWR sky130_fd_sc_hd__decap_3
X_4621_ _6883_/Q _4883_/A2 _4619_/X _4620_/X VGND VGND VPWR VPWR _4621_/X sky130_fd_sc_hd__a211o_2
XFILLER_54_1391 VGND VGND VPWR VPWR sky130_fd_sc_hd__decap_3
XFILLER_15_1375 VGND VGND VPWR VPWR sky130_fd_sc_hd__decap_3
XFILLER_50_1255 VGND VGND VPWR VPWR sky130_fd_sc_hd__decap_3
X_4552_ _6320_/Q _4750_/A2 _3354_/X _4750_/B2 VGND VGND VPWR VPWR _4552_/X sky130_fd_sc_hd__a22o_2
XFILLER_11_1228 VGND VGND VPWR VPWR sky130_fd_sc_hd__decap_3
XFILLER_11_1239 VGND VGND VPWR VPWR sky130_fd_sc_hd__decap_3
XFILLER_50_1288 VGND VGND VPWR VPWR sky130_fd_sc_hd__decap_3
XFILLER_7_570 VGND VGND VPWR VPWR sky130_fd_sc_hd__decap_3
X_3503_ _6303_/Q _6311_/Q _6319_/Q _6239_/Q _3504_/S0 _4386_/A VGND VGND VPWR VPWR
+ _3503_/X sky130_fd_sc_hd__mux4_2
X_4483_ _4896_/A1 _4480_/X _4481_/Y _4482_/X _4896_/C1 VGND VGND VPWR VPWR _4483_/X
+ sky130_fd_sc_hd__o221a_2
X_6222_ _7040_/CLK _6222_/D wire715/A VGND VGND VPWR VPWR _6222_/Q sky130_fd_sc_hd__dfrtp_2
X_3434_ _6328_/Q _6448_/Q VGND VGND VPWR VPWR _3434_/X sky130_fd_sc_hd__xor2_2
X_6153_ _7004_/CLK _6153_/D load_slew834/X VGND VGND VPWR VPWR _6153_/Q sky130_fd_sc_hd__dfrtp_2
X_3365_ hold970/X _3364_/X _3429_/S VGND VGND VPWR VPWR _6156_/D sky130_fd_sc_hd__mux2_1
XFILLER_44_1026 VGND VGND VPWR VPWR sky130_fd_sc_hd__decap_3
XFILLER_58_706 VGND VGND VPWR VPWR sky130_fd_sc_hd__fill_2
XFILLER_44_1037 VGND VGND VPWR VPWR sky130_fd_sc_hd__decap_3
X_5104_ _6436_/Q _5104_/B VGND VGND VPWR VPWR _5282_/B sky130_fd_sc_hd__xnor2_2
X_6084_ hold868/X _6073_/D _5781_/S VGND VGND VPWR VPWR _7079_/D sky130_fd_sc_hd__a21o_2
Xhold1204 _6945_/Q VGND VGND VPWR VPWR _5941_/A1 sky130_fd_sc_hd__dlygate4sd3_1
Xhold1215 _6696_/Q VGND VGND VPWR VPWR _5637_/A1 sky130_fd_sc_hd__dlygate4sd3_1
X_3296_ _6275_/Q _6379_/Q VGND VGND VPWR VPWR _3296_/X sky130_fd_sc_hd__xor2_2
XFILLER_61_1340 VGND VGND VPWR VPWR sky130_fd_sc_hd__decap_3
Xhold1226 _6800_/Q VGND VGND VPWR VPWR _5756_/A1 sky130_fd_sc_hd__dlygate4sd3_1
XFILLER_61_1351 VGND VGND VPWR VPWR sky130_fd_sc_hd__decap_3
XFILLER_39_942 VGND VGND VPWR VPWR sky130_fd_sc_hd__decap_3
Xhold1237 _6750_/Q VGND VGND VPWR VPWR _5699_/A0 sky130_fd_sc_hd__dlygate4sd3_1
X_5035_ _6459_/Q _6677_/Q VGND VGND VPWR VPWR _5036_/B sky130_fd_sc_hd__xor2_2
Xhold1248 _6765_/Q VGND VGND VPWR VPWR _5717_/A1 sky130_fd_sc_hd__dlygate4sd3_1
XFILLER_39_953 VGND VGND VPWR VPWR sky130_fd_sc_hd__fill_2
XFILLER_22_1335 VGND VGND VPWR VPWR sky130_fd_sc_hd__decap_3
XFILLER_61_1384 VGND VGND VPWR VPWR sky130_fd_sc_hd__decap_3
Xhold1259 _6899_/Q VGND VGND VPWR VPWR _5890_/A1 sky130_fd_sc_hd__dlygate4sd3_1
XFILLER_2_1418 VGND VGND VPWR VPWR sky130_fd_sc_hd__decap_3
XTAP_TAPCELL_ROW_0_201 VGND VPWR sky130_fd_sc_hd__tapvpwrvgnd_1
XFILLER_2_1429 VGND VGND VPWR VPWR sky130_fd_sc_hd__decap_3
XTAP_TAPCELL_ROW_0_212 VGND VPWR sky130_fd_sc_hd__tapvpwrvgnd_1
XFILLER_22_1368 VGND VGND VPWR VPWR sky130_fd_sc_hd__decap_3
XFILLER_38_474 VGND VGND VPWR VPWR sky130_fd_sc_hd__fill_2
XFILLER_54_923 VGND VGND VPWR VPWR sky130_fd_sc_hd__fill_1
XFILLER_22_1379 VGND VGND VPWR VPWR sky130_fd_sc_hd__decap_3
XFILLER_53_411 VGND VGND VPWR VPWR sky130_fd_sc_hd__decap_3
XFILLER_54_956 VGND VGND VPWR VPWR sky130_fd_sc_hd__decap_3
XFILLER_0_1142 VGND VGND VPWR VPWR sky130_fd_sc_hd__decap_3
X_6986_ _6986_/CLK _6986_/D fanout653/X VGND VGND VPWR VPWR _6986_/Q sky130_fd_sc_hd__dfrtp_2
XFILLER_41_606 VGND VGND VPWR VPWR sky130_fd_sc_hd__fill_1
XFILLER_53_466 VGND VGND VPWR VPWR sky130_fd_sc_hd__decap_3
XFILLER_0_1164 VGND VGND VPWR VPWR sky130_fd_sc_hd__decap_3
XFILLER_41_617 VGND VGND VPWR VPWR sky130_fd_sc_hd__decap_3
XFILLER_13_319 VGND VGND VPWR VPWR sky130_fd_sc_hd__decap_3
XTAP_TAPCELL_ROW_24_815 VGND VPWR sky130_fd_sc_hd__tapvpwrvgnd_1
XFILLER_0_1186 VGND VGND VPWR VPWR sky130_fd_sc_hd__decap_3
XTAP_TAPCELL_ROW_24_826 VGND VPWR sky130_fd_sc_hd__tapvpwrvgnd_1
X_5937_ hold945/X _6941_/Q _5998_/S VGND VGND VPWR VPWR _5937_/X sky130_fd_sc_hd__mux2_1
XTAP_TAPCELL_ROW_24_837 VGND VPWR sky130_fd_sc_hd__tapvpwrvgnd_1
XFILLER_55_1144 VGND VGND VPWR VPWR sky130_fd_sc_hd__decap_3
XFILLER_21_330 VGND VGND VPWR VPWR sky130_fd_sc_hd__decap_3
X_5868_ _5868_/A _5868_/B _5868_/C VGND VGND VPWR VPWR _5868_/Y sky130_fd_sc_hd__nand3_2
XFILLER_55_1177 VGND VGND VPWR VPWR sky130_fd_sc_hd__fill_1
XFILLER_22_875 VGND VGND VPWR VPWR sky130_fd_sc_hd__decap_3
XFILLER_55_1199 VGND VGND VPWR VPWR sky130_fd_sc_hd__decap_3
X_4819_ _6918_/Q wire295/X _4817_/X _4818_/X VGND VGND VPWR VPWR _4819_/X sky130_fd_sc_hd__a211o_2
XFILLER_33_1431 VGND VGND VPWR VPWR sky130_fd_sc_hd__decap_3
X_5799_ _5915_/D _5868_/B _5799_/C VGND VGND VPWR VPWR _5799_/X sky130_fd_sc_hd__and3b_2
XFILLER_5_529 VGND VGND VPWR VPWR sky130_fd_sc_hd__decap_3
XFILLER_1_724 VGND VGND VPWR VPWR sky130_fd_sc_hd__decap_3
XFILLER_0_212 VGND VGND VPWR VPWR sky130_fd_sc_hd__decap_3
XFILLER_1_735 VGND VGND VPWR VPWR sky130_fd_sc_hd__decap_3
XFILLER_27_1224 VGND VGND VPWR VPWR sky130_fd_sc_hd__decap_3
XFILLER_66_1273 VGND VGND VPWR VPWR sky130_fd_sc_hd__decap_3
XFILLER_7_1307 VGND VGND VPWR VPWR sky130_fd_sc_hd__decap_3
XFILLER_0_234 VGND VGND VPWR VPWR sky130_fd_sc_hd__decap_3
XFILLER_1_768 VGND VGND VPWR VPWR sky130_fd_sc_hd__decap_3
XFILLER_0_256 VGND VGND VPWR VPWR sky130_fd_sc_hd__decap_3
XFILLER_27_1257 VGND VGND VPWR VPWR sky130_fd_sc_hd__decap_3
XFILLER_76_514 VGND VGND VPWR VPWR sky130_fd_sc_hd__decap_3
XFILLER_76_536 VGND VGND VPWR VPWR sky130_fd_sc_hd__fill_2
XFILLER_40_1424 VGND VGND VPWR VPWR sky130_fd_sc_hd__decap_3
XFILLER_40_1435 VGND VGND VPWR VPWR sky130_fd_sc_hd__decap_3
XFILLER_29_452 VGND VGND VPWR VPWR sky130_fd_sc_hd__decap_3
XFILLER_5_1086 VGND VGND VPWR VPWR sky130_fd_sc_hd__decap_3
XFILLER_40_1468 VGND VGND VPWR VPWR sky130_fd_sc_hd__fill_1
XFILLER_44_411 VGND VGND VPWR VPWR sky130_fd_sc_hd__decap_3
XFILLER_44_433 VGND VGND VPWR VPWR sky130_fd_sc_hd__fill_1
XFILLER_16_135 VGND VGND VPWR VPWR sky130_fd_sc_hd__decap_3
XPHY_EDGE_ROW_19_Right_19 VGND VGND VPWR VPWR sky130_fd_sc_hd__decap_3
XFILLER_60_904 VGND VGND VPWR VPWR sky130_fd_sc_hd__decap_3
XFILLER_32_617 VGND VGND VPWR VPWR sky130_fd_sc_hd__decap_3
XFILLER_44_477 VGND VGND VPWR VPWR sky130_fd_sc_hd__decap_3
XFILLER_38_1320 VGND VGND VPWR VPWR sky130_fd_sc_hd__decap_3
XFILLER_73_1222 VGND VGND VPWR VPWR sky130_fd_sc_hd__decap_3
XFILLER_72_53 VGND VGND VPWR VPWR sky130_fd_sc_hd__decap_3
XFILLER_73_1233 VGND VGND VPWR VPWR sky130_fd_sc_hd__decap_3
XFILLER_38_1353 VGND VGND VPWR VPWR sky130_fd_sc_hd__decap_3
XFILLER_73_1266 VGND VGND VPWR VPWR sky130_fd_sc_hd__decap_3
XFILLER_38_1397 VGND VGND VPWR VPWR sky130_fd_sc_hd__decap_3
XFILLER_34_1239 VGND VGND VPWR VPWR sky130_fd_sc_hd__decap_3
XFILLER_13_897 VGND VGND VPWR VPWR sky130_fd_sc_hd__fill_2
XFILLER_40_694 VGND VGND VPWR VPWR sky130_fd_sc_hd__decap_3
XFILLER_75_9 VGND VGND VPWR VPWR sky130_fd_sc_hd__decap_3
XPHY_EDGE_ROW_28_Right_28 VGND VGND VPWR VPWR sky130_fd_sc_hd__decap_3
XFILLER_10_1250 VGND VGND VPWR VPWR sky130_fd_sc_hd__decap_3
XFILLER_4_551 VGND VGND VPWR VPWR sky130_fd_sc_hd__decap_3
XFILLER_10_1261 VGND VGND VPWR VPWR sky130_fd_sc_hd__decap_3
XFILLER_67_1048 VGND VGND VPWR VPWR sky130_fd_sc_hd__decap_3
XFILLER_4_584 VGND VGND VPWR VPWR sky130_fd_sc_hd__decap_3
XFILLER_49_1460 VGND VGND VPWR VPWR sky130_fd_sc_hd__decap_3
XTAP_TAPCELL_ROW_56_1650 VGND VPWR sky130_fd_sc_hd__tapvpwrvgnd_1
XFILLER_10_1294 VGND VGND VPWR VPWR sky130_fd_sc_hd__decap_3
XFILLER_4_595 VGND VGND VPWR VPWR sky130_fd_sc_hd__decap_3
XTAP_TAPCELL_ROW_56_1661 VGND VPWR sky130_fd_sc_hd__tapvpwrvgnd_1
XFILLER_45_1313 VGND VGND VPWR VPWR sky130_fd_sc_hd__decap_3
XFILLER_80_1226 VGND VGND VPWR VPWR sky130_fd_sc_hd__decap_3
XFILLER_67_503 VGND VGND VPWR VPWR sky130_fd_sc_hd__fill_1
XFILLER_45_1357 VGND VGND VPWR VPWR sky130_fd_sc_hd__decap_3
XTAP_TAPCELL_ROW_52_1547 VGND VPWR sky130_fd_sc_hd__tapvpwrvgnd_1
XFILLER_80_1248 VGND VGND VPWR VPWR sky130_fd_sc_hd__decap_3
X_3150_ _7004_/Q _3219_/B2 _3180_/A1 _3149_/X _3205_/B1 VGND VGND VPWR VPWR _3150_/X
+ sky130_fd_sc_hd__a221o_2
XTAP_TAPCELL_ROW_52_1558 VGND VPWR sky130_fd_sc_hd__tapvpwrvgnd_1
XFILLER_39_249 VGND VGND VPWR VPWR sky130_fd_sc_hd__decap_3
X_3081_ _3488_/B _3100_/B VGND VGND VPWR VPWR _7086_/D sky130_fd_sc_hd__nor2_2
XFILLER_78_1111 VGND VGND VPWR VPWR sky130_fd_sc_hd__decap_3
XPHY_EDGE_ROW_37_Right_37 VGND VGND VPWR VPWR sky130_fd_sc_hd__decap_3
XFILLER_48_794 VGND VGND VPWR VPWR sky130_fd_sc_hd__decap_3
XFILLER_36_945 VGND VGND VPWR VPWR sky130_fd_sc_hd__decap_3
XFILLER_78_1144 VGND VGND VPWR VPWR sky130_fd_sc_hd__decap_3
XFILLER_78_1155 VGND VGND VPWR VPWR sky130_fd_sc_hd__decap_3
XFILLER_1_1440 VGND VGND VPWR VPWR sky130_fd_sc_hd__decap_3
XFILLER_36_967 VGND VGND VPWR VPWR sky130_fd_sc_hd__decap_3
X_6840_ _7090_/CLK _6840_/D fanout716/X VGND VGND VPWR VPWR _6840_/Q sky130_fd_sc_hd__dfrtp_2
XFILLER_35_455 VGND VGND VPWR VPWR sky130_fd_sc_hd__decap_3
XFILLER_36_978 VGND VGND VPWR VPWR sky130_fd_sc_hd__fill_2
XFILLER_39_1117 VGND VGND VPWR VPWR sky130_fd_sc_hd__decap_3
XFILLER_21_1390 VGND VGND VPWR VPWR sky130_fd_sc_hd__decap_3
XFILLER_36_989 VGND VGND VPWR VPWR sky130_fd_sc_hd__fill_2
XFILLER_62_241 VGND VGND VPWR VPWR sky130_fd_sc_hd__fill_2
XFILLER_78_1188 VGND VGND VPWR VPWR sky130_fd_sc_hd__decap_3
XTAP_TAPCELL_ROW_18_664 VGND VPWR sky130_fd_sc_hd__tapvpwrvgnd_1
XTAP_TAPCELL_ROW_18_675 VGND VPWR sky130_fd_sc_hd__tapvpwrvgnd_1
XFILLER_22_105 VGND VGND VPWR VPWR sky130_fd_sc_hd__decap_3
XFILLER_63_797 VGND VGND VPWR VPWR sky130_fd_sc_hd__decap_3
X_6771_ _6772_/CLK _6771_/D load_slew825/X VGND VGND VPWR VPWR _6771_/Q sky130_fd_sc_hd__dfrtp_2
XFILLER_35_499 VGND VGND VPWR VPWR sky130_fd_sc_hd__decap_3
XFILLER_51_948 VGND VGND VPWR VPWR sky130_fd_sc_hd__decap_3
X_3983_ _6227_/Q _4081_/A2 _3981_/X _3982_/X VGND VGND VPWR VPWR _6227_/D sky130_fd_sc_hd__o22a_2
XFILLER_17_1404 VGND VGND VPWR VPWR sky130_fd_sc_hd__decap_3
XFILLER_56_1453 VGND VGND VPWR VPWR sky130_fd_sc_hd__decap_3
XFILLER_52_1306 VGND VGND VPWR VPWR sky130_fd_sc_hd__decap_3
X_5722_ _5722_/A _5758_/B _5758_/C VGND VGND VPWR VPWR _5730_/S sky130_fd_sc_hd__or3_2
XFILLER_50_469 VGND VGND VPWR VPWR sky130_fd_sc_hd__decap_3
XFILLER_17_1437 VGND VGND VPWR VPWR sky130_fd_sc_hd__decap_3
XFILLER_52_1317 VGND VGND VPWR VPWR sky130_fd_sc_hd__decap_3
X_5653_ _5653_/A0 _5901_/A0 _5657_/S VGND VGND VPWR VPWR _6709_/D sky130_fd_sc_hd__mux2_1
XFILLER_15_1161 VGND VGND VPWR VPWR sky130_fd_sc_hd__decap_3
X_4604_ _4604_/A _4604_/B _4604_/C VGND VGND VPWR VPWR _4604_/X sky130_fd_sc_hd__and3_2
XPHY_EDGE_ROW_46_Right_46 VGND VGND VPWR VPWR sky130_fd_sc_hd__decap_3
X_5584_ _5577_/A _5589_/A2 _5567_/Y VGND VGND VPWR VPWR _5584_/Y sky130_fd_sc_hd__a21oi_4
XFILLER_50_1085 VGND VGND VPWR VPWR sky130_fd_sc_hd__decap_3
X_4535_ _4534_/B _4710_/B _4534_/Y _4888_/C1 VGND VGND VPWR VPWR _4535_/Y sky130_fd_sc_hd__o211ai_2
X_4466_ _4586_/B _6517_/Q _4480_/S VGND VGND VPWR VPWR _4466_/X sky130_fd_sc_hd__mux2_1
X_6205_ _7056_/CLK _6205_/D load_slew700/X VGND VGND VPWR VPWR _6205_/Q sky130_fd_sc_hd__dfrtp_2
Xfanout803 fanout848/X VGND VGND VPWR VPWR fanout803/X sky130_fd_sc_hd__clkdlybuf4s25_1
XFILLER_63_1413 VGND VGND VPWR VPWR sky130_fd_sc_hd__decap_3
X_3417_ hold869/X _3416_/X _3465_/S VGND VGND VPWR VPWR _6182_/D sky130_fd_sc_hd__mux2_1
Xfanout814 fanout816/X VGND VGND VPWR VPWR fanout814/X sky130_fd_sc_hd__clkdlybuf4s25_1
X_4397_ _6508_/Q _4396_/A _3486_/B VGND VGND VPWR VPWR _4397_/X sky130_fd_sc_hd__a21bo_2
Xfanout836 fanout841/X VGND VGND VPWR VPWR fanout836/X sky130_fd_sc_hd__clkdlybuf4s25_1
XFILLER_63_1446 VGND VGND VPWR VPWR sky130_fd_sc_hd__decap_3
Xfanout847 fanout848/X VGND VGND VPWR VPWR fanout847/X sky130_fd_sc_hd__clkdlybuf4s25_1
XTAP_TAPCELL_ROW_5_326 VGND VPWR sky130_fd_sc_hd__tapvpwrvgnd_1
X_6136_ _7011_/CLK _6136_/D load_slew815/X VGND VGND VPWR VPWR _6136_/Q sky130_fd_sc_hd__dfrtp_2
XFILLER_63_1457 VGND VGND VPWR VPWR sky130_fd_sc_hd__decap_3
XTAP_TAPCELL_ROW_5_337 VGND VPWR sky130_fd_sc_hd__tapvpwrvgnd_1
XFILLER_58_525 VGND VGND VPWR VPWR sky130_fd_sc_hd__decap_3
X_3348_ _6229_/Q _6405_/Q VGND VGND VPWR VPWR _3348_/X sky130_fd_sc_hd__xor2_2
Xhold1001 _6731_/Q VGND VGND VPWR VPWR _5678_/A0 sky130_fd_sc_hd__dlygate4sd3_1
Xhold1012 _5969_/X VGND VGND VPWR VPWR _6973_/D sky130_fd_sc_hd__dlygate4sd3_1
Xhold1023 _6007_/X VGND VGND VPWR VPWR _7011_/D sky130_fd_sc_hd__dlygate4sd3_1
Xhold1034 _7052_/Q VGND VGND VPWR VPWR _6048_/A1 sky130_fd_sc_hd__dlygate4sd3_1
X_6067_ _6067_/A1 _6062_/X _5685_/C VGND VGND VPWR VPWR _7069_/D sky130_fd_sc_hd__a21o_2
Xhold1045 _6177_/Q VGND VGND VPWR VPWR _6024_/A0 sky130_fd_sc_hd__dlygate4sd3_1
XFILLER_6_1362 VGND VGND VPWR VPWR sky130_fd_sc_hd__decap_3
XPHY_EDGE_ROW_55_Right_55 VGND VGND VPWR VPWR sky130_fd_sc_hd__decap_3
X_3279_ _5960_/A0 _3278_/X _3389_/S VGND VGND VPWR VPWR _6113_/D sky130_fd_sc_hd__mux2_1
Xhold1056 _6213_/Q VGND VGND VPWR VPWR _6060_/A0 sky130_fd_sc_hd__dlygate4sd3_1
XFILLER_6_1373 VGND VGND VPWR VPWR sky130_fd_sc_hd__decap_3
XFILLER_22_1143 VGND VGND VPWR VPWR sky130_fd_sc_hd__decap_3
Xhold1067 _6729_/Q VGND VGND VPWR VPWR _5675_/A0 sky130_fd_sc_hd__dlygate4sd3_1
X_5018_ _5016_/X _5017_/Y _5257_/A2 VGND VGND VPWR VPWR _5020_/S sky130_fd_sc_hd__a21oi_2
XFILLER_39_783 VGND VGND VPWR VPWR sky130_fd_sc_hd__fill_1
Xhold1078 _6210_/Q VGND VGND VPWR VPWR _6057_/A0 sky130_fd_sc_hd__dlygate4sd3_1
XFILLER_73_539 VGND VGND VPWR VPWR sky130_fd_sc_hd__fill_2
XFILLER_2_1226 VGND VGND VPWR VPWR sky130_fd_sc_hd__decap_3
Xhold1089 _6143_/Q VGND VGND VPWR VPWR _5990_/A0 sky130_fd_sc_hd__dlygate4sd3_1
XFILLER_2_1259 VGND VGND VPWR VPWR sky130_fd_sc_hd__fill_1
XFILLER_27_967 VGND VGND VPWR VPWR sky130_fd_sc_hd__fill_1
XFILLER_26_68 VGND VGND VPWR VPWR sky130_fd_sc_hd__fill_2
XFILLER_53_252 VGND VGND VPWR VPWR sky130_fd_sc_hd__decap_3
XFILLER_26_79 VGND VGND VPWR VPWR sky130_fd_sc_hd__decap_3
XFILLER_57_1239 VGND VGND VPWR VPWR sky130_fd_sc_hd__decap_3
XFILLER_26_488 VGND VGND VPWR VPWR sky130_fd_sc_hd__decap_3
X_6969_ _7088_/CLK _6969_/D load_slew769/X VGND VGND VPWR VPWR _6969_/Q sky130_fd_sc_hd__dfrtp_2
XFILLER_70_1406 VGND VGND VPWR VPWR sky130_fd_sc_hd__decap_3
XFILLER_42_12 VGND VGND VPWR VPWR sky130_fd_sc_hd__decap_3
XFILLER_21_160 VGND VGND VPWR VPWR sky130_fd_sc_hd__decap_3
XFILLER_42_67 VGND VGND VPWR VPWR sky130_fd_sc_hd__fill_1
XPHY_EDGE_ROW_64_Right_64 VGND VGND VPWR VPWR sky130_fd_sc_hd__decap_3
XFILLER_10_856 VGND VGND VPWR VPWR sky130_fd_sc_hd__decap_3
XFILLER_33_1272 VGND VGND VPWR VPWR sky130_fd_sc_hd__decap_3
XFILLER_5_337 VGND VGND VPWR VPWR sky130_fd_sc_hd__decap_3
XFILLER_68_1335 VGND VGND VPWR VPWR sky130_fd_sc_hd__decap_3
XFILLER_29_1319 VGND VGND VPWR VPWR sky130_fd_sc_hd__decap_3
XFILLER_68_1368 VGND VGND VPWR VPWR sky130_fd_sc_hd__decap_3
XFILLER_68_1379 VGND VGND VPWR VPWR sky130_fd_sc_hd__decap_3
XFILLER_1_532 VGND VGND VPWR VPWR sky130_fd_sc_hd__fill_2
Xhold890 _6180_/Q VGND VGND VPWR VPWR hold890/X sky130_fd_sc_hd__dlygate4sd3_1
XFILLER_3_39 VGND VGND VPWR VPWR sky130_fd_sc_hd__decap_3
XFILLER_7_1104 VGND VGND VPWR VPWR sky130_fd_sc_hd__decap_3
XFILLER_1_576 VGND VGND VPWR VPWR sky130_fd_sc_hd__decap_3
XFILLER_77_834 VGND VGND VPWR VPWR sky130_fd_sc_hd__decap_3
XFILLER_27_1065 VGND VGND VPWR VPWR sky130_fd_sc_hd__decap_3
XFILLER_67_42 VGND VGND VPWR VPWR sky130_fd_sc_hd__decap_3
XPHY_EDGE_ROW_73_Right_73 VGND VGND VPWR VPWR sky130_fd_sc_hd__decap_3
XFILLER_7_1148 VGND VGND VPWR VPWR sky130_fd_sc_hd__decap_3
XFILLER_67_75 VGND VGND VPWR VPWR sky130_fd_sc_hd__decap_3
XFILLER_40_1243 VGND VGND VPWR VPWR sky130_fd_sc_hd__decap_3
XFILLER_79_1431 VGND VGND VPWR VPWR sky130_fd_sc_hd__decap_3
XFILLER_29_271 VGND VGND VPWR VPWR sky130_fd_sc_hd__decap_3
XFILLER_40_1276 VGND VGND VPWR VPWR sky130_fd_sc_hd__decap_3
XTAP_TAPCELL_ROW_28_940 VGND VPWR sky130_fd_sc_hd__tapvpwrvgnd_1
XFILLER_18_978 VGND VGND VPWR VPWR sky130_fd_sc_hd__fill_2
XFILLER_45_775 VGND VGND VPWR VPWR sky130_fd_sc_hd__decap_3
XFILLER_75_1328 VGND VGND VPWR VPWR sky130_fd_sc_hd__decap_3
XTAP_TAPCELL_ROW_15_601 VGND VPWR sky130_fd_sc_hd__tapvpwrvgnd_1
XFILLER_17_488 VGND VGND VPWR VPWR sky130_fd_sc_hd__decap_3
XFILLER_60_723 VGND VGND VPWR VPWR sky130_fd_sc_hd__decap_3
XFILLER_44_285 VGND VGND VPWR VPWR sky130_fd_sc_hd__decap_3
XFILLER_73_1041 VGND VGND VPWR VPWR sky130_fd_sc_hd__fill_1
XTAP_TAPCELL_ROW_45_1362 VGND VPWR sky130_fd_sc_hd__tapvpwrvgnd_1
XFILLER_13_661 VGND VGND VPWR VPWR sky130_fd_sc_hd__decap_3
XTAP_TAPCELL_ROW_45_1373 VGND VPWR sky130_fd_sc_hd__tapvpwrvgnd_1
XFILLER_34_1025 VGND VGND VPWR VPWR sky130_fd_sc_hd__fill_2
XFILLER_73_1096 VGND VGND VPWR VPWR sky130_fd_sc_hd__fill_1
XFILLER_34_1058 VGND VGND VPWR VPWR sky130_fd_sc_hd__fill_1
XFILLER_8_131 VGND VGND VPWR VPWR sky130_fd_sc_hd__fill_1
XFILLER_73_6 VGND VGND VPWR VPWR sky130_fd_sc_hd__decap_3
XTAP_TAPCELL_ROW_41_1259 VGND VPWR sky130_fd_sc_hd__tapvpwrvgnd_1
XFILLER_9_676 VGND VGND VPWR VPWR sky130_fd_sc_hd__decap_3
XFILLER_12_1312 VGND VGND VPWR VPWR sky130_fd_sc_hd__decap_3
XFILLER_12_1323 VGND VGND VPWR VPWR sky130_fd_sc_hd__decap_3
XFILLER_51_1372 VGND VGND VPWR VPWR sky130_fd_sc_hd__decap_3
XTAP_TAPCELL_ROW_58_1701 VGND VPWR sky130_fd_sc_hd__tapvpwrvgnd_1
XFILLER_8_197 VGND VGND VPWR VPWR sky130_fd_sc_hd__decap_3
XTAP_TAPCELL_ROW_58_1712 VGND VPWR sky130_fd_sc_hd__tapvpwrvgnd_1
XFILLER_12_1356 VGND VGND VPWR VPWR sky130_fd_sc_hd__decap_3
X_4320_ _4817_/A1 _4313_/X _4319_/X VGND VGND VPWR VPWR _4320_/X sky130_fd_sc_hd__o21a_2
XFILLER_47_1419 VGND VGND VPWR VPWR sky130_fd_sc_hd__decap_3
XTAP_TAPCELL_ROW_54_1609 VGND VPWR sky130_fd_sc_hd__tapvpwrvgnd_1
X_4251_ _4338_/A _4829_/B VGND VGND VPWR VPWR _4251_/Y sky130_fd_sc_hd__nand2_2
XFILLER_45_1121 VGND VGND VPWR VPWR sky130_fd_sc_hd__decap_3
X_3202_ _3202_/A _3202_/B _3202_/C VGND VGND VPWR VPWR _3202_/X sky130_fd_sc_hd__and3_2
X_4182_ _4259_/A _4336_/B VGND VGND VPWR VPWR _4183_/B sky130_fd_sc_hd__xor2_2
X_3133_ _3212_/A1 _6963_/Q _6971_/Q _3136_/A VGND VGND VPWR VPWR _3133_/X sky130_fd_sc_hd__a22o_2
XFILLER_80_1089 VGND VGND VPWR VPWR sky130_fd_sc_hd__decap_3
XFILLER_68_889 VGND VGND VPWR VPWR sky130_fd_sc_hd__decap_3
XFILLER_23_1452 VGND VGND VPWR VPWR sky130_fd_sc_hd__decap_3
XFILLER_23_1463 VGND VGND VPWR VPWR sky130_fd_sc_hd__decap_3
XFILLER_67_388 VGND VGND VPWR VPWR sky130_fd_sc_hd__decap_3
X_3064_ _6360_/Q VGND VGND VPWR VPWR _3064_/Y sky130_fd_sc_hd__inv_2
XFILLER_70_509 VGND VGND VPWR VPWR sky130_fd_sc_hd__fill_2
XFILLER_36_775 VGND VGND VPWR VPWR sky130_fd_sc_hd__decap_3
XFILLER_35_252 VGND VGND VPWR VPWR sky130_fd_sc_hd__decap_3
XFILLER_63_572 VGND VGND VPWR VPWR sky130_fd_sc_hd__fill_2
XFILLER_24_937 VGND VGND VPWR VPWR sky130_fd_sc_hd__decap_3
XFILLER_1_1281 VGND VGND VPWR VPWR sky130_fd_sc_hd__decap_3
X_6823_ _6990_/CLK _6823_/D load_slew748/X VGND VGND VPWR VPWR _6823_/Q sky130_fd_sc_hd__dfrtp_2
XFILLER_1_1292 VGND VGND VPWR VPWR sky130_fd_sc_hd__decap_3
XFILLER_51_745 VGND VGND VPWR VPWR sky130_fd_sc_hd__decap_3
XFILLER_23_447 VGND VGND VPWR VPWR sky130_fd_sc_hd__fill_1
XFILLER_23_458 VGND VGND VPWR VPWR sky130_fd_sc_hd__fill_1
XFILLER_56_1250 VGND VGND VPWR VPWR sky130_fd_sc_hd__decap_3
X_6754_ _6986_/CLK _6754_/D load_slew648/X VGND VGND VPWR VPWR _6754_/Q sky130_fd_sc_hd__dfrtp_2
XFILLER_56_1261 VGND VGND VPWR VPWR sky130_fd_sc_hd__decap_3
XFILLER_17_1223 VGND VGND VPWR VPWR sky130_fd_sc_hd__decap_3
X_3966_ _4088_/A1 wire154/X _4277_/B _3958_/Y _6529_/Q VGND VGND VPWR VPWR _3966_/X
+ sky130_fd_sc_hd__a32o_2
XFILLER_52_1114 VGND VGND VPWR VPWR sky130_fd_sc_hd__decap_3
XFILLER_32_981 VGND VGND VPWR VPWR sky130_fd_sc_hd__decap_3
XFILLER_17_1245 VGND VGND VPWR VPWR sky130_fd_sc_hd__decap_3
X_5705_ _5907_/A0 _5705_/A1 wire89/A VGND VGND VPWR VPWR _6754_/D sky130_fd_sc_hd__mux2_1
XFILLER_56_1294 VGND VGND VPWR VPWR sky130_fd_sc_hd__decap_3
X_6685_ _6970_/CLK _6685_/D load_slew671/X VGND VGND VPWR VPWR _6685_/Q sky130_fd_sc_hd__dfrtp_2
XFILLER_17_1278 VGND VGND VPWR VPWR sky130_fd_sc_hd__decap_3
XFILLER_31_491 VGND VGND VPWR VPWR sky130_fd_sc_hd__decap_3
X_3897_ _6341_/Q _3897_/A2 _3895_/X _3896_/X VGND VGND VPWR VPWR _4240_/B sky130_fd_sc_hd__o22a_2
XFILLER_12_15 VGND VGND VPWR VPWR sky130_fd_sc_hd__decap_3
XFILLER_17_1289 VGND VGND VPWR VPWR sky130_fd_sc_hd__decap_3
XFILLER_52_1169 VGND VGND VPWR VPWR sky130_fd_sc_hd__fill_1
X_5636_ _5912_/A0 _5636_/A1 wire93/X VGND VGND VPWR VPWR _6695_/D sky130_fd_sc_hd__mux2_1
XFILLER_30_1412 VGND VGND VPWR VPWR sky130_fd_sc_hd__decap_3
XFILLER_30_1456 VGND VGND VPWR VPWR sky130_fd_sc_hd__decap_3
X_5567_ _5567_/A _5567_/B VGND VGND VPWR VPWR _5567_/Y sky130_fd_sc_hd__nor2_2
X_4518_ _4518_/A _4872_/B VGND VGND VPWR VPWR _4518_/Y sky130_fd_sc_hd__nor2_2
X_5498_ _5498_/A _5498_/B VGND VGND VPWR VPWR _6602_/D sky130_fd_sc_hd__and2_2
XFILLER_5_9 VGND VGND VPWR VPWR sky130_fd_sc_hd__decap_3
X_4449_ _6330_/Q _4861_/A2 _3310_/X _4861_/B2 VGND VGND VPWR VPWR _4449_/X sky130_fd_sc_hd__a22o_2
Xfanout600 input9/X VGND VGND VPWR VPWR _5801_/C sky130_fd_sc_hd__clkdlybuf4s25_1
XFILLER_28_1341 VGND VGND VPWR VPWR sky130_fd_sc_hd__decap_3
XFILLER_63_1221 VGND VGND VPWR VPWR sky130_fd_sc_hd__decap_3
XFILLER_67_1390 VGND VGND VPWR VPWR sky130_fd_sc_hd__decap_3
XFILLER_8_1424 VGND VGND VPWR VPWR sky130_fd_sc_hd__decap_3
Xfanout622 _5918_/A1 VGND VGND VPWR VPWR _5909_/A0 sky130_fd_sc_hd__clkdlybuf4s25_1
Xfanout633 _5784_/C VGND VGND VPWR VPWR _5907_/A0 sky130_fd_sc_hd__clkdlybuf4s25_1
XFILLER_59_823 VGND VGND VPWR VPWR sky130_fd_sc_hd__decap_3
XFILLER_8_1435 VGND VGND VPWR VPWR sky130_fd_sc_hd__decap_3
Xfanout644 fanout653/X VGND VGND VPWR VPWR fanout644/X sky130_fd_sc_hd__clkdlybuf4s25_1
XFILLER_63_1254 VGND VGND VPWR VPWR sky130_fd_sc_hd__decap_3
XFILLER_28_1385 VGND VGND VPWR VPWR sky130_fd_sc_hd__decap_3
XFILLER_8_1468 VGND VGND VPWR VPWR sky130_fd_sc_hd__fill_1
Xfanout666 fanout667/X VGND VGND VPWR VPWR fanout666/X sky130_fd_sc_hd__clkdlybuf4s25_1
XFILLER_24_1238 VGND VGND VPWR VPWR sky130_fd_sc_hd__decap_3
X_6119_ _6752_/CLK _6119_/D load_slew669/X VGND VGND VPWR VPWR _6119_/Q sky130_fd_sc_hd__dfrtp_2
XFILLER_63_1287 VGND VGND VPWR VPWR sky130_fd_sc_hd__fill_1
Xfanout688 fanout698/X VGND VGND VPWR VPWR fanout688/X sky130_fd_sc_hd__clkdlybuf4s25_1
XFILLER_63_1298 VGND VGND VPWR VPWR sky130_fd_sc_hd__decap_3
Xfanout699 fanout699/A VGND VGND VPWR VPWR fanout699/X sky130_fd_sc_hd__clkdlybuf4s25_1
XFILLER_73_303 VGND VGND VPWR VPWR sky130_fd_sc_hd__decap_3
XFILLER_6_1170 VGND VGND VPWR VPWR sky130_fd_sc_hd__decap_3
XFILLER_46_539 VGND VGND VPWR VPWR sky130_fd_sc_hd__decap_3
XFILLER_2_1023 VGND VGND VPWR VPWR sky130_fd_sc_hd__decap_3
XFILLER_39_591 VGND VGND VPWR VPWR sky130_fd_sc_hd__fill_2
XFILLER_27_742 VGND VGND VPWR VPWR sky130_fd_sc_hd__decap_3
XFILLER_2_1067 VGND VGND VPWR VPWR sky130_fd_sc_hd__decap_3
XFILLER_42_701 VGND VGND VPWR VPWR sky130_fd_sc_hd__fill_1
XFILLER_54_572 VGND VGND VPWR VPWR sky130_fd_sc_hd__decap_3
XFILLER_27_797 VGND VGND VPWR VPWR sky130_fd_sc_hd__decap_3
XFILLER_57_1025 VGND VGND VPWR VPWR sky130_fd_sc_hd__decap_3
XFILLER_42_734 VGND VGND VPWR VPWR sky130_fd_sc_hd__decap_3
XFILLER_14_436 VGND VGND VPWR VPWR sky130_fd_sc_hd__decap_3
XFILLER_42_745 VGND VGND VPWR VPWR sky130_fd_sc_hd__fill_2
XFILLER_74_1350 VGND VGND VPWR VPWR sky130_fd_sc_hd__decap_3
XFILLER_35_1301 VGND VGND VPWR VPWR sky130_fd_sc_hd__decap_3
XFILLER_41_255 VGND VGND VPWR VPWR sky130_fd_sc_hd__decap_3
XFILLER_70_1203 VGND VGND VPWR VPWR sky130_fd_sc_hd__fill_1
XFILLER_23_970 VGND VGND VPWR VPWR sky130_fd_sc_hd__decap_3
XFILLER_70_1214 VGND VGND VPWR VPWR sky130_fd_sc_hd__decap_3
XFILLER_35_1334 VGND VGND VPWR VPWR sky130_fd_sc_hd__decap_3
XFILLER_41_277 VGND VGND VPWR VPWR sky130_fd_sc_hd__decap_3
XFILLER_74_1394 VGND VGND VPWR VPWR sky130_fd_sc_hd__decap_3
XFILLER_35_1345 VGND VGND VPWR VPWR sky130_fd_sc_hd__decap_3
XFILLER_22_480 VGND VGND VPWR VPWR sky130_fd_sc_hd__fill_1
XFILLER_70_1247 VGND VGND VPWR VPWR sky130_fd_sc_hd__decap_3
XFILLER_35_1378 VGND VGND VPWR VPWR sky130_fd_sc_hd__decap_3
XFILLER_6_602 VGND VGND VPWR VPWR sky130_fd_sc_hd__decap_3
XFILLER_10_664 VGND VGND VPWR VPWR sky130_fd_sc_hd__decap_3
XFILLER_6_668 VGND VGND VPWR VPWR sky130_fd_sc_hd__decap_3
XFILLER_5_167 VGND VGND VPWR VPWR sky130_fd_sc_hd__fill_1
XTAP_TAPCELL_ROW_9_440 VGND VPWR sky130_fd_sc_hd__tapvpwrvgnd_1
XFILLER_68_1187 VGND VGND VPWR VPWR sky130_fd_sc_hd__decap_3
XFILLER_78_41 VGND VGND VPWR VPWR sky130_fd_sc_hd__decap_3
XFILLER_2_852 VGND VGND VPWR VPWR sky130_fd_sc_hd__decap_3
XFILLER_1_340 VGND VGND VPWR VPWR sky130_fd_sc_hd__decap_3
XFILLER_78_74 VGND VGND VPWR VPWR sky130_fd_sc_hd__decap_3
XFILLER_38_9 VGND VGND VPWR VPWR sky130_fd_sc_hd__decap_3
XFILLER_46_1441 VGND VGND VPWR VPWR sky130_fd_sc_hd__decap_3
XFILLER_78_85 VGND VGND VPWR VPWR sky130_fd_sc_hd__decap_3
XFILLER_2_896 VGND VGND VPWR VPWR sky130_fd_sc_hd__decap_3
XFILLER_1_373 VGND VGND VPWR VPWR sky130_fd_sc_hd__decap_3
XFILLER_49_322 VGND VGND VPWR VPWR sky130_fd_sc_hd__decap_3
XTAP_TAPCELL_ROW_34_1074 VGND VPWR sky130_fd_sc_hd__tapvpwrvgnd_1
XFILLER_42_1338 VGND VGND VPWR VPWR sky130_fd_sc_hd__decap_3
XFILLER_76_141 VGND VGND VPWR VPWR sky130_fd_sc_hd__decap_3
XTAP_TAPCELL_ROW_34_1085 VGND VPWR sky130_fd_sc_hd__tapvpwrvgnd_1
XFILLER_49_366 VGND VGND VPWR VPWR sky130_fd_sc_hd__decap_3
XTAP_TAPCELL_ROW_34_1096 VGND VPWR sky130_fd_sc_hd__tapvpwrvgnd_1
XFILLER_49_399 VGND VGND VPWR VPWR sky130_fd_sc_hd__decap_3
XFILLER_79_1272 VGND VGND VPWR VPWR sky130_fd_sc_hd__decap_3
XFILLER_75_1114 VGND VGND VPWR VPWR sky130_fd_sc_hd__decap_3
XTAP_TAPCELL_ROW_47_1413 VGND VPWR sky130_fd_sc_hd__tapvpwrvgnd_1
XFILLER_18_797 VGND VGND VPWR VPWR sky130_fd_sc_hd__decap_3
XTAP_TAPCELL_ROW_47_1424 VGND VPWR sky130_fd_sc_hd__tapvpwrvgnd_1
XTAP_TAPCELL_ROW_47_1435 VGND VPWR sky130_fd_sc_hd__tapvpwrvgnd_1
XFILLER_75_1136 VGND VGND VPWR VPWR sky130_fd_sc_hd__decap_3
XFILLER_75_1169 VGND VGND VPWR VPWR sky130_fd_sc_hd__decap_3
X_3820_ _3692_/X _3693_/X _3581_/Y VGND VGND VPWR VPWR _3822_/D sky130_fd_sc_hd__a21o_2
XFILLER_53_1401 VGND VGND VPWR VPWR sky130_fd_sc_hd__decap_3
XFILLER_21_918 VGND VGND VPWR VPWR sky130_fd_sc_hd__decap_3
XFILLER_60_575 VGND VGND VPWR VPWR sky130_fd_sc_hd__decap_3
XFILLER_20_417 VGND VGND VPWR VPWR sky130_fd_sc_hd__decap_3
XFILLER_32_277 VGND VGND VPWR VPWR sky130_fd_sc_hd__decap_3
XFILLER_53_1434 VGND VGND VPWR VPWR sky130_fd_sc_hd__decap_3
X_3751_ _3822_/B _3822_/C _3752_/A VGND VGND VPWR VPWR _3879_/B sky130_fd_sc_hd__a21o_2
XFILLER_13_480 VGND VGND VPWR VPWR sky130_fd_sc_hd__fill_1
XFILLER_14_1418 VGND VGND VPWR VPWR sky130_fd_sc_hd__decap_3
XFILLER_14_1429 VGND VGND VPWR VPWR sky130_fd_sc_hd__decap_3
X_6470_ _7064_/CLK _6470_/D fanout719/X VGND VGND VPWR VPWR _6470_/Q sky130_fd_sc_hd__dfrtp_2
XFILLER_71_3 VGND VGND VPWR VPWR sky130_fd_sc_hd__decap_3
X_3682_ _3683_/A _3693_/A VGND VGND VPWR VPWR _3705_/A sky130_fd_sc_hd__nor2_2
XFILLER_12_1131 VGND VGND VPWR VPWR sky130_fd_sc_hd__decap_3
X_5421_ _5421_/A1 _5485_/A2 _3993_/X VGND VGND VPWR VPWR _6533_/D sky130_fd_sc_hd__a21o_2
X_5352_ _6807_/Q _5112_/B _5352_/S VGND VGND VPWR VPWR _5352_/X sky130_fd_sc_hd__mux2_1
XFILLER_12_1186 VGND VGND VPWR VPWR sky130_fd_sc_hd__decap_3
X_4303_ _4303_/A _4303_/B VGND VGND VPWR VPWR _4304_/B sky130_fd_sc_hd__xor2_2
XFILLER_47_1227 VGND VGND VPWR VPWR sky130_fd_sc_hd__decap_3
X_5283_ _6774_/Q _5350_/S _5345_/S _5282_/Y VGND VGND VPWR VPWR _5283_/X sky130_fd_sc_hd__o211a_2
X_7022_ _7022_/CLK _7022_/D fanout761/X VGND VGND VPWR VPWR _7022_/Q sky130_fd_sc_hd__dfrtp_2
XFILLER_59_119 VGND VGND VPWR VPWR sky130_fd_sc_hd__decap_3
XFILLER_4_71 VGND VGND VPWR VPWR sky130_fd_sc_hd__decap_3
X_4234_ _4318_/A _4815_/B _4229_/X _4874_/A1 VGND VGND VPWR VPWR _4234_/X sky130_fd_sc_hd__o2bb2a_2
XFILLER_60_1427 VGND VGND VPWR VPWR sky130_fd_sc_hd__fill_1
X_4165_ _4756_/A1 _4159_/X _4164_/X VGND VGND VPWR VPWR _4165_/X sky130_fd_sc_hd__o21a_2
XFILLER_60_1438 VGND VGND VPWR VPWR sky130_fd_sc_hd__decap_3
XFILLER_28_517 VGND VGND VPWR VPWR sky130_fd_sc_hd__decap_3
XFILLER_3_1310 VGND VGND VPWR VPWR sky130_fd_sc_hd__decap_3
X_3116_ _6081_/A _7026_/Q _7034_/Q _6081_/B VGND VGND VPWR VPWR _3116_/X sky130_fd_sc_hd__a22o_2
X_4096_ _6598_/Q _4777_/A _4097_/A1 VGND VGND VPWR VPWR _4096_/X sky130_fd_sc_hd__a21bo_2
XFILLER_23_1260 VGND VGND VPWR VPWR sky130_fd_sc_hd__decap_3
XFILLER_3_1343 VGND VGND VPWR VPWR sky130_fd_sc_hd__fill_1
XFILLER_3_1354 VGND VGND VPWR VPWR sky130_fd_sc_hd__decap_3
X_3047_ _7067_/Q VGND VGND VPWR VPWR _5740_/C sky130_fd_sc_hd__inv_2
XFILLER_71_829 VGND VGND VPWR VPWR sky130_fd_sc_hd__decap_3
XFILLER_36_550 VGND VGND VPWR VPWR sky130_fd_sc_hd__decap_3
XFILLER_58_1312 VGND VGND VPWR VPWR sky130_fd_sc_hd__decap_3
XFILLER_3_1387 VGND VGND VPWR VPWR sky130_fd_sc_hd__decap_3
XFILLER_24_701 VGND VGND VPWR VPWR sky130_fd_sc_hd__fill_1
XFILLER_58_1323 VGND VGND VPWR VPWR sky130_fd_sc_hd__decap_3
XFILLER_64_881 VGND VGND VPWR VPWR sky130_fd_sc_hd__fill_2
XFILLER_19_1307 VGND VGND VPWR VPWR sky130_fd_sc_hd__decap_3
XFILLER_58_1356 VGND VGND VPWR VPWR sky130_fd_sc_hd__decap_3
XFILLER_51_531 VGND VGND VPWR VPWR sky130_fd_sc_hd__decap_3
XFILLER_63_391 VGND VGND VPWR VPWR sky130_fd_sc_hd__fill_1
X_6806_ _7063_/CLK _6806_/D fanout768/A VGND VGND VPWR VPWR _6806_/Q sky130_fd_sc_hd__dfrtp_2
XFILLER_51_564 VGND VGND VPWR VPWR sky130_fd_sc_hd__fill_1
X_4998_ _6695_/Q _3061_/Y _5261_/A VGND VGND VPWR VPWR _4998_/X sky130_fd_sc_hd__mux2_1
XFILLER_23_266 VGND VGND VPWR VPWR sky130_fd_sc_hd__fill_1
XFILLER_11_428 VGND VGND VPWR VPWR sky130_fd_sc_hd__decap_3
XFILLER_17_1031 VGND VGND VPWR VPWR sky130_fd_sc_hd__fill_2
XFILLER_23_299 VGND VGND VPWR VPWR sky130_fd_sc_hd__fill_2
X_6737_ _6865_/CLK _6737_/D wire712/X VGND VGND VPWR VPWR _6737_/Q sky130_fd_sc_hd__dfrtp_2
X_3949_ _6327_/Q _5517_/A3 _3947_/X _3948_/X VGND VGND VPWR VPWR _4258_/B sky130_fd_sc_hd__o22a_2
X_6668_ _7052_/CLK _6668_/D fanout797/X VGND VGND VPWR VPWR _6668_/Q sky130_fd_sc_hd__dfrtp_2
XFILLER_20_973 VGND VGND VPWR VPWR sky130_fd_sc_hd__decap_3
XFILLER_20_984 VGND VGND VPWR VPWR sky130_fd_sc_hd__fill_1
X_5619_ _7069_/Q _5703_/A _5694_/C VGND VGND VPWR VPWR _5626_/S sky130_fd_sc_hd__and3_2
XTAP_TAPCELL_ROW_30_990 VGND VPWR sky130_fd_sc_hd__tapvpwrvgnd_1
XFILLER_30_1253 VGND VGND VPWR VPWR sky130_fd_sc_hd__decap_3
X_6599_ _6905_/CLK _6599_/D wire738/X VGND VGND VPWR VPWR _6599_/Q sky130_fd_sc_hd__dfrtp_2
XFILLER_30_1264 VGND VGND VPWR VPWR sky130_fd_sc_hd__decap_3
XFILLER_69_1452 VGND VGND VPWR VPWR sky130_fd_sc_hd__decap_3
XFILLER_69_1463 VGND VGND VPWR VPWR sky130_fd_sc_hd__decap_3
XFILLER_2_115 VGND VGND VPWR VPWR sky130_fd_sc_hd__decap_3
XFILLER_30_1297 VGND VGND VPWR VPWR sky130_fd_sc_hd__decap_3
XFILLER_3_649 VGND VGND VPWR VPWR sky130_fd_sc_hd__decap_3
XFILLER_65_1316 VGND VGND VPWR VPWR sky130_fd_sc_hd__decap_3
XFILLER_3_6 VGND VGND VPWR VPWR sky130_fd_sc_hd__decap_3
XFILLER_2_159 VGND VGND VPWR VPWR sky130_fd_sc_hd__decap_3
XFILLER_8_1232 VGND VGND VPWR VPWR sky130_fd_sc_hd__decap_3
Xfanout430 _3082_/X VGND VGND VPWR VPWR wire431/A sky130_fd_sc_hd__clkdlybuf4s25_1
Xfanout452 _5514_/A VGND VGND VPWR VPWR _4783_/A sky130_fd_sc_hd__clkdlybuf4s25_1
XFILLER_28_1193 VGND VGND VPWR VPWR sky130_fd_sc_hd__decap_3
Xfanout463 _7090_/Q VGND VGND VPWR VPWR _4838_/A1 sky130_fd_sc_hd__clkdlybuf4s25_1
XFILLER_8_1276 VGND VGND VPWR VPWR sky130_fd_sc_hd__decap_3
Xfanout474 _4680_/C1 VGND VGND VPWR VPWR _4880_/C1 sky130_fd_sc_hd__clkdlybuf4s25_1
XFILLER_58_141 VGND VGND VPWR VPWR sky130_fd_sc_hd__fill_2
XFILLER_74_601 VGND VGND VPWR VPWR sky130_fd_sc_hd__fill_1
Xfanout485 _4091_/A1 VGND VGND VPWR VPWR _4123_/B2 sky130_fd_sc_hd__clkdlybuf4s25_1
XFILLER_4_1129 VGND VGND VPWR VPWR sky130_fd_sc_hd__decap_3
XFILLER_48_88 VGND VGND VPWR VPWR sky130_fd_sc_hd__decap_3
Xfanout496 _7088_/Q VGND VGND VPWR VPWR _3486_/A sky130_fd_sc_hd__clkdlybuf4s25_1
XFILLER_24_1079 VGND VGND VPWR VPWR sky130_fd_sc_hd__decap_3
XFILLER_0_18 VGND VGND VPWR VPWR sky130_fd_sc_hd__decap_3
XFILLER_41_1360 VGND VGND VPWR VPWR sky130_fd_sc_hd__decap_3
XFILLER_73_122 VGND VGND VPWR VPWR sky130_fd_sc_hd__fill_2
XFILLER_0_29 VGND VGND VPWR VPWR sky130_fd_sc_hd__decap_3
XFILLER_64_21 VGND VGND VPWR VPWR sky130_fd_sc_hd__decap_3
XFILLER_34_509 VGND VGND VPWR VPWR sky130_fd_sc_hd__decap_3
XFILLER_41_1393 VGND VGND VPWR VPWR sky130_fd_sc_hd__decap_3
XFILLER_64_32 VGND VGND VPWR VPWR sky130_fd_sc_hd__decap_3
XFILLER_62_829 VGND VGND VPWR VPWR sky130_fd_sc_hd__decap_3
XFILLER_76_1412 VGND VGND VPWR VPWR sky130_fd_sc_hd__decap_3
XFILLER_64_54 VGND VGND VPWR VPWR sky130_fd_sc_hd__decap_3
XFILLER_15_723 VGND VGND VPWR VPWR sky130_fd_sc_hd__decap_3
XFILLER_27_583 VGND VGND VPWR VPWR sky130_fd_sc_hd__decap_3
XFILLER_76_1456 VGND VGND VPWR VPWR sky130_fd_sc_hd__decap_3
XFILLER_37_1407 VGND VGND VPWR VPWR sky130_fd_sc_hd__decap_3
XFILLER_42_520 VGND VGND VPWR VPWR sky130_fd_sc_hd__decap_3
XFILLER_15_756 VGND VGND VPWR VPWR sky130_fd_sc_hd__decap_3
XFILLER_72_1309 VGND VGND VPWR VPWR sky130_fd_sc_hd__decap_3
XFILLER_70_862 VGND VGND VPWR VPWR sky130_fd_sc_hd__decap_3
XFILLER_9_27 VGND VGND VPWR VPWR sky130_fd_sc_hd__decap_3
XFILLER_74_1191 VGND VGND VPWR VPWR sky130_fd_sc_hd__decap_3
XFILLER_35_1142 VGND VGND VPWR VPWR sky130_fd_sc_hd__decap_3
XFILLER_80_53 VGND VGND VPWR VPWR sky130_fd_sc_hd__decap_3
XFILLER_11_940 VGND VGND VPWR VPWR sky130_fd_sc_hd__decap_3
Xfanout70 _4104_/C1 VGND VGND VPWR VPWR _4080_/C1 sky130_fd_sc_hd__clkdlybuf4s25_1
XFILLER_80_64 VGND VGND VPWR VPWR sky130_fd_sc_hd__decap_3
XFILLER_70_1055 VGND VGND VPWR VPWR sky130_fd_sc_hd__decap_3
XFILLER_11_962 VGND VGND VPWR VPWR sky130_fd_sc_hd__decap_3
XFILLER_35_1175 VGND VGND VPWR VPWR sky130_fd_sc_hd__fill_1
XFILLER_6_410 VGND VGND VPWR VPWR sky130_fd_sc_hd__decap_3
XFILLER_13_1440 VGND VGND VPWR VPWR sky130_fd_sc_hd__decap_3
XFILLER_10_472 VGND VGND VPWR VPWR sky130_fd_sc_hd__decap_3
XFILLER_6_421 VGND VGND VPWR VPWR sky130_fd_sc_hd__decap_3
XFILLER_13_80 VGND VGND VPWR VPWR sky130_fd_sc_hd__decap_3
XFILLER_10_483 VGND VGND VPWR VPWR sky130_fd_sc_hd__fill_2
XFILLER_6_498 VGND VGND VPWR VPWR sky130_fd_sc_hd__decap_3
XTAP_TAPCELL_ROW_36_1125 VGND VPWR sky130_fd_sc_hd__tapvpwrvgnd_1
XTAP_TAPCELL_ROW_36_1136 VGND VPWR sky130_fd_sc_hd__tapvpwrvgnd_1
XFILLER_2_660 VGND VGND VPWR VPWR sky130_fd_sc_hd__decap_3
XTAP_TAPCELL_ROW_36_1147 VGND VPWR sky130_fd_sc_hd__tapvpwrvgnd_1
Xload_slew825 fanout824/X VGND VGND VPWR VPWR load_slew825/X sky130_fd_sc_hd__buf_4
XFILLER_36_6 VGND VGND VPWR VPWR sky130_fd_sc_hd__fill_1
XFILLER_69_428 VGND VGND VPWR VPWR sky130_fd_sc_hd__decap_3
XFILLER_2_693 VGND VGND VPWR VPWR sky130_fd_sc_hd__decap_3
XFILLER_1_181 VGND VGND VPWR VPWR sky130_fd_sc_hd__decap_3
XFILLER_46_1282 VGND VGND VPWR VPWR sky130_fd_sc_hd__decap_3
XFILLER_78_984 VGND VGND VPWR VPWR sky130_fd_sc_hd__fill_1
XFILLER_65_601 VGND VGND VPWR VPWR sky130_fd_sc_hd__decap_3
XFILLER_37_314 VGND VGND VPWR VPWR sky130_fd_sc_hd__decap_3
XFILLER_20_1400 VGND VGND VPWR VPWR sky130_fd_sc_hd__decap_3
XFILLER_65_634 VGND VGND VPWR VPWR sky130_fd_sc_hd__decap_3
XFILLER_64_122 VGND VGND VPWR VPWR sky130_fd_sc_hd__decap_3
XFILLER_80_604 VGND VGND VPWR VPWR sky130_fd_sc_hd__decap_3
XFILLER_20_1444 VGND VGND VPWR VPWR sky130_fd_sc_hd__decap_3
XFILLER_37_369 VGND VGND VPWR VPWR sky130_fd_sc_hd__decap_3
X_5970_ hold864/X _6974_/Q _5970_/S VGND VGND VPWR VPWR _5970_/X sky130_fd_sc_hd__mux2_1
XFILLER_18_561 VGND VGND VPWR VPWR sky130_fd_sc_hd__decap_3
XFILLER_80_626 VGND VGND VPWR VPWR sky130_fd_sc_hd__fill_2
X_4921_ _6684_/Q _3050_/Y _5213_/A VGND VGND VPWR VPWR _4921_/X sky130_fd_sc_hd__mux2_1
XFILLER_79_1091 VGND VGND VPWR VPWR sky130_fd_sc_hd__decap_3
XFILLER_33_520 VGND VGND VPWR VPWR sky130_fd_sc_hd__decap_3
XFILLER_52_339 VGND VGND VPWR VPWR sky130_fd_sc_hd__decap_3
XFILLER_33_553 VGND VGND VPWR VPWR sky130_fd_sc_hd__decap_3
XFILLER_61_862 VGND VGND VPWR VPWR sky130_fd_sc_hd__decap_3
X_4852_ _6585_/Q _4879_/B _4793_/A VGND VGND VPWR VPWR _4852_/X sky130_fd_sc_hd__a21bo_2
XFILLER_33_564 VGND VGND VPWR VPWR sky130_fd_sc_hd__decap_3
XFILLER_21_715 VGND VGND VPWR VPWR sky130_fd_sc_hd__decap_3
XFILLER_61_895 VGND VGND VPWR VPWR sky130_fd_sc_hd__fill_1
XFILLER_20_203 VGND VGND VPWR VPWR sky130_fd_sc_hd__decap_3
X_3803_ _6322_/Q _3807_/A2 _3801_/X _3802_/X VGND VGND VPWR VPWR _4292_/A sky130_fd_sc_hd__o22a_2
XFILLER_18_1362 VGND VGND VPWR VPWR sky130_fd_sc_hd__decap_3
X_4783_ _4783_/A _4783_/B _4783_/C VGND VGND VPWR VPWR _4835_/S sky130_fd_sc_hd__or3_2
XFILLER_53_1242 VGND VGND VPWR VPWR sky130_fd_sc_hd__decap_3
XFILLER_18_1373 VGND VGND VPWR VPWR sky130_fd_sc_hd__decap_3
XFILLER_14_1226 VGND VGND VPWR VPWR sky130_fd_sc_hd__decap_3
X_6522_ _6926_/CLK _6522_/D fanout758/X VGND VGND VPWR VPWR _6522_/Q sky130_fd_sc_hd__dfrtp_2
XFILLER_53_1275 VGND VGND VPWR VPWR sky130_fd_sc_hd__decap_3
X_3734_ _6328_/Q _4829_/A _3732_/X _3733_/X VGND VGND VPWR VPWR _4200_/A sky130_fd_sc_hd__o22a_2
XFILLER_14_1259 VGND VGND VPWR VPWR sky130_fd_sc_hd__fill_1
XFILLER_9_281 VGND VGND VPWR VPWR sky130_fd_sc_hd__decap_3
X_6453_ _6991_/CLK _6453_/D fanout806/X VGND VGND VPWR VPWR _6453_/Q sky130_fd_sc_hd__dfrtp_2
X_3665_ _3665_/A _3665_/B _3879_/A VGND VGND VPWR VPWR _3666_/B sky130_fd_sc_hd__and3_2
Xclkload40 _6926_/CLK VGND VGND VPWR VPWR clkload40/Y sky130_fd_sc_hd__bufinv_16
X_5404_ _5404_/A1 _5468_/A2 _4462_/X VGND VGND VPWR VPWR _6516_/D sky130_fd_sc_hd__a21o_2
Xclkload51 _7009_/CLK VGND VGND VPWR VPWR clkload51/X sky130_fd_sc_hd__clkbuf_4
Xclkload62 _7035_/CLK VGND VGND VPWR VPWR clkload62/X sky130_fd_sc_hd__clkbuf_4
X_6384_ _6986_/CLK _6384_/D load_slew648/X VGND VGND VPWR VPWR _6384_/Q sky130_fd_sc_hd__dfrtp_2
X_3596_ _6253_/Q _6261_/Q _6269_/Q _6221_/Q _3597_/S0 _3601_/A VGND VGND VPWR VPWR
+ _3596_/X sky130_fd_sc_hd__mux4_2
X_5335_ _6460_/Q _5334_/X _5335_/S VGND VGND VPWR VPWR _6460_/D sky130_fd_sc_hd__mux2_1
XFILLER_47_1068 VGND VGND VPWR VPWR sky130_fd_sc_hd__decap_3
X_5266_ _6430_/Q _5269_/A2 _5265_/X VGND VGND VPWR VPWR _6430_/D sky130_fd_sc_hd__a21o_2
XFILLER_25_1322 VGND VGND VPWR VPWR sky130_fd_sc_hd__decap_3
X_7005_ _7037_/CLK _7005_/D fanout675/X VGND VGND VPWR VPWR _7005_/Q sky130_fd_sc_hd__dfrtp_2
XFILLER_64_1371 VGND VGND VPWR VPWR sky130_fd_sc_hd__fill_1
XFILLER_69_951 VGND VGND VPWR VPWR sky130_fd_sc_hd__fill_1
X_4217_ _6258_/Q _4863_/A2 _4214_/X _4216_/X VGND VGND VPWR VPWR _6258_/D sky130_fd_sc_hd__o22a_2
XFILLER_64_1382 VGND VGND VPWR VPWR sky130_fd_sc_hd__decap_3
XFILLER_69_962 VGND VGND VPWR VPWR sky130_fd_sc_hd__decap_3
XFILLER_5_1416 VGND VGND VPWR VPWR sky130_fd_sc_hd__decap_3
X_5197_ _5196_/Y _5130_/X _5221_/A2 _6407_/Q VGND VGND VPWR VPWR _6407_/D sky130_fd_sc_hd__a2bb2o_2
XFILLER_60_1235 VGND VGND VPWR VPWR sky130_fd_sc_hd__decap_3
XFILLER_25_1366 VGND VGND VPWR VPWR sky130_fd_sc_hd__decap_3
XFILLER_69_995 VGND VGND VPWR VPWR sky130_fd_sc_hd__decap_3
XFILLER_29_837 VGND VGND VPWR VPWR sky130_fd_sc_hd__decap_3
XFILLER_5_1449 VGND VGND VPWR VPWR sky130_fd_sc_hd__decap_3
XFILLER_68_483 VGND VGND VPWR VPWR sky130_fd_sc_hd__fill_1
X_4148_ _6251_/Q wire54/X _4145_/X _4147_/X VGND VGND VPWR VPWR _6251_/D sky130_fd_sc_hd__o22a_2
XFILLER_25_1399 VGND VGND VPWR VPWR sky130_fd_sc_hd__fill_1
XFILLER_56_645 VGND VGND VPWR VPWR sky130_fd_sc_hd__decap_3
XFILLER_60_1279 VGND VGND VPWR VPWR sky130_fd_sc_hd__decap_3
XFILLER_55_122 VGND VGND VPWR VPWR sky130_fd_sc_hd__decap_3
XFILLER_28_358 VGND VGND VPWR VPWR sky130_fd_sc_hd__decap_3
XFILLER_3_1151 VGND VGND VPWR VPWR sky130_fd_sc_hd__decap_3
XFILLER_16_509 VGND VGND VPWR VPWR sky130_fd_sc_hd__decap_3
XFILLER_43_306 VGND VGND VPWR VPWR sky130_fd_sc_hd__fill_2
XFILLER_55_166 VGND VGND VPWR VPWR sky130_fd_sc_hd__fill_2
X_4079_ _4097_/A1 _4076_/X _4077_/Y _4078_/X _4013_/A VGND VGND VPWR VPWR _4079_/X
+ sky130_fd_sc_hd__o221a_2
XFILLER_37_870 VGND VGND VPWR VPWR sky130_fd_sc_hd__decap_3
XFILLER_55_177 VGND VGND VPWR VPWR sky130_fd_sc_hd__decap_3
XFILLER_37_892 VGND VGND VPWR VPWR sky130_fd_sc_hd__decap_3
XFILLER_3_1195 VGND VGND VPWR VPWR sky130_fd_sc_hd__decap_3
XFILLER_19_1104 VGND VGND VPWR VPWR sky130_fd_sc_hd__decap_3
XFILLER_24_531 VGND VGND VPWR VPWR sky130_fd_sc_hd__fill_1
XFILLER_52_840 VGND VGND VPWR VPWR sky130_fd_sc_hd__decap_3
XFILLER_24_542 VGND VGND VPWR VPWR sky130_fd_sc_hd__decap_3
XFILLER_52_884 VGND VGND VPWR VPWR sky130_fd_sc_hd__decap_3
XFILLER_24_586 VGND VGND VPWR VPWR sky130_fd_sc_hd__fill_2
XFILLER_51_372 VGND VGND VPWR VPWR sky130_fd_sc_hd__decap_3
XFILLER_71_1331 VGND VGND VPWR VPWR sky130_fd_sc_hd__decap_3
XFILLER_11_225 VGND VGND VPWR VPWR sky130_fd_sc_hd__decap_3
XFILLER_36_1462 VGND VGND VPWR VPWR sky130_fd_sc_hd__decap_3
XFILLER_8_719 VGND VGND VPWR VPWR sky130_fd_sc_hd__decap_3
Xwire105 wire105/A VGND VGND VPWR VPWR wire105/X sky130_fd_sc_hd__buf_4
Xclkload1 clkload1/A VGND VGND VPWR VPWR clkload1/X sky130_fd_sc_hd__clkbuf_8
XFILLER_32_1315 VGND VGND VPWR VPWR sky130_fd_sc_hd__fill_1
XFILLER_71_1375 VGND VGND VPWR VPWR sky130_fd_sc_hd__decap_3
XTAP_TAPCELL_ROW_22_765 VGND VPWR sky130_fd_sc_hd__tapvpwrvgnd_1
XFILLER_32_1326 VGND VGND VPWR VPWR sky130_fd_sc_hd__decap_3
XTAP_TAPCELL_ROW_22_776 VGND VPWR sky130_fd_sc_hd__tapvpwrvgnd_1
Xwire127 wire127/A VGND VGND VPWR VPWR _5341_/S sky130_fd_sc_hd__clkbuf_4
Xwire149 _3848_/A VGND VGND VPWR VPWR _4316_/A sky130_fd_sc_hd__buf_2
XFILLER_32_1359 VGND VGND VPWR VPWR sky130_fd_sc_hd__decap_3
XFILLER_4_903 VGND VGND VPWR VPWR sky130_fd_sc_hd__decap_3
XFILLER_3_402 VGND VGND VPWR VPWR sky130_fd_sc_hd__decap_3
XTAP_TAPCELL_ROW_76_2173 VGND VPWR sky130_fd_sc_hd__tapvpwrvgnd_1
XTAP_TAPCELL_ROW_76_2184 VGND VPWR sky130_fd_sc_hd__tapvpwrvgnd_1
XFILLER_3_435 VGND VGND VPWR VPWR sky130_fd_sc_hd__decap_3
XFILLER_69_1260 VGND VGND VPWR VPWR sky130_fd_sc_hd__decap_3
XFILLER_1_3 VGND VGND VPWR VPWR sky130_fd_sc_hd__decap_3
XFILLER_59_43 VGND VGND VPWR VPWR sky130_fd_sc_hd__decap_3
XFILLER_78_203 VGND VGND VPWR VPWR sky130_fd_sc_hd__fill_1
XFILLER_79_759 VGND VGND VPWR VPWR sky130_fd_sc_hd__decap_3
XFILLER_43_1422 VGND VGND VPWR VPWR sky130_fd_sc_hd__decap_3
XFILLER_8_1040 VGND VGND VPWR VPWR sky130_fd_sc_hd__decap_3
XTAP_TAPCELL_ROW_31_1000 VGND VPWR sky130_fd_sc_hd__tapvpwrvgnd_1
XTAP_TAPCELL_ROW_31_1011 VGND VPWR sky130_fd_sc_hd__tapvpwrvgnd_1
XFILLER_43_1455 VGND VGND VPWR VPWR sky130_fd_sc_hd__fill_1
XFILLER_59_461 VGND VGND VPWR VPWR sky130_fd_sc_hd__decap_3
Xfanout282 _4833_/A2 VGND VGND VPWR VPWR _4635_/A2 sky130_fd_sc_hd__clkdlybuf4s25_1
XFILLER_43_1466 VGND VGND VPWR VPWR sky130_fd_sc_hd__decap_3
XFILLER_75_53 VGND VGND VPWR VPWR sky130_fd_sc_hd__decap_3
XFILLER_47_645 VGND VGND VPWR VPWR sky130_fd_sc_hd__fill_1
XFILLER_46_144 VGND VGND VPWR VPWR sky130_fd_sc_hd__fill_2
XFILLER_62_604 VGND VGND VPWR VPWR sky130_fd_sc_hd__fill_1
Xload_slew46 _4758_/B1 VGND VGND VPWR VPWR _4876_/B1 sky130_fd_sc_hd__buf_4
XFILLER_28_881 VGND VGND VPWR VPWR sky130_fd_sc_hd__decap_3
Xload_slew68 _4664_/S VGND VGND VPWR VPWR _4759_/A2 sky130_fd_sc_hd__buf_4
XFILLER_76_1220 VGND VGND VPWR VPWR sky130_fd_sc_hd__decap_3
XFILLER_15_531 VGND VGND VPWR VPWR sky130_fd_sc_hd__decap_3
XFILLER_76_1253 VGND VGND VPWR VPWR sky130_fd_sc_hd__decap_3
XFILLER_76_1264 VGND VGND VPWR VPWR sky130_fd_sc_hd__decap_3
XFILLER_61_169 VGND VGND VPWR VPWR sky130_fd_sc_hd__fill_2
XFILLER_72_1117 VGND VGND VPWR VPWR sky130_fd_sc_hd__decap_3
XFILLER_15_564 VGND VGND VPWR VPWR sky130_fd_sc_hd__decap_3
XFILLER_76_1297 VGND VGND VPWR VPWR sky130_fd_sc_hd__decap_3
XFILLER_37_1248 VGND VGND VPWR VPWR sky130_fd_sc_hd__decap_3
XFILLER_30_523 VGND VGND VPWR VPWR sky130_fd_sc_hd__decap_3
XFILLER_30_556 VGND VGND VPWR VPWR sky130_fd_sc_hd__decap_3
XFILLER_50_1415 VGND VGND VPWR VPWR sky130_fd_sc_hd__decap_3
XTAP_TAPCELL_ROW_61_1774 VGND VPWR sky130_fd_sc_hd__tapvpwrvgnd_1
XTAP_TAPCELL_ROW_61_1785 VGND VPWR sky130_fd_sc_hd__tapvpwrvgnd_1
XTAP_TAPCELL_ROW_61_1796 VGND VPWR sky130_fd_sc_hd__tapvpwrvgnd_1
XFILLER_50_1459 VGND VGND VPWR VPWR sky130_fd_sc_hd__decap_3
XFILLER_7_785 VGND VGND VPWR VPWR sky130_fd_sc_hd__decap_3
XFILLER_13_1281 VGND VGND VPWR VPWR sky130_fd_sc_hd__decap_3
X_3450_ _6336_/Q _6456_/Q VGND VGND VPWR VPWR _3450_/X sky130_fd_sc_hd__xor2_2
XFILLER_13_1292 VGND VGND VPWR VPWR sky130_fd_sc_hd__decap_3
XFILLER_48_1300 VGND VGND VPWR VPWR sky130_fd_sc_hd__decap_3
XFILLER_6_284 VGND VGND VPWR VPWR sky130_fd_sc_hd__decap_3
X_3381_ _6011_/A0 _3380_/X _3461_/S VGND VGND VPWR VPWR _6164_/D sky130_fd_sc_hd__mux2_1
XFILLER_48_1344 VGND VGND VPWR VPWR sky130_fd_sc_hd__decap_3
X_5120_ _6438_/Q _5120_/B VGND VGND VPWR VPWR _5288_/B sky130_fd_sc_hd__xnor2_2
XFILLER_3_980 VGND VGND VPWR VPWR sky130_fd_sc_hd__decap_3
Xload_slew611 _5664_/A0 VGND VGND VPWR VPWR _5912_/A0 sky130_fd_sc_hd__buf_4
XFILLER_34_3 VGND VGND VPWR VPWR sky130_fd_sc_hd__decap_3
XFILLER_48_1388 VGND VGND VPWR VPWR sky130_fd_sc_hd__decap_3
X_5051_ _6397_/Q _5261_/B VGND VGND VPWR VPWR _5051_/X sky130_fd_sc_hd__or2_2
Xhold1408 _6913_/Q VGND VGND VPWR VPWR _5905_/A1 sky130_fd_sc_hd__dlygate4sd3_1
Xload_slew677 fanout676/X VGND VGND VPWR VPWR load_slew677/X sky130_fd_sc_hd__clkbuf_4
Xhold1419 _6534_/Q VGND VGND VPWR VPWR _5422_/A1 sky130_fd_sc_hd__dlygate4sd3_1
XFILLER_66_910 VGND VGND VPWR VPWR sky130_fd_sc_hd__decap_3
X_4002_ _5512_/A _4002_/A2 _4344_/B _3958_/Y _6535_/Q VGND VGND VPWR VPWR _4002_/X
+ sky130_fd_sc_hd__a32o_2
XFILLER_37_133 VGND VGND VPWR VPWR sky130_fd_sc_hd__decap_3
XFILLER_66_965 VGND VGND VPWR VPWR sky130_fd_sc_hd__decap_3
XFILLER_1_72 VGND VGND VPWR VPWR sky130_fd_sc_hd__decap_3
XFILLER_65_464 VGND VGND VPWR VPWR sky130_fd_sc_hd__decap_3
XFILLER_53_615 VGND VGND VPWR VPWR sky130_fd_sc_hd__fill_1
XFILLER_80_412 VGND VGND VPWR VPWR sky130_fd_sc_hd__decap_3
XFILLER_0_1313 VGND VGND VPWR VPWR sky130_fd_sc_hd__decap_3
XFILLER_25_317 VGND VGND VPWR VPWR sky130_fd_sc_hd__decap_3
XFILLER_20_1252 VGND VGND VPWR VPWR sky130_fd_sc_hd__decap_3
XFILLER_0_1335 VGND VGND VPWR VPWR sky130_fd_sc_hd__decap_3
XFILLER_19_892 VGND VGND VPWR VPWR sky130_fd_sc_hd__decap_3
XFILLER_59_1440 VGND VGND VPWR VPWR sky130_fd_sc_hd__decap_3
XFILLER_18_380 VGND VGND VPWR VPWR sky130_fd_sc_hd__decap_3
XFILLER_80_445 VGND VGND VPWR VPWR sky130_fd_sc_hd__decap_3
XFILLER_20_1285 VGND VGND VPWR VPWR sky130_fd_sc_hd__decap_3
X_5953_ _5953_/A0 _6957_/Q _6049_/S VGND VGND VPWR VPWR _5953_/X sky130_fd_sc_hd__mux2_1
XFILLER_52_136 VGND VGND VPWR VPWR sky130_fd_sc_hd__decap_3
XFILLER_0_1357 VGND VGND VPWR VPWR sky130_fd_sc_hd__decap_3
XFILLER_55_1304 VGND VGND VPWR VPWR sky130_fd_sc_hd__decap_3
XFILLER_0_1379 VGND VGND VPWR VPWR sky130_fd_sc_hd__decap_3
XFILLER_40_309 VGND VGND VPWR VPWR sky130_fd_sc_hd__decap_3
X_4904_ _6376_/Q _5198_/B VGND VGND VPWR VPWR _4904_/X sky130_fd_sc_hd__or2_2
X_5884_ _5795_/C _5884_/A1 _5887_/S VGND VGND VPWR VPWR _6894_/D sky130_fd_sc_hd__mux2_1
XFILLER_55_1337 VGND VGND VPWR VPWR sky130_fd_sc_hd__decap_3
XFILLER_55_1348 VGND VGND VPWR VPWR sky130_fd_sc_hd__decap_3
XFILLER_61_681 VGND VGND VPWR VPWR sky130_fd_sc_hd__decap_3
XFILLER_21_523 VGND VGND VPWR VPWR sky130_fd_sc_hd__decap_3
X_4835_ _4344_/B _6583_/Q _4835_/S VGND VGND VPWR VPWR _4835_/X sky130_fd_sc_hd__mux2_1
XFILLER_60_191 VGND VGND VPWR VPWR sky130_fd_sc_hd__decap_3
X_4766_ _6911_/Q _4766_/A2 _4766_/B1 _4765_/X VGND VGND VPWR VPWR _4766_/X sky130_fd_sc_hd__a211o_2
XFILLER_53_1094 VGND VGND VPWR VPWR sky130_fd_sc_hd__decap_3
X_3717_ _3717_/A _4169_/S VGND VGND VPWR VPWR _3717_/Y sky130_fd_sc_hd__nor2_2
X_6505_ _6847_/CLK _6505_/D load_slew778/X VGND VGND VPWR VPWR _6505_/Q sky130_fd_sc_hd__dfrtp_2
XFILLER_14_1067 VGND VGND VPWR VPWR sky130_fd_sc_hd__fill_1
X_4697_ _4696_/B _4872_/B _4696_/Y _4874_/A1 VGND VGND VPWR VPWR _4697_/Y sky130_fd_sc_hd__o211ai_2
XFILLER_14_1089 VGND VGND VPWR VPWR sky130_fd_sc_hd__decap_3
XFILLER_20_15 VGND VGND VPWR VPWR sky130_fd_sc_hd__decap_3
XFILLER_31_1381 VGND VGND VPWR VPWR sky130_fd_sc_hd__decap_3
X_6436_ _7063_/CLK _6436_/D load_slew775/X VGND VGND VPWR VPWR _6436_/Q sky130_fd_sc_hd__dfrtp_2
X_3648_ _3648_/A _3648_/B VGND VGND VPWR VPWR _3648_/X sky130_fd_sc_hd__xor2_2
XFILLER_66_1400 VGND VGND VPWR VPWR sky130_fd_sc_hd__decap_3
XFILLER_1_906 VGND VGND VPWR VPWR sky130_fd_sc_hd__decap_3
X_6367_ _6993_/CLK _6367_/D fanout741/X VGND VGND VPWR VPWR _6367_/Q sky130_fd_sc_hd__dfrtp_2
X_3579_ _3652_/A _3579_/B _3579_/C VGND VGND VPWR VPWR _3583_/B sky130_fd_sc_hd__nand3b_2
XFILLER_66_1444 VGND VGND VPWR VPWR sky130_fd_sc_hd__decap_3
XFILLER_0_405 VGND VGND VPWR VPWR sky130_fd_sc_hd__decap_3
XFILLER_1_939 VGND VGND VPWR VPWR sky130_fd_sc_hd__decap_3
X_5318_ _6790_/Q _4987_/B _5318_/S VGND VGND VPWR VPWR _5318_/X sky130_fd_sc_hd__mux2_1
XFILLER_0_427 VGND VGND VPWR VPWR sky130_fd_sc_hd__decap_3
XFILLER_27_1428 VGND VGND VPWR VPWR sky130_fd_sc_hd__decap_3
X_6298_ _6943_/CLK _6298_/D fanout823/X VGND VGND VPWR VPWR _6298_/Q sky130_fd_sc_hd__dfrtp_2
XFILLER_0_449 VGND VGND VPWR VPWR sky130_fd_sc_hd__decap_3
XFILLER_9_1360 VGND VGND VPWR VPWR sky130_fd_sc_hd__decap_3
X_5249_ _5328_/S _5249_/B VGND VGND VPWR VPWR _5249_/Y sky130_fd_sc_hd__nand2_2
XFILLER_5_1213 VGND VGND VPWR VPWR sky130_fd_sc_hd__decap_3
XFILLER_9_1393 VGND VGND VPWR VPWR sky130_fd_sc_hd__decap_3
XFILLER_29_612 VGND VGND VPWR VPWR sky130_fd_sc_hd__decap_3
XFILLER_29_623 VGND VGND VPWR VPWR sky130_fd_sc_hd__decap_3
XFILLER_60_1043 VGND VGND VPWR VPWR sky130_fd_sc_hd__decap_3
XFILLER_5_1257 VGND VGND VPWR VPWR sky130_fd_sc_hd__decap_3
XFILLER_60_1076 VGND VGND VPWR VPWR sky130_fd_sc_hd__decap_3
XTAP_TAPCELL_ROW_3_276 VGND VPWR sky130_fd_sc_hd__tapvpwrvgnd_1
XTAP_TAPCELL_ROW_3_287 VGND VPWR sky130_fd_sc_hd__tapvpwrvgnd_1
XFILLER_72_957 VGND VGND VPWR VPWR sky130_fd_sc_hd__decap_3
XFILLER_71_434 VGND VGND VPWR VPWR sky130_fd_sc_hd__decap_3
XTAP_TAPCELL_ROW_80_2306 VGND VPWR sky130_fd_sc_hd__tapvpwrvgnd_1
XFILLER_43_136 VGND VGND VPWR VPWR sky130_fd_sc_hd__decap_3
XTAP_TAPCELL_ROW_80_2317 VGND VPWR sky130_fd_sc_hd__tapvpwrvgnd_1
XFILLER_72_979 VGND VGND VPWR VPWR sky130_fd_sc_hd__fill_1
XFILLER_45_78 VGND VGND VPWR VPWR sky130_fd_sc_hd__fill_1
XFILLER_73_1404 VGND VGND VPWR VPWR sky130_fd_sc_hd__decap_3
XFILLER_43_158 VGND VGND VPWR VPWR sky130_fd_sc_hd__decap_3
XFILLER_73_1437 VGND VGND VPWR VPWR sky130_fd_sc_hd__decap_3
XFILLER_12_512 VGND VGND VPWR VPWR sky130_fd_sc_hd__decap_3
XFILLER_24_383 VGND VGND VPWR VPWR sky130_fd_sc_hd__decap_3
XFILLER_24_394 VGND VGND VPWR VPWR sky130_fd_sc_hd__decap_3
XFILLER_71_1150 VGND VGND VPWR VPWR sky130_fd_sc_hd__decap_3
XFILLER_8_516 VGND VGND VPWR VPWR sky130_fd_sc_hd__decap_3
XFILLER_36_1270 VGND VGND VPWR VPWR sky130_fd_sc_hd__decap_3
XFILLER_40_887 VGND VGND VPWR VPWR sky130_fd_sc_hd__fill_1
XFILLER_12_589 VGND VGND VPWR VPWR sky130_fd_sc_hd__decap_3
XTAP_TAPCELL_ROW_78_2224 VGND VPWR sky130_fd_sc_hd__tapvpwrvgnd_1
XTAP_TAPCELL_ROW_78_2235 VGND VPWR sky130_fd_sc_hd__tapvpwrvgnd_1
XFILLER_71_1183 VGND VGND VPWR VPWR sky130_fd_sc_hd__decap_3
XFILLER_32_1178 VGND VGND VPWR VPWR sky130_fd_sc_hd__decap_3
XFILLER_10_1421 VGND VGND VPWR VPWR sky130_fd_sc_hd__decap_3
XFILLER_10_1432 VGND VGND VPWR VPWR sky130_fd_sc_hd__decap_3
XFILLER_4_733 VGND VGND VPWR VPWR sky130_fd_sc_hd__fill_2
XFILLER_67_1219 VGND VGND VPWR VPWR sky130_fd_sc_hd__decap_3
XFILLER_10_1465 VGND VGND VPWR VPWR sky130_fd_sc_hd__decap_3
XFILLER_79_501 VGND VGND VPWR VPWR sky130_fd_sc_hd__decap_3
XFILLER_10_70 VGND VGND VPWR VPWR sky130_fd_sc_hd__decap_3
XFILLER_79_523 VGND VGND VPWR VPWR sky130_fd_sc_hd__decap_3
XFILLER_3_287 VGND VGND VPWR VPWR sky130_fd_sc_hd__fill_1
XFILLER_80_1419 VGND VGND VPWR VPWR sky130_fd_sc_hd__decap_3
XFILLER_79_567 VGND VGND VPWR VPWR sky130_fd_sc_hd__fill_1
XFILLER_20_9 VGND VGND VPWR VPWR sky130_fd_sc_hd__decap_3
XFILLER_66_206 VGND VGND VPWR VPWR sky130_fd_sc_hd__decap_3
XFILLER_19_100 VGND VGND VPWR VPWR sky130_fd_sc_hd__decap_3
XFILLER_43_1263 VGND VGND VPWR VPWR sky130_fd_sc_hd__decap_3
XFILLER_78_1315 VGND VGND VPWR VPWR sky130_fd_sc_hd__fill_1
XFILLER_48_987 VGND VGND VPWR VPWR sky130_fd_sc_hd__decap_3
XTAP_TAPCELL_ROW_50_1497 VGND VPWR sky130_fd_sc_hd__tapvpwrvgnd_1
XFILLER_78_1326 VGND VGND VPWR VPWR sky130_fd_sc_hd__decap_3
XFILLER_34_103 VGND VGND VPWR VPWR sky130_fd_sc_hd__fill_1
XFILLER_78_1359 VGND VGND VPWR VPWR sky130_fd_sc_hd__decap_3
XFILLER_63_957 VGND VGND VPWR VPWR sky130_fd_sc_hd__fill_2
XFILLER_34_136 VGND VGND VPWR VPWR sky130_fd_sc_hd__decap_3
XTAP_TAPCELL_ROW_67_1950 VGND VPWR sky130_fd_sc_hd__tapvpwrvgnd_1
XFILLER_34_147 VGND VGND VPWR VPWR sky130_fd_sc_hd__fill_2
XFILLER_50_618 VGND VGND VPWR VPWR sky130_fd_sc_hd__fill_2
XFILLER_16_884 VGND VGND VPWR VPWR sky130_fd_sc_hd__decap_3
XTAP_TAPCELL_ROW_63_1836 VGND VPWR sky130_fd_sc_hd__tapvpwrvgnd_1
XFILLER_37_1034 VGND VGND VPWR VPWR sky130_fd_sc_hd__decap_3
XTAP_TAPCELL_ROW_63_1847 VGND VPWR sky130_fd_sc_hd__tapvpwrvgnd_1
XFILLER_42_191 VGND VGND VPWR VPWR sky130_fd_sc_hd__decap_3
XFILLER_15_1310 VGND VGND VPWR VPWR sky130_fd_sc_hd__decap_3
XTAP_TAPCELL_ROW_13_540 VGND VPWR sky130_fd_sc_hd__tapvpwrvgnd_1
X_4620_ _6257_/Q _4765_/A2 _3372_/X _4882_/B2 VGND VGND VPWR VPWR _4620_/X sky130_fd_sc_hd__a22o_2
XTAP_TAPCELL_ROW_13_551 VGND VPWR sky130_fd_sc_hd__tapvpwrvgnd_1
XFILLER_15_1343 VGND VGND VPWR VPWR sky130_fd_sc_hd__fill_1
XFILLER_15_1354 VGND VGND VPWR VPWR sky130_fd_sc_hd__decap_3
XFILLER_11_1207 VGND VGND VPWR VPWR sky130_fd_sc_hd__decap_3
X_4551_ _4597_/A _4551_/B _4551_/C VGND VGND VPWR VPWR _4551_/X sky130_fd_sc_hd__and3_2
XFILLER_50_1267 VGND VGND VPWR VPWR sky130_fd_sc_hd__decap_3
XFILLER_15_1387 VGND VGND VPWR VPWR sky130_fd_sc_hd__decap_3
X_3502_ _6279_/Q _6287_/Q _6295_/Q _6231_/Q _3504_/S0 _4386_/A VGND VGND VPWR VPWR
+ _3502_/X sky130_fd_sc_hd__mux4_2
X_4482_ _6519_/Q _4541_/A _4896_/A1 VGND VGND VPWR VPWR _4482_/X sky130_fd_sc_hd__a21bo_2
XFILLER_7_593 VGND VGND VPWR VPWR sky130_fd_sc_hd__decap_3
X_6221_ _6910_/CLK _6221_/D load_slew778/X VGND VGND VPWR VPWR _6221_/Q sky130_fd_sc_hd__dfrtp_2
X_3433_ hold994/X _3432_/X _3481_/S VGND VGND VPWR VPWR _6190_/D sky130_fd_sc_hd__mux2_1
XFILLER_48_1152 VGND VGND VPWR VPWR sky130_fd_sc_hd__decap_3
X_6152_ _7027_/CLK _6152_/D load_slew845/X VGND VGND VPWR VPWR _6152_/Q sky130_fd_sc_hd__dfrtp_2
XFILLER_44_1005 VGND VGND VPWR VPWR sky130_fd_sc_hd__decap_3
X_3364_ _6301_/Q _6413_/Q VGND VGND VPWR VPWR _3364_/X sky130_fd_sc_hd__xor2_2
X_5103_ _6468_/Q _5103_/B VGND VGND VPWR VPWR _5104_/B sky130_fd_sc_hd__xnor2_2
Xload_slew441 _5107_/A VGND VGND VPWR VPWR _5052_/B1 sky130_fd_sc_hd__buf_4
X_6083_ hold874/X _6073_/D _5627_/S VGND VGND VPWR VPWR _7078_/D sky130_fd_sc_hd__a21o_2
Xhold1205 _6788_/Q VGND VGND VPWR VPWR _5743_/A1 sky130_fd_sc_hd__dlygate4sd3_1
XFILLER_26_1450 VGND VGND VPWR VPWR sky130_fd_sc_hd__decap_3
X_3295_ hold926/X _3294_/X _3389_/S VGND VGND VPWR VPWR _6121_/D sky130_fd_sc_hd__mux2_1
Xhold1216 _6720_/Q VGND VGND VPWR VPWR _5665_/A1 sky130_fd_sc_hd__dlygate4sd3_1
XFILLER_22_1303 VGND VGND VPWR VPWR sky130_fd_sc_hd__decap_3
XFILLER_57_228 VGND VGND VPWR VPWR sky130_fd_sc_hd__decap_3
X_5034_ _6362_/Q _5033_/X _5034_/S VGND VGND VPWR VPWR _6362_/D sky130_fd_sc_hd__mux2_1
Xhold1227 _6810_/Q VGND VGND VPWR VPWR _5775_/A0 sky130_fd_sc_hd__dlygate4sd3_1
Xhold1238 _6791_/Q VGND VGND VPWR VPWR _5746_/A1 sky130_fd_sc_hd__dlygate4sd3_1
XFILLER_61_1363 VGND VGND VPWR VPWR sky130_fd_sc_hd__decap_3
Xhold1249 _6874_/Q VGND VGND VPWR VPWR _5860_/A0 sky130_fd_sc_hd__dlygate4sd3_1
XFILLER_22_1347 VGND VGND VPWR VPWR sky130_fd_sc_hd__decap_3
XFILLER_61_1396 VGND VGND VPWR VPWR sky130_fd_sc_hd__decap_3
XPHY_EDGE_ROW_69_Left_150 VGND VGND VPWR VPWR sky130_fd_sc_hd__decap_3
XTAP_TAPCELL_ROW_0_202 VGND VPWR sky130_fd_sc_hd__tapvpwrvgnd_1
XFILLER_65_250 VGND VGND VPWR VPWR sky130_fd_sc_hd__fill_1
XTAP_TAPCELL_ROW_0_213 VGND VPWR sky130_fd_sc_hd__tapvpwrvgnd_1
XFILLER_38_497 VGND VGND VPWR VPWR sky130_fd_sc_hd__decap_3
XFILLER_26_648 VGND VGND VPWR VPWR sky130_fd_sc_hd__decap_3
XFILLER_53_423 VGND VGND VPWR VPWR sky130_fd_sc_hd__decap_3
XFILLER_0_1121 VGND VGND VPWR VPWR sky130_fd_sc_hd__decap_3
X_6985_ _6993_/CLK _6985_/D load_slew710/X VGND VGND VPWR VPWR _6985_/Q sky130_fd_sc_hd__dfrtp_2
XFILLER_15_15 VGND VGND VPWR VPWR sky130_fd_sc_hd__decap_3
XFILLER_20_1093 VGND VGND VPWR VPWR sky130_fd_sc_hd__decap_3
XFILLER_53_478 VGND VGND VPWR VPWR sky130_fd_sc_hd__fill_2
XTAP_TAPCELL_ROW_24_816 VGND VPWR sky130_fd_sc_hd__tapvpwrvgnd_1
X_5936_ hold880/X _6940_/Q _6032_/S VGND VGND VPWR VPWR _5936_/X sky130_fd_sc_hd__mux2_1
XFILLER_59_1281 VGND VGND VPWR VPWR sky130_fd_sc_hd__decap_3
XTAP_TAPCELL_ROW_24_827 VGND VPWR sky130_fd_sc_hd__tapvpwrvgnd_1
XFILLER_59_1292 VGND VGND VPWR VPWR sky130_fd_sc_hd__decap_3
XFILLER_0_1198 VGND VGND VPWR VPWR sky130_fd_sc_hd__decap_3
XFILLER_34_681 VGND VGND VPWR VPWR sky130_fd_sc_hd__decap_3
XFILLER_62_990 VGND VGND VPWR VPWR sky130_fd_sc_hd__decap_3
XFILLER_22_832 VGND VGND VPWR VPWR sky130_fd_sc_hd__decap_3
XFILLER_21_320 VGND VGND VPWR VPWR sky130_fd_sc_hd__fill_2
XFILLER_40_139 VGND VGND VPWR VPWR sky130_fd_sc_hd__fill_1
XFILLER_33_180 VGND VGND VPWR VPWR sky130_fd_sc_hd__decap_3
XFILLER_22_865 VGND VGND VPWR VPWR sky130_fd_sc_hd__decap_3
X_5867_ _5867_/A0 _5932_/A0 _5867_/S VGND VGND VPWR VPWR _6881_/D sky130_fd_sc_hd__mux2_1
XFILLER_33_1410 VGND VGND VPWR VPWR sky130_fd_sc_hd__decap_3
X_4818_ _6284_/Q wire507/X _3442_/X _4875_/B2 VGND VGND VPWR VPWR _4818_/X sky130_fd_sc_hd__a22o_2
X_5798_ _5798_/A1 _5783_/X _5841_/C _5797_/X VGND VGND VPWR VPWR _6823_/D sky130_fd_sc_hd__a22o_2
XFILLER_33_1443 VGND VGND VPWR VPWR sky130_fd_sc_hd__decap_3
XFILLER_5_508 VGND VGND VPWR VPWR sky130_fd_sc_hd__decap_3
X_4749_ _4769_/B1 _4746_/X _4747_/Y _4748_/X _4597_/A VGND VGND VPWR VPWR _4749_/X
+ sky130_fd_sc_hd__o221a_2
XTAP_TAPCELL_ROW_73_2110 VGND VPWR sky130_fd_sc_hd__tapvpwrvgnd_1
X_6419_ _6765_/CLK _6419_/D wire639/X VGND VGND VPWR VPWR _6419_/Q sky130_fd_sc_hd__dfrtp_2
XFILLER_1_703 VGND VGND VPWR VPWR sky130_fd_sc_hd__decap_3
XFILLER_66_1241 VGND VGND VPWR VPWR sky130_fd_sc_hd__decap_3
XFILLER_1_747 VGND VGND VPWR VPWR sky130_fd_sc_hd__decap_3
XFILLER_27_1236 VGND VGND VPWR VPWR sky130_fd_sc_hd__decap_3
XFILLER_66_1285 VGND VGND VPWR VPWR sky130_fd_sc_hd__decap_3
XFILLER_0_246 VGND VGND VPWR VPWR sky130_fd_sc_hd__decap_3
XFILLER_62_1127 VGND VGND VPWR VPWR sky130_fd_sc_hd__decap_3
XFILLER_7_1319 VGND VGND VPWR VPWR sky130_fd_sc_hd__decap_3
XFILLER_49_718 VGND VGND VPWR VPWR sky130_fd_sc_hd__decap_3
XFILLER_0_268 VGND VGND VPWR VPWR sky130_fd_sc_hd__decap_3
XFILLER_27_1269 VGND VGND VPWR VPWR sky130_fd_sc_hd__decap_3
XFILLER_49_729 VGND VGND VPWR VPWR sky130_fd_sc_hd__decap_3
XFILLER_76_526 VGND VGND VPWR VPWR sky130_fd_sc_hd__decap_3
XFILLER_40_1403 VGND VGND VPWR VPWR sky130_fd_sc_hd__decap_3
XFILLER_76_559 VGND VGND VPWR VPWR sky130_fd_sc_hd__decap_3
XFILLER_57_740 VGND VGND VPWR VPWR sky130_fd_sc_hd__decap_3
XFILLER_5_1043 VGND VGND VPWR VPWR sky130_fd_sc_hd__decap_3
XFILLER_56_44 VGND VGND VPWR VPWR sky130_fd_sc_hd__decap_3
XFILLER_40_1447 VGND VGND VPWR VPWR sky130_fd_sc_hd__decap_3
XFILLER_5_1065 VGND VGND VPWR VPWR sky130_fd_sc_hd__fill_1
XFILLER_17_604 VGND VGND VPWR VPWR sky130_fd_sc_hd__decap_3
XFILLER_29_464 VGND VGND VPWR VPWR sky130_fd_sc_hd__decap_3
XFILLER_57_773 VGND VGND VPWR VPWR sky130_fd_sc_hd__decap_3
XFILLER_17_626 VGND VGND VPWR VPWR sky130_fd_sc_hd__fill_1
XFILLER_5_1098 VGND VGND VPWR VPWR sky130_fd_sc_hd__decap_3
XFILLER_29_486 VGND VGND VPWR VPWR sky130_fd_sc_hd__decap_3
XFILLER_56_272 VGND VGND VPWR VPWR sky130_fd_sc_hd__decap_3
XFILLER_72_21 VGND VGND VPWR VPWR sky130_fd_sc_hd__decap_3
XFILLER_73_1201 VGND VGND VPWR VPWR sky130_fd_sc_hd__decap_3
XFILLER_72_32 VGND VGND VPWR VPWR sky130_fd_sc_hd__decap_3
XFILLER_77_1381 VGND VGND VPWR VPWR sky130_fd_sc_hd__decap_3
XFILLER_38_1332 VGND VGND VPWR VPWR sky130_fd_sc_hd__decap_3
XFILLER_13_821 VGND VGND VPWR VPWR sky130_fd_sc_hd__fill_1
XFILLER_72_65 VGND VGND VPWR VPWR sky130_fd_sc_hd__decap_3
XFILLER_13_832 VGND VGND VPWR VPWR sky130_fd_sc_hd__decap_3
XFILLER_73_1245 VGND VGND VPWR VPWR sky130_fd_sc_hd__decap_3
XFILLER_38_1365 VGND VGND VPWR VPWR sky130_fd_sc_hd__decap_3
XFILLER_38_1376 VGND VGND VPWR VPWR sky130_fd_sc_hd__decap_3
XFILLER_9_814 VGND VGND VPWR VPWR sky130_fd_sc_hd__fill_2
XFILLER_40_651 VGND VGND VPWR VPWR sky130_fd_sc_hd__fill_1
XFILLER_73_1278 VGND VGND VPWR VPWR sky130_fd_sc_hd__decap_3
XFILLER_73_1289 VGND VGND VPWR VPWR sky130_fd_sc_hd__decap_3
XFILLER_9_847 VGND VGND VPWR VPWR sky130_fd_sc_hd__decap_3
XFILLER_40_673 VGND VGND VPWR VPWR sky130_fd_sc_hd__decap_3
XFILLER_8_357 VGND VGND VPWR VPWR sky130_fd_sc_hd__decap_3
XFILLER_8_379 VGND VGND VPWR VPWR sky130_fd_sc_hd__decap_3
XFILLER_68_9 VGND VGND VPWR VPWR sky130_fd_sc_hd__decap_3
XFILLER_4_563 VGND VGND VPWR VPWR sky130_fd_sc_hd__decap_3
XFILLER_10_1273 VGND VGND VPWR VPWR sky130_fd_sc_hd__decap_3
XTAP_TAPCELL_ROW_56_1651 VGND VPWR sky130_fd_sc_hd__tapvpwrvgnd_1
XTAP_TAPCELL_ROW_56_1662 VGND VPWR sky130_fd_sc_hd__tapvpwrvgnd_1
XFILLER_80_1205 VGND VGND VPWR VPWR sky130_fd_sc_hd__decap_3
XFILLER_45_1325 VGND VGND VPWR VPWR sky130_fd_sc_hd__decap_3
XTAP_TAPCELL_ROW_52_1548 VGND VPWR sky130_fd_sc_hd__tapvpwrvgnd_1
XFILLER_45_1369 VGND VGND VPWR VPWR sky130_fd_sc_hd__decap_3
XTAP_TAPCELL_ROW_52_1559 VGND VPWR sky130_fd_sc_hd__tapvpwrvgnd_1
XTAP_TAPCELL_ROW_7_390 VGND VPWR sky130_fd_sc_hd__tapvpwrvgnd_1
XFILLER_39_228 VGND VGND VPWR VPWR sky130_fd_sc_hd__decap_3
XFILLER_0_791 VGND VGND VPWR VPWR sky130_fd_sc_hd__decap_3
X_3080_ _7093_/Q _7112_/A _7093_/D VGND VGND VPWR VPWR _3100_/B sky130_fd_sc_hd__nand3b_2
XFILLER_43_1082 VGND VGND VPWR VPWR sky130_fd_sc_hd__decap_3
XFILLER_36_913 VGND VGND VPWR VPWR sky130_fd_sc_hd__fill_2
XFILLER_78_1123 VGND VGND VPWR VPWR sky130_fd_sc_hd__decap_3
XFILLER_63_732 VGND VGND VPWR VPWR sky130_fd_sc_hd__decap_3
XFILLER_35_434 VGND VGND VPWR VPWR sky130_fd_sc_hd__decap_3
XFILLER_36_957 VGND VGND VPWR VPWR sky130_fd_sc_hd__fill_2
XFILLER_78_1167 VGND VGND VPWR VPWR sky130_fd_sc_hd__decap_3
XFILLER_1_1452 VGND VGND VPWR VPWR sky130_fd_sc_hd__decap_3
XFILLER_1_1463 VGND VGND VPWR VPWR sky130_fd_sc_hd__decap_3
XFILLER_39_1129 VGND VGND VPWR VPWR sky130_fd_sc_hd__fill_2
XTAP_TAPCELL_ROW_18_665 VGND VPWR sky130_fd_sc_hd__tapvpwrvgnd_1
XFILLER_51_927 VGND VGND VPWR VPWR sky130_fd_sc_hd__fill_1
XFILLER_62_253 VGND VGND VPWR VPWR sky130_fd_sc_hd__fill_1
XTAP_TAPCELL_ROW_18_676 VGND VPWR sky130_fd_sc_hd__tapvpwrvgnd_1
XFILLER_23_629 VGND VGND VPWR VPWR sky130_fd_sc_hd__fill_2
XFILLER_56_1421 VGND VGND VPWR VPWR sky130_fd_sc_hd__decap_3
XFILLER_56_1432 VGND VGND VPWR VPWR sky130_fd_sc_hd__decap_3
X_3982_ _3344_/X _4080_/A2 _4080_/B1 _6869_/Q _4080_/C1 VGND VGND VPWR VPWR _3982_/X
+ sky130_fd_sc_hd__a221o_2
X_6770_ _7032_/CLK _6770_/D load_slew690/X VGND VGND VPWR VPWR _6770_/Q sky130_fd_sc_hd__dfrtp_2
XFILLER_16_681 VGND VGND VPWR VPWR sky130_fd_sc_hd__decap_3
XFILLER_44_990 VGND VGND VPWR VPWR sky130_fd_sc_hd__decap_3
XFILLER_50_426 VGND VGND VPWR VPWR sky130_fd_sc_hd__decap_3
XFILLER_17_1416 VGND VGND VPWR VPWR sky130_fd_sc_hd__decap_3
X_5721_ _5801_/C _5721_/A1 wire88/X VGND VGND VPWR VPWR _6769_/D sky130_fd_sc_hd__mux2_1
XFILLER_56_1465 VGND VGND VPWR VPWR sky130_fd_sc_hd__decap_3
XFILLER_15_191 VGND VGND VPWR VPWR sky130_fd_sc_hd__fill_2
XFILLER_52_1329 VGND VGND VPWR VPWR sky130_fd_sc_hd__decap_3
XFILLER_17_1449 VGND VGND VPWR VPWR sky130_fd_sc_hd__decap_3
XFILLER_31_673 VGND VGND VPWR VPWR sky130_fd_sc_hd__decap_3
X_5652_ _5652_/A0 _5688_/A1 _5657_/S VGND VGND VPWR VPWR _6708_/D sky130_fd_sc_hd__mux2_1
XFILLER_30_194 VGND VGND VPWR VPWR sky130_fd_sc_hd__fill_2
X_4603_ _4602_/B _4777_/B _4602_/Y _3098_/A VGND VGND VPWR VPWR _4604_/C sky130_fd_sc_hd__o211ai_2
X_5583_ _5583_/A1 _5583_/A2 _5582_/Y _3712_/B VGND VGND VPWR VPWR _6657_/D sky130_fd_sc_hd__a22o_2
XFILLER_11_1015 VGND VGND VPWR VPWR sky130_fd_sc_hd__decap_3
XFILLER_7_71 VGND VGND VPWR VPWR sky130_fd_sc_hd__decap_3
X_4534_ _6526_/Q _4534_/B VGND VGND VPWR VPWR _4534_/Y sky130_fd_sc_hd__nand2_2
XFILLER_11_1059 VGND VGND VPWR VPWR sky130_fd_sc_hd__decap_3
X_4465_ _6284_/Q _4464_/X wire60/X VGND VGND VPWR VPWR _6284_/D sky130_fd_sc_hd__mux2_1
X_6204_ _7055_/CLK _6204_/D load_slew792/X VGND VGND VPWR VPWR _6204_/Q sky130_fd_sc_hd__dfrtp_2
X_3416_ _6239_/Q _6439_/Q VGND VGND VPWR VPWR _3416_/X sky130_fd_sc_hd__xor2_2
Xfanout804 fanout806/X VGND VGND VPWR VPWR fanout804/X sky130_fd_sc_hd__clkdlybuf4s25_1
X_4396_ _4396_/A _4754_/B VGND VGND VPWR VPWR _4396_/Y sky130_fd_sc_hd__nor2_2
XFILLER_63_1425 VGND VGND VPWR VPWR sky130_fd_sc_hd__decap_3
Xfanout826 fanout832/X VGND VGND VPWR VPWR wire827/A sky130_fd_sc_hd__clkdlybuf4s25_1
X_6135_ _6986_/CLK _6135_/D fanout647/X VGND VGND VPWR VPWR _6135_/Q sky130_fd_sc_hd__dfrtp_2
Xfanout848 input1/X VGND VGND VPWR VPWR fanout848/X sky130_fd_sc_hd__clkdlybuf4s25_1
XTAP_TAPCELL_ROW_5_327 VGND VPWR sky130_fd_sc_hd__tapvpwrvgnd_1
XFILLER_24_1409 VGND VGND VPWR VPWR sky130_fd_sc_hd__decap_3
X_3347_ _5994_/A0 _3346_/X _3353_/S VGND VGND VPWR VPWR _6147_/D sky130_fd_sc_hd__mux2_1
XTAP_TAPCELL_ROW_5_338 VGND VPWR sky130_fd_sc_hd__tapvpwrvgnd_1
Xhold1002 _7059_/Q VGND VGND VPWR VPWR _6055_/A1 sky130_fd_sc_hd__dlygate4sd3_1
Xload_slew260 _4659_/A VGND VGND VPWR VPWR _4602_/B sky130_fd_sc_hd__clkbuf_4
Xhold1013 _6139_/Q VGND VGND VPWR VPWR _5986_/A0 sky130_fd_sc_hd__dlygate4sd3_1
Xhold1024 _6094_/Q VGND VGND VPWR VPWR _5941_/A0 sky130_fd_sc_hd__dlygate4sd3_1
X_6066_ _6062_/B _5618_/Y _6065_/Y _6073_/D VGND VGND VPWR VPWR _7068_/D sky130_fd_sc_hd__o211a_2
XFILLER_6_1341 VGND VGND VPWR VPWR sky130_fd_sc_hd__decap_3
X_3278_ _6218_/Q _6370_/Q VGND VGND VPWR VPWR _3278_/X sky130_fd_sc_hd__xor2_2
Xhold1035 _6115_/Q VGND VGND VPWR VPWR _5962_/A0 sky130_fd_sc_hd__dlygate4sd3_1
Xload_slew293 _3877_/B1 VGND VGND VPWR VPWR _4584_/A2 sky130_fd_sc_hd__clkbuf_4
XFILLER_26_1291 VGND VGND VPWR VPWR sky130_fd_sc_hd__decap_3
Xhold1046 _6093_/Q VGND VGND VPWR VPWR _5940_/A0 sky130_fd_sc_hd__dlygate4sd3_1
Xhold1057 _6060_/X VGND VGND VPWR VPWR _7064_/D sky130_fd_sc_hd__dlygate4sd3_1
XFILLER_2_1205 VGND VGND VPWR VPWR sky130_fd_sc_hd__decap_3
X_5017_ _6392_/Q _5246_/B wire434/X VGND VGND VPWR VPWR _5017_/Y sky130_fd_sc_hd__a21oi_2
XFILLER_6_1385 VGND VGND VPWR VPWR sky130_fd_sc_hd__decap_3
XFILLER_38_250 VGND VGND VPWR VPWR sky130_fd_sc_hd__fill_2
Xhold1068 _6091_/Q VGND VGND VPWR VPWR _5938_/A0 sky130_fd_sc_hd__dlygate4sd3_1
Xhold1079 _6057_/X VGND VGND VPWR VPWR _7061_/D sky130_fd_sc_hd__dlygate4sd3_1
XFILLER_38_261 VGND VGND VPWR VPWR sky130_fd_sc_hd__decap_3
XFILLER_2_1238 VGND VGND VPWR VPWR sky130_fd_sc_hd__decap_3
XFILLER_26_445 VGND VGND VPWR VPWR sky130_fd_sc_hd__decap_3
XFILLER_53_231 VGND VGND VPWR VPWR sky130_fd_sc_hd__decap_3
XFILLER_42_905 VGND VGND VPWR VPWR sky130_fd_sc_hd__fill_2
XFILLER_57_1229 VGND VGND VPWR VPWR sky130_fd_sc_hd__decap_3
XFILLER_13_106 VGND VGND VPWR VPWR sky130_fd_sc_hd__decap_3
X_6968_ _7040_/CLK _6968_/D fanout688/X VGND VGND VPWR VPWR _6968_/Q sky130_fd_sc_hd__dfrtp_2
X_5919_ _5919_/A0 _5793_/C _5919_/S VGND VGND VPWR VPWR _6925_/D sky130_fd_sc_hd__mux2_1
X_6899_ _6900_/CLK _6899_/D fanout832/X VGND VGND VPWR VPWR _6899_/Q sky130_fd_sc_hd__dfrtp_2
XFILLER_70_1418 VGND VGND VPWR VPWR sky130_fd_sc_hd__decap_3
XFILLER_70_1429 VGND VGND VPWR VPWR sky130_fd_sc_hd__decap_3
XFILLER_10_813 VGND VGND VPWR VPWR sky130_fd_sc_hd__decap_3
XFILLER_42_46 VGND VGND VPWR VPWR sky130_fd_sc_hd__decap_3
XFILLER_50_993 VGND VGND VPWR VPWR sky130_fd_sc_hd__decap_3
XFILLER_33_1251 VGND VGND VPWR VPWR sky130_fd_sc_hd__decap_3
XFILLER_33_1284 VGND VGND VPWR VPWR sky130_fd_sc_hd__decap_3
XFILLER_33_1295 VGND VGND VPWR VPWR sky130_fd_sc_hd__decap_3
XFILLER_68_1303 VGND VGND VPWR VPWR sky130_fd_sc_hd__decap_3
XFILLER_68_1347 VGND VGND VPWR VPWR sky130_fd_sc_hd__decap_3
XFILLER_1_511 VGND VGND VPWR VPWR sky130_fd_sc_hd__decap_3
XFILLER_3_18 VGND VGND VPWR VPWR sky130_fd_sc_hd__decap_3
Xhold880 _6089_/Q VGND VGND VPWR VPWR hold880/X sky130_fd_sc_hd__dlygate4sd3_1
Xhold891 _6727_/Q VGND VGND VPWR VPWR hold891/X sky130_fd_sc_hd__dlygate4sd3_1
XFILLER_1_544 VGND VGND VPWR VPWR sky130_fd_sc_hd__decap_3
XFILLER_66_1082 VGND VGND VPWR VPWR sky130_fd_sc_hd__fill_1
XFILLER_7_1116 VGND VGND VPWR VPWR sky130_fd_sc_hd__decap_3
XFILLER_67_21 VGND VGND VPWR VPWR sky130_fd_sc_hd__decap_3
XFILLER_7_1127 VGND VGND VPWR VPWR sky130_fd_sc_hd__decap_3
XFILLER_67_54 VGND VGND VPWR VPWR sky130_fd_sc_hd__fill_2
XFILLER_27_1077 VGND VGND VPWR VPWR sky130_fd_sc_hd__decap_3
XFILLER_77_868 VGND VGND VPWR VPWR sky130_fd_sc_hd__decap_3
XFILLER_44_1391 VGND VGND VPWR VPWR sky130_fd_sc_hd__decap_3
XFILLER_79_1410 VGND VGND VPWR VPWR sky130_fd_sc_hd__decap_3
XFILLER_36_209 VGND VGND VPWR VPWR sky130_fd_sc_hd__fill_1
XFILLER_40_1255 VGND VGND VPWR VPWR sky130_fd_sc_hd__decap_3
XFILLER_57_570 VGND VGND VPWR VPWR sky130_fd_sc_hd__decap_3
XFILLER_17_412 VGND VGND VPWR VPWR sky130_fd_sc_hd__decap_3
XFILLER_79_1443 VGND VGND VPWR VPWR sky130_fd_sc_hd__decap_3
XFILLER_45_732 VGND VGND VPWR VPWR sky130_fd_sc_hd__decap_3
XTAP_TAPCELL_ROW_28_930 VGND VPWR sky130_fd_sc_hd__tapvpwrvgnd_1
XFILLER_40_1288 VGND VGND VPWR VPWR sky130_fd_sc_hd__decap_3
XFILLER_17_445 VGND VGND VPWR VPWR sky130_fd_sc_hd__decap_3
XTAP_TAPCELL_ROW_28_941 VGND VPWR sky130_fd_sc_hd__tapvpwrvgnd_1
XFILLER_75_1307 VGND VGND VPWR VPWR sky130_fd_sc_hd__decap_3
XFILLER_33_905 VGND VGND VPWR VPWR sky130_fd_sc_hd__decap_3
XFILLER_72_551 VGND VGND VPWR VPWR sky130_fd_sc_hd__fill_1
XFILLER_44_242 VGND VGND VPWR VPWR sky130_fd_sc_hd__decap_3
XFILLER_17_467 VGND VGND VPWR VPWR sky130_fd_sc_hd__decap_3
XFILLER_44_253 VGND VGND VPWR VPWR sky130_fd_sc_hd__decap_3
XFILLER_33_927 VGND VGND VPWR VPWR sky130_fd_sc_hd__decap_3
XTAP_TAPCELL_ROW_15_602 VGND VPWR sky130_fd_sc_hd__tapvpwrvgnd_1
XFILLER_72_584 VGND VGND VPWR VPWR sky130_fd_sc_hd__decap_3
XFILLER_44_297 VGND VGND VPWR VPWR sky130_fd_sc_hd__decap_3
XFILLER_60_779 VGND VGND VPWR VPWR sky130_fd_sc_hd__decap_3
XTAP_TAPCELL_ROW_45_1363 VGND VPWR sky130_fd_sc_hd__tapvpwrvgnd_1
XFILLER_38_1184 VGND VGND VPWR VPWR sky130_fd_sc_hd__decap_3
XTAP_TAPCELL_ROW_45_1374 VGND VPWR sky130_fd_sc_hd__tapvpwrvgnd_1
XFILLER_73_1075 VGND VGND VPWR VPWR sky130_fd_sc_hd__decap_3
XFILLER_13_673 VGND VGND VPWR VPWR sky130_fd_sc_hd__fill_1
XFILLER_34_1037 VGND VGND VPWR VPWR sky130_fd_sc_hd__decap_3
XFILLER_9_655 VGND VGND VPWR VPWR sky130_fd_sc_hd__decap_3
XFILLER_51_1340 VGND VGND VPWR VPWR sky130_fd_sc_hd__decap_3
XFILLER_12_194 VGND VGND VPWR VPWR sky130_fd_sc_hd__fill_2
XFILLER_51_1351 VGND VGND VPWR VPWR sky130_fd_sc_hd__decap_3
XFILLER_12_1335 VGND VGND VPWR VPWR sky130_fd_sc_hd__decap_3
XFILLER_51_1384 VGND VGND VPWR VPWR sky130_fd_sc_hd__decap_3
XFILLER_8_187 VGND VGND VPWR VPWR sky130_fd_sc_hd__decap_3
XTAP_TAPCELL_ROW_58_1702 VGND VPWR sky130_fd_sc_hd__tapvpwrvgnd_1
XFILLER_66_6 VGND VGND VPWR VPWR sky130_fd_sc_hd__decap_3
XTAP_TAPCELL_ROW_58_1713 VGND VPWR sky130_fd_sc_hd__tapvpwrvgnd_1
XFILLER_12_1368 VGND VGND VPWR VPWR sky130_fd_sc_hd__decap_3
XFILLER_12_1379 VGND VGND VPWR VPWR sky130_fd_sc_hd__decap_3
XFILLER_5_850 VGND VGND VPWR VPWR sky130_fd_sc_hd__decap_3
XFILLER_4_360 VGND VGND VPWR VPWR sky130_fd_sc_hd__decap_3
X_4250_ _4250_/A _4250_/B VGND VGND VPWR VPWR _4829_/B sky130_fd_sc_hd__xnor2_2
X_3201_ _6944_/Q _6081_/B _6076_/A1 _3200_/X _3205_/B1 VGND VGND VPWR VPWR _3202_/C
+ sky130_fd_sc_hd__a221o_2
XFILLER_68_813 VGND VGND VPWR VPWR sky130_fd_sc_hd__fill_1
X_4181_ _4249_/B _4181_/B VGND VGND VPWR VPWR _4336_/B sky130_fd_sc_hd__xnor2_2
XFILLER_80_1046 VGND VGND VPWR VPWR sky130_fd_sc_hd__decap_3
XFILLER_45_1177 VGND VGND VPWR VPWR sky130_fd_sc_hd__decap_3
X_3132_ _6979_/Q _6987_/Q _3211_/S VGND VGND VPWR VPWR _3132_/X sky130_fd_sc_hd__mux2_1
XFILLER_67_334 VGND VGND VPWR VPWR sky130_fd_sc_hd__fill_2
XFILLER_80_1068 VGND VGND VPWR VPWR sky130_fd_sc_hd__decap_3
XFILLER_23_1431 VGND VGND VPWR VPWR sky130_fd_sc_hd__decap_3
X_3063_ _6359_/Q VGND VGND VPWR VPWR _3063_/Y sky130_fd_sc_hd__inv_2
XFILLER_36_710 VGND VGND VPWR VPWR sky130_fd_sc_hd__decap_3
XFILLER_48_570 VGND VGND VPWR VPWR sky130_fd_sc_hd__decap_3
XFILLER_48_592 VGND VGND VPWR VPWR sky130_fd_sc_hd__decap_3
XFILLER_35_231 VGND VGND VPWR VPWR sky130_fd_sc_hd__decap_3
XFILLER_36_754 VGND VGND VPWR VPWR sky130_fd_sc_hd__fill_2
XFILLER_1_1260 VGND VGND VPWR VPWR sky130_fd_sc_hd__decap_3
X_6822_ _6990_/CLK _6822_/D load_slew751/X VGND VGND VPWR VPWR _6822_/Q sky130_fd_sc_hd__dfrtp_2
XFILLER_17_1202 VGND VGND VPWR VPWR sky130_fd_sc_hd__decap_3
X_6753_ _7089_/CLK _6753_/D fanout729/X VGND VGND VPWR VPWR _6753_/Q sky130_fd_sc_hd__dfrtp_2
X_3965_ _6224_/Q _4081_/A2 _3963_/X _3964_/X VGND VGND VPWR VPWR _6224_/D sky130_fd_sc_hd__o22a_2
XFILLER_56_1273 VGND VGND VPWR VPWR sky130_fd_sc_hd__decap_3
XFILLER_10_109 VGND VGND VPWR VPWR sky130_fd_sc_hd__fill_2
X_5704_ _7066_/Q _5722_/A _5740_/C _5758_/C VGND VGND VPWR VPWR wire89/A sky130_fd_sc_hd__or4_2
XFILLER_17_1257 VGND VGND VPWR VPWR sky130_fd_sc_hd__decap_3
X_3896_ _6293_/Q _3928_/A2 _3928_/B1 _6269_/Q _3928_/C1 VGND VGND VPWR VPWR _3896_/X
+ sky130_fd_sc_hd__a221o_2
X_6684_ _7019_/CLK _6684_/D fanout838/X VGND VGND VPWR VPWR _6684_/Q sky130_fd_sc_hd__dfrtp_2
XFILLER_12_27 VGND VGND VPWR VPWR sky130_fd_sc_hd__fill_1
X_5635_ _5911_/A0 _5635_/A1 wire93/X VGND VGND VPWR VPWR _6694_/D sky130_fd_sc_hd__mux2_1
XFILLER_30_1424 VGND VGND VPWR VPWR sky130_fd_sc_hd__decap_3
XFILLER_30_1435 VGND VGND VPWR VPWR sky130_fd_sc_hd__decap_3
X_5566_ _6367_/Q _5566_/A2 _5566_/B1 _5566_/B2 VGND VGND VPWR VPWR _6649_/D sky130_fd_sc_hd__a22o_2
XFILLER_3_809 VGND VGND VPWR VPWR sky130_fd_sc_hd__decap_3
XFILLER_30_1468 VGND VGND VPWR VPWR sky130_fd_sc_hd__fill_1
X_4517_ _4842_/A _4665_/B _4694_/C _4487_/X _6524_/Q VGND VGND VPWR VPWR _4517_/X
+ sky130_fd_sc_hd__a32o_2
X_5497_ _6601_/Q _6600_/Q _5488_/X _6602_/Q VGND VGND VPWR VPWR _5498_/B sky130_fd_sc_hd__a31o_2
X_4448_ _4680_/C1 _4445_/X _4446_/Y _4447_/X _4683_/A VGND VGND VPWR VPWR _4448_/X
+ sky130_fd_sc_hd__o221a_2
XFILLER_28_1320 VGND VGND VPWR VPWR sky130_fd_sc_hd__decap_3
Xfanout601 input9/X VGND VGND VPWR VPWR _5932_/A0 sky130_fd_sc_hd__clkdlybuf4s25_1
Xfanout612 wire613/X VGND VGND VPWR VPWR _5903_/A0 sky130_fd_sc_hd__clkdlybuf4s25_1
XFILLER_8_1403 VGND VGND VPWR VPWR sky130_fd_sc_hd__decap_3
XFILLER_63_1233 VGND VGND VPWR VPWR sky130_fd_sc_hd__decap_3
Xfanout623 _5826_/A0 VGND VGND VPWR VPWR _5918_/A1 sky130_fd_sc_hd__clkdlybuf4s25_1
XFILLER_28_1353 VGND VGND VPWR VPWR sky130_fd_sc_hd__decap_3
X_4379_ _6506_/Q _4360_/X _4756_/A1 VGND VGND VPWR VPWR _4379_/X sky130_fd_sc_hd__a21o_2
Xfanout634 input2/X VGND VGND VPWR VPWR _5784_/C sky130_fd_sc_hd__clkdlybuf4s25_1
XFILLER_8_1447 VGND VGND VPWR VPWR sky130_fd_sc_hd__decap_3
XFILLER_58_312 VGND VGND VPWR VPWR sky130_fd_sc_hd__fill_2
XFILLER_59_835 VGND VGND VPWR VPWR sky130_fd_sc_hd__decap_3
Xfanout656 fanout666/X VGND VGND VPWR VPWR fanout656/X sky130_fd_sc_hd__clkdlybuf4s25_1
XFILLER_63_1266 VGND VGND VPWR VPWR sky130_fd_sc_hd__decap_3
XFILLER_28_1397 VGND VGND VPWR VPWR sky130_fd_sc_hd__decap_3
Xfanout667 fanout848/X VGND VGND VPWR VPWR fanout667/X sky130_fd_sc_hd__clkdlybuf4s25_1
X_6118_ _7089_/CLK _6118_/D load_slew769/X VGND VGND VPWR VPWR _6118_/Q sky130_fd_sc_hd__dfrtp_2
Xfanout678 fanout680/X VGND VGND VPWR VPWR fanout678/X sky130_fd_sc_hd__clkdlybuf4s25_1
Xfanout689 fanout698/X VGND VGND VPWR VPWR fanout689/X sky130_fd_sc_hd__clkdlybuf4s25_1
XFILLER_2_1002 VGND VGND VPWR VPWR sky130_fd_sc_hd__decap_3
X_6049_ _6049_/A0 _7053_/Q _6049_/S VGND VGND VPWR VPWR _6049_/X sky130_fd_sc_hd__mux2_1
XFILLER_27_710 VGND VGND VPWR VPWR sky130_fd_sc_hd__decap_3
XFILLER_39_570 VGND VGND VPWR VPWR sky130_fd_sc_hd__decap_3
XFILLER_6_1182 VGND VGND VPWR VPWR sky130_fd_sc_hd__decap_3
XFILLER_37_57 VGND VGND VPWR VPWR sky130_fd_sc_hd__fill_2
XFILLER_73_337 VGND VGND VPWR VPWR sky130_fd_sc_hd__decap_3
XFILLER_2_1035 VGND VGND VPWR VPWR sky130_fd_sc_hd__fill_1
XFILLER_2_1046 VGND VGND VPWR VPWR sky130_fd_sc_hd__decap_3
XFILLER_73_359 VGND VGND VPWR VPWR sky130_fd_sc_hd__decap_3
XFILLER_26_231 VGND VGND VPWR VPWR sky130_fd_sc_hd__fill_1
XFILLER_2_1079 VGND VGND VPWR VPWR sky130_fd_sc_hd__decap_3
XFILLER_14_415 VGND VGND VPWR VPWR sky130_fd_sc_hd__decap_3
XFILLER_53_12 VGND VGND VPWR VPWR sky130_fd_sc_hd__fill_2
XFILLER_39_1460 VGND VGND VPWR VPWR sky130_fd_sc_hd__decap_3
XFILLER_30_908 VGND VGND VPWR VPWR sky130_fd_sc_hd__decap_3
XFILLER_74_1362 VGND VGND VPWR VPWR sky130_fd_sc_hd__decap_3
XFILLER_35_1313 VGND VGND VPWR VPWR sky130_fd_sc_hd__decap_3
XFILLER_42_779 VGND VGND VPWR VPWR sky130_fd_sc_hd__decap_3
XFILLER_74_1373 VGND VGND VPWR VPWR sky130_fd_sc_hd__decap_3
XFILLER_70_1226 VGND VGND VPWR VPWR sky130_fd_sc_hd__decap_3
XFILLER_23_993 VGND VGND VPWR VPWR sky130_fd_sc_hd__decap_3
XFILLER_35_1357 VGND VGND VPWR VPWR sky130_fd_sc_hd__decap_3
XFILLER_70_1259 VGND VGND VPWR VPWR sky130_fd_sc_hd__fill_1
XFILLER_10_643 VGND VGND VPWR VPWR sky130_fd_sc_hd__fill_1
XFILLER_6_614 VGND VGND VPWR VPWR sky130_fd_sc_hd__decap_3
XFILLER_10_676 VGND VGND VPWR VPWR sky130_fd_sc_hd__decap_3
XFILLER_5_113 VGND VGND VPWR VPWR sky130_fd_sc_hd__decap_3
XFILLER_33_1092 VGND VGND VPWR VPWR sky130_fd_sc_hd__fill_1
XFILLER_68_1144 VGND VGND VPWR VPWR sky130_fd_sc_hd__decap_3
XFILLER_68_1166 VGND VGND VPWR VPWR sky130_fd_sc_hd__decap_3
XFILLER_11_1390 VGND VGND VPWR VPWR sky130_fd_sc_hd__decap_3
XTAP_TAPCELL_ROW_9_430 VGND VPWR sky130_fd_sc_hd__tapvpwrvgnd_1
XTAP_TAPCELL_ROW_9_441 VGND VPWR sky130_fd_sc_hd__tapvpwrvgnd_1
XFILLER_2_831 VGND VGND VPWR VPWR sky130_fd_sc_hd__decap_3
XFILLER_78_53 VGND VGND VPWR VPWR sky130_fd_sc_hd__decap_3
XFILLER_68_1199 VGND VGND VPWR VPWR sky130_fd_sc_hd__decap_3
XFILLER_2_864 VGND VGND VPWR VPWR sky130_fd_sc_hd__decap_3
XFILLER_2_875 VGND VGND VPWR VPWR sky130_fd_sc_hd__decap_3
XFILLER_1_352 VGND VGND VPWR VPWR sky130_fd_sc_hd__decap_3
XFILLER_46_1453 VGND VGND VPWR VPWR sky130_fd_sc_hd__decap_3
XFILLER_42_1306 VGND VGND VPWR VPWR sky130_fd_sc_hd__decap_3
XFILLER_1_385 VGND VGND VPWR VPWR sky130_fd_sc_hd__decap_3
XFILLER_42_1317 VGND VGND VPWR VPWR sky130_fd_sc_hd__decap_3
XFILLER_76_120 VGND VGND VPWR VPWR sky130_fd_sc_hd__decap_3
XFILLER_1_396 VGND VGND VPWR VPWR sky130_fd_sc_hd__decap_3
XTAP_TAPCELL_ROW_34_1075 VGND VPWR sky130_fd_sc_hd__tapvpwrvgnd_1
XFILLER_65_805 VGND VGND VPWR VPWR sky130_fd_sc_hd__decap_3
XTAP_TAPCELL_ROW_34_1086 VGND VPWR sky130_fd_sc_hd__tapvpwrvgnd_1
XFILLER_76_153 VGND VGND VPWR VPWR sky130_fd_sc_hd__decap_3
XTAP_TAPCELL_ROW_34_1097 VGND VPWR sky130_fd_sc_hd__tapvpwrvgnd_1
XFILLER_65_849 VGND VGND VPWR VPWR sky130_fd_sc_hd__decap_3
XFILLER_40_1052 VGND VGND VPWR VPWR sky130_fd_sc_hd__decap_3
XFILLER_76_197 VGND VGND VPWR VPWR sky130_fd_sc_hd__decap_3
XFILLER_79_1251 VGND VGND VPWR VPWR sky130_fd_sc_hd__decap_3
XFILLER_17_231 VGND VGND VPWR VPWR sky130_fd_sc_hd__decap_3
XTAP_TAPCELL_ROW_47_1414 VGND VPWR sky130_fd_sc_hd__tapvpwrvgnd_1
XFILLER_79_1284 VGND VGND VPWR VPWR sky130_fd_sc_hd__decap_3
XFILLER_27_90 VGND VGND VPWR VPWR sky130_fd_sc_hd__fill_1
XTAP_TAPCELL_ROW_47_1425 VGND VPWR sky130_fd_sc_hd__tapvpwrvgnd_1
XFILLER_79_1295 VGND VGND VPWR VPWR sky130_fd_sc_hd__decap_3
XFILLER_45_584 VGND VGND VPWR VPWR sky130_fd_sc_hd__decap_3
XFILLER_75_1148 VGND VGND VPWR VPWR sky130_fd_sc_hd__decap_3
XFILLER_33_757 VGND VGND VPWR VPWR sky130_fd_sc_hd__fill_1
XFILLER_33_779 VGND VGND VPWR VPWR sky130_fd_sc_hd__decap_3
XFILLER_53_1413 VGND VGND VPWR VPWR sky130_fd_sc_hd__decap_3
X_3750_ _3822_/B _3822_/C VGND VGND VPWR VPWR _3791_/B sky130_fd_sc_hd__nand2_2
XFILLER_53_1446 VGND VGND VPWR VPWR sky130_fd_sc_hd__decap_3
XFILLER_53_1457 VGND VGND VPWR VPWR sky130_fd_sc_hd__decap_3
XFILLER_9_452 VGND VGND VPWR VPWR sky130_fd_sc_hd__decap_3
XFILLER_9_463 VGND VGND VPWR VPWR sky130_fd_sc_hd__decap_3
X_3681_ _3681_/A _3681_/B _3693_/C VGND VGND VPWR VPWR _3683_/B sky130_fd_sc_hd__and3_2
X_5420_ _5420_/A1 _5484_/A2 _3987_/X VGND VGND VPWR VPWR _6532_/D sky130_fd_sc_hd__a21o_2
XFILLER_64_3 VGND VGND VPWR VPWR sky130_fd_sc_hd__decap_3
X_5351_ _6468_/Q _5350_/X _5353_/S VGND VGND VPWR VPWR _6468_/D sky130_fd_sc_hd__mux2_1
XFILLER_12_1198 VGND VGND VPWR VPWR sky130_fd_sc_hd__decap_3
X_4302_ _4302_/A _4302_/B VGND VGND VPWR VPWR _4305_/A sky130_fd_sc_hd__xnor2_2
X_5282_ _5350_/S _5282_/B VGND VGND VPWR VPWR _5282_/Y sky130_fd_sc_hd__nand2_2
XFILLER_47_1239 VGND VGND VPWR VPWR sky130_fd_sc_hd__decap_3
XFILLER_4_190 VGND VGND VPWR VPWR sky130_fd_sc_hd__decap_3
XFILLER_4_50 VGND VGND VPWR VPWR sky130_fd_sc_hd__decap_3
X_7021_ clkload9/A _7021_/D load_slew643/X VGND VGND VPWR VPWR _7021_/Q sky130_fd_sc_hd__dfrtp_2
X_4233_ _4233_/A _4233_/B VGND VGND VPWR VPWR _4815_/B sky130_fd_sc_hd__xnor2_2
XFILLER_4_83 VGND VGND VPWR VPWR sky130_fd_sc_hd__fill_1
XFILLER_4_94 VGND VGND VPWR VPWR sky130_fd_sc_hd__decap_3
XFILLER_60_1406 VGND VGND VPWR VPWR sky130_fd_sc_hd__decap_3
X_4164_ _6477_/Q _4319_/A2 _4558_/A _4163_/Y VGND VGND VPWR VPWR _4164_/X sky130_fd_sc_hd__o211a_2
XFILLER_67_131 VGND VGND VPWR VPWR sky130_fd_sc_hd__fill_1
X_3115_ _7042_/Q _7050_/Q _3200_/S VGND VGND VPWR VPWR _3115_/X sky130_fd_sc_hd__mux2_1
XFILLER_56_827 VGND VGND VPWR VPWR sky130_fd_sc_hd__decap_3
X_4095_ _4747_/A _4095_/B VGND VGND VPWR VPWR _4095_/Y sky130_fd_sc_hd__nor2_2
XFILLER_3_1322 VGND VGND VPWR VPWR sky130_fd_sc_hd__decap_3
XFILLER_23_1272 VGND VGND VPWR VPWR sky130_fd_sc_hd__decap_3
XFILLER_55_337 VGND VGND VPWR VPWR sky130_fd_sc_hd__decap_3
X_3046_ _7068_/Q VGND VGND VPWR VPWR _5722_/A sky130_fd_sc_hd__inv_2
XFILLER_3_1366 VGND VGND VPWR VPWR sky130_fd_sc_hd__decap_3
XFILLER_36_562 VGND VGND VPWR VPWR sky130_fd_sc_hd__decap_3
XFILLER_3_1399 VGND VGND VPWR VPWR sky130_fd_sc_hd__fill_1
XFILLER_58_1335 VGND VGND VPWR VPWR sky130_fd_sc_hd__decap_3
XFILLER_24_735 VGND VGND VPWR VPWR sky130_fd_sc_hd__decap_3
XFILLER_19_1319 VGND VGND VPWR VPWR sky130_fd_sc_hd__decap_3
XFILLER_23_223 VGND VGND VPWR VPWR sky130_fd_sc_hd__fill_1
XFILLER_58_1368 VGND VGND VPWR VPWR sky130_fd_sc_hd__decap_3
X_6805_ _7095_/CLK _6805_/D load_slew696/X VGND VGND VPWR VPWR _6805_/Q sky130_fd_sc_hd__dfrtp_2
XFILLER_51_543 VGND VGND VPWR VPWR sky130_fd_sc_hd__decap_3
XFILLER_58_1379 VGND VGND VPWR VPWR sky130_fd_sc_hd__decap_3
X_4997_ _4995_/X _4996_/Y _5263_/A2 VGND VGND VPWR VPWR _4999_/S sky130_fd_sc_hd__a21oi_2
XFILLER_23_15 VGND VGND VPWR VPWR sky130_fd_sc_hd__fill_1
XFILLER_23_278 VGND VGND VPWR VPWR sky130_fd_sc_hd__fill_2
X_6736_ _7048_/CLK _6736_/D fanout657/A VGND VGND VPWR VPWR _6736_/Q sky130_fd_sc_hd__dfrtp_2
X_3948_ _6279_/Q _3948_/A2 _3948_/B1 _6255_/Q _3948_/C1 VGND VGND VPWR VPWR _3948_/X
+ sky130_fd_sc_hd__a221o_2
XFILLER_17_1065 VGND VGND VPWR VPWR sky130_fd_sc_hd__decap_3
X_6667_ _6923_/CLK _6667_/D fanout811/X VGND VGND VPWR VPWR _6667_/Q sky130_fd_sc_hd__dfrtp_2
X_3879_ _3879_/A _3879_/B _3879_/C VGND VGND VPWR VPWR _3880_/B sky130_fd_sc_hd__and3_2
XTAP_TAPCELL_ROW_30_980 VGND VPWR sky130_fd_sc_hd__tapvpwrvgnd_1
XFILLER_30_1232 VGND VGND VPWR VPWR sky130_fd_sc_hd__decap_3
X_5618_ _5694_/C VGND VGND VPWR VPWR _5618_/Y sky130_fd_sc_hd__inv_2
XTAP_TAPCELL_ROW_30_991 VGND VPWR sky130_fd_sc_hd__tapvpwrvgnd_1
X_6598_ _7064_/CLK _6598_/D load_slew723/X VGND VGND VPWR VPWR _6598_/Q sky130_fd_sc_hd__dfrtp_2
XFILLER_69_1431 VGND VGND VPWR VPWR sky130_fd_sc_hd__decap_3
XFILLER_3_606 VGND VGND VPWR VPWR sky130_fd_sc_hd__decap_3
XFILLER_3_617 VGND VGND VPWR VPWR sky130_fd_sc_hd__decap_3
XFILLER_30_1276 VGND VGND VPWR VPWR sky130_fd_sc_hd__decap_3
X_5549_ _6350_/Q _5501_/B _5549_/B1 _5562_/B2 VGND VGND VPWR VPWR _6632_/D sky130_fd_sc_hd__a22o_2
XFILLER_2_127 VGND VGND VPWR VPWR sky130_fd_sc_hd__decap_3
XFILLER_65_1328 VGND VGND VPWR VPWR sky130_fd_sc_hd__decap_3
XFILLER_8_1200 VGND VGND VPWR VPWR sky130_fd_sc_hd__decap_3
XFILLER_8_1211 VGND VGND VPWR VPWR sky130_fd_sc_hd__decap_3
Xfanout420 _3933_/A VGND VGND VPWR VPWR _4338_/A sky130_fd_sc_hd__clkdlybuf4s25_1
XFILLER_63_1052 VGND VGND VPWR VPWR sky130_fd_sc_hd__decap_3
XFILLER_8_1244 VGND VGND VPWR VPWR sky130_fd_sc_hd__decap_3
Xfanout442 _3074_/Y VGND VGND VPWR VPWR wire443/A sky130_fd_sc_hd__clkdlybuf4s25_1
Xfanout453 _3042_/Y VGND VGND VPWR VPWR _5514_/A sky130_fd_sc_hd__clkdlybuf4s25_1
XFILLER_24_1014 VGND VGND VPWR VPWR sky130_fd_sc_hd__decap_3
Xfanout464 _4771_/C1 VGND VGND VPWR VPWR _4769_/B1 sky130_fd_sc_hd__clkdlybuf4s25_1
XFILLER_58_131 VGND VGND VPWR VPWR sky130_fd_sc_hd__fill_1
XFILLER_4_1108 VGND VGND VPWR VPWR sky130_fd_sc_hd__decap_3
Xfanout475 _4680_/C1 VGND VGND VPWR VPWR _4859_/C1 sky130_fd_sc_hd__clkdlybuf4s25_1
Xfanout486 _4381_/C1 VGND VGND VPWR VPWR _4091_/A1 sky130_fd_sc_hd__clkdlybuf4s25_1
XFILLER_8_1288 VGND VGND VPWR VPWR sky130_fd_sc_hd__decap_3
XFILLER_47_827 VGND VGND VPWR VPWR sky130_fd_sc_hd__decap_3
XFILLER_59_687 VGND VGND VPWR VPWR sky130_fd_sc_hd__decap_3
Xfanout497 _4832_/A2 VGND VGND VPWR VPWR _4868_/A2 sky130_fd_sc_hd__clkdlybuf4s25_1
XFILLER_46_315 VGND VGND VPWR VPWR sky130_fd_sc_hd__decap_3
XFILLER_58_197 VGND VGND VPWR VPWR sky130_fd_sc_hd__decap_3
XFILLER_41_1372 VGND VGND VPWR VPWR sky130_fd_sc_hd__decap_3
XFILLER_73_156 VGND VGND VPWR VPWR sky130_fd_sc_hd__decap_3
XFILLER_15_702 VGND VGND VPWR VPWR sky130_fd_sc_hd__decap_3
XFILLER_76_1424 VGND VGND VPWR VPWR sky130_fd_sc_hd__decap_3
XFILLER_76_1435 VGND VGND VPWR VPWR sky130_fd_sc_hd__decap_3
XFILLER_15_735 VGND VGND VPWR VPWR sky130_fd_sc_hd__fill_1
XFILLER_64_88 VGND VGND VPWR VPWR sky130_fd_sc_hd__fill_1
XFILLER_76_1468 VGND VGND VPWR VPWR sky130_fd_sc_hd__fill_1
XFILLER_37_1419 VGND VGND VPWR VPWR sky130_fd_sc_hd__decap_3
XFILLER_15_768 VGND VGND VPWR VPWR sky130_fd_sc_hd__decap_3
XFILLER_14_267 VGND VGND VPWR VPWR sky130_fd_sc_hd__decap_3
XFILLER_9_39 VGND VGND VPWR VPWR sky130_fd_sc_hd__decap_3
XFILLER_35_1110 VGND VGND VPWR VPWR sky130_fd_sc_hd__fill_1
XTAP_TAPCELL_ROW_42_1300 VGND VPWR sky130_fd_sc_hd__tapvpwrvgnd_1
XFILLER_80_21 VGND VGND VPWR VPWR sky130_fd_sc_hd__decap_3
XFILLER_74_1170 VGND VGND VPWR VPWR sky130_fd_sc_hd__decap_3
XFILLER_80_32 VGND VGND VPWR VPWR sky130_fd_sc_hd__decap_3
Xfanout71 _3490_/X VGND VGND VPWR VPWR _4104_/C1 sky130_fd_sc_hd__clkdlybuf4s25_1
XFILLER_70_1034 VGND VGND VPWR VPWR sky130_fd_sc_hd__fill_2
XFILLER_80_76 VGND VGND VPWR VPWR sky130_fd_sc_hd__decap_3
XFILLER_13_1452 VGND VGND VPWR VPWR sky130_fd_sc_hd__decap_3
XFILLER_13_1463 VGND VGND VPWR VPWR sky130_fd_sc_hd__decap_3
XFILLER_10_495 VGND VGND VPWR VPWR sky130_fd_sc_hd__fill_2
XFILLER_7_978 VGND VGND VPWR VPWR sky130_fd_sc_hd__fill_2
XFILLER_6_455 VGND VGND VPWR VPWR sky130_fd_sc_hd__decap_3
XPHY_EDGE_ROW_23_Left_104 VGND VGND VPWR VPWR sky130_fd_sc_hd__decap_3
XFILLER_6_477 VGND VGND VPWR VPWR sky130_fd_sc_hd__fill_1
XTAP_TAPCELL_ROW_36_1126 VGND VPWR sky130_fd_sc_hd__tapvpwrvgnd_1
XTAP_TAPCELL_ROW_36_1137 VGND VPWR sky130_fd_sc_hd__tapvpwrvgnd_1
Xload_slew815 fanout814/X VGND VGND VPWR VPWR load_slew815/X sky130_fd_sc_hd__clkbuf_4
XTAP_TAPCELL_ROW_36_1148 VGND VPWR sky130_fd_sc_hd__tapvpwrvgnd_1
XFILLER_2_672 VGND VGND VPWR VPWR sky130_fd_sc_hd__decap_3
XFILLER_46_1250 VGND VGND VPWR VPWR sky130_fd_sc_hd__decap_3
Xload_slew837 fanout836/X VGND VGND VPWR VPWR load_slew837/X sky130_fd_sc_hd__clkbuf_2
XFILLER_46_1261 VGND VGND VPWR VPWR sky130_fd_sc_hd__decap_3
XFILLER_1_193 VGND VGND VPWR VPWR sky130_fd_sc_hd__decap_3
XFILLER_29_6 VGND VGND VPWR VPWR sky130_fd_sc_hd__decap_3
XFILLER_46_1294 VGND VGND VPWR VPWR sky130_fd_sc_hd__decap_3
XFILLER_38_816 VGND VGND VPWR VPWR sky130_fd_sc_hd__decap_3
XFILLER_42_1136 VGND VGND VPWR VPWR sky130_fd_sc_hd__decap_3
XFILLER_64_112 VGND VGND VPWR VPWR sky130_fd_sc_hd__fill_2
XFILLER_20_1412 VGND VGND VPWR VPWR sky130_fd_sc_hd__decap_3
XPHY_EDGE_ROW_32_Left_113 VGND VGND VPWR VPWR sky130_fd_sc_hd__decap_3
XFILLER_64_156 VGND VGND VPWR VPWR sky130_fd_sc_hd__fill_1
XFILLER_20_1456 VGND VGND VPWR VPWR sky130_fd_sc_hd__decap_3
X_4920_ _4918_/X _4919_/Y _5215_/A2 VGND VGND VPWR VPWR _4922_/S sky130_fd_sc_hd__a21oi_2
XFILLER_64_189 VGND VGND VPWR VPWR sky130_fd_sc_hd__decap_3
X_4851_ _4879_/B _4851_/B VGND VGND VPWR VPWR _4851_/Y sky130_fd_sc_hd__nor2_2
XFILLER_21_727 VGND VGND VPWR VPWR sky130_fd_sc_hd__fill_1
XFILLER_18_1341 VGND VGND VPWR VPWR sky130_fd_sc_hd__decap_3
XFILLER_21_738 VGND VGND VPWR VPWR sky130_fd_sc_hd__decap_3
X_3802_ _6274_/Q _3928_/A2 _3928_/B1 _6250_/Q _3928_/C1 VGND VGND VPWR VPWR _3802_/X
+ sky130_fd_sc_hd__a221o_2
XFILLER_57_1390 VGND VGND VPWR VPWR sky130_fd_sc_hd__decap_3
X_4782_ _6327_/Q _4781_/X _4782_/S VGND VGND VPWR VPWR _6327_/D sky130_fd_sc_hd__mux2_1
XFILLER_60_395 VGND VGND VPWR VPWR sky130_fd_sc_hd__decap_3
XFILLER_14_1205 VGND VGND VPWR VPWR sky130_fd_sc_hd__decap_3
XFILLER_53_1254 VGND VGND VPWR VPWR sky130_fd_sc_hd__decap_3
XFILLER_18_1385 VGND VGND VPWR VPWR sky130_fd_sc_hd__decap_3
X_6521_ _6958_/CLK _6521_/D load_slew760/X VGND VGND VPWR VPWR _6521_/Q sky130_fd_sc_hd__dfrtp_2
X_3733_ _6280_/Q _3960_/B _3921_/B1 _6256_/Q _3921_/C1 VGND VGND VPWR VPWR _3733_/X
+ sky130_fd_sc_hd__a221o_2
XFILLER_14_1238 VGND VGND VPWR VPWR sky130_fd_sc_hd__decap_3
XFILLER_53_1287 VGND VGND VPWR VPWR sky130_fd_sc_hd__fill_1
XFILLER_53_1298 VGND VGND VPWR VPWR sky130_fd_sc_hd__decap_3
XPHY_EDGE_ROW_41_Left_122 VGND VGND VPWR VPWR sky130_fd_sc_hd__decap_3
X_6452_ _7046_/CLK _6452_/D load_slew744/X VGND VGND VPWR VPWR _6452_/Q sky130_fd_sc_hd__dfrtp_2
X_3664_ _3661_/X _3702_/B _3786_/A VGND VGND VPWR VPWR _3667_/A sky130_fd_sc_hd__nand3b_2
Xclkload30 _6913_/CLK VGND VGND VPWR VPWR clkload30/X sky130_fd_sc_hd__clkbuf_4
Xclkload41 _7022_/CLK VGND VGND VPWR VPWR clkload41/X sky130_fd_sc_hd__clkbuf_4
XTAP_TAPCELL_ROW_11_490 VGND VPWR sky130_fd_sc_hd__tapvpwrvgnd_1
X_5403_ _5403_/A1 _5470_/A2 _4455_/X VGND VGND VPWR VPWR _6515_/D sky130_fd_sc_hd__a21o_2
Xclkload52 _6910_/CLK VGND VGND VPWR VPWR clkload52/X sky130_fd_sc_hd__clkbuf_4
X_3595_ _6293_/Q _4312_/A _5574_/A2 _6277_/Q _4487_/A VGND VGND VPWR VPWR _3595_/X
+ sky130_fd_sc_hd__a221o_2
X_6383_ _6913_/CLK _6383_/D fanout729/X VGND VGND VPWR VPWR _6383_/Q sky130_fd_sc_hd__dfrtp_2
X_5334_ _6798_/Q _5043_/B _5334_/S VGND VGND VPWR VPWR _5334_/X sky130_fd_sc_hd__mux2_1
XFILLER_47_1058 VGND VGND VPWR VPWR sky130_fd_sc_hd__decap_3
X_5265_ _6768_/Q _5338_/S _5341_/S _5264_/Y VGND VGND VPWR VPWR _5265_/X sky130_fd_sc_hd__o211a_2
XFILLER_25_1301 VGND VGND VPWR VPWR sky130_fd_sc_hd__decap_3
XFILLER_64_1350 VGND VGND VPWR VPWR sky130_fd_sc_hd__decap_3
X_7004_ _7004_/CLK _7004_/D load_slew834/X VGND VGND VPWR VPWR _7004_/Q sky130_fd_sc_hd__dfrtp_2
XFILLER_25_1334 VGND VGND VPWR VPWR sky130_fd_sc_hd__decap_3
X_4216_ _6820_/Q _4862_/A2 _4862_/B1 _4215_/X VGND VGND VPWR VPWR _4216_/X sky130_fd_sc_hd__a211o_2
X_5196_ _6745_/Q _5219_/A VGND VGND VPWR VPWR _5196_/Y sky130_fd_sc_hd__nor2_2
XFILLER_25_1345 VGND VGND VPWR VPWR sky130_fd_sc_hd__decap_3
XFILLER_64_1394 VGND VGND VPWR VPWR sky130_fd_sc_hd__decap_3
XFILLER_5_1428 VGND VGND VPWR VPWR sky130_fd_sc_hd__decap_3
XPHY_EDGE_ROW_50_Left_131 VGND VGND VPWR VPWR sky130_fd_sc_hd__decap_3
XFILLER_60_1247 VGND VGND VPWR VPWR sky130_fd_sc_hd__decap_3
XFILLER_25_1378 VGND VGND VPWR VPWR sky130_fd_sc_hd__decap_3
XFILLER_28_315 VGND VGND VPWR VPWR sky130_fd_sc_hd__decap_3
X_4147_ _6813_/Q _4751_/A2 wire36/X _4146_/X VGND VGND VPWR VPWR _4147_/X sky130_fd_sc_hd__a211o_2
XFILLER_55_101 VGND VGND VPWR VPWR sky130_fd_sc_hd__decap_3
XFILLER_3_1130 VGND VGND VPWR VPWR sky130_fd_sc_hd__decap_3
XFILLER_55_134 VGND VGND VPWR VPWR sky130_fd_sc_hd__decap_3
X_4078_ _6595_/Q _4777_/A _4097_/A1 VGND VGND VPWR VPWR _4078_/X sky130_fd_sc_hd__a21bo_2
XFILLER_71_605 VGND VGND VPWR VPWR sky130_fd_sc_hd__decap_3
XFILLER_3_1163 VGND VGND VPWR VPWR sky130_fd_sc_hd__decap_3
XFILLER_43_329 VGND VGND VPWR VPWR sky130_fd_sc_hd__decap_3
XFILLER_58_1132 VGND VGND VPWR VPWR sky130_fd_sc_hd__decap_3
XFILLER_70_137 VGND VGND VPWR VPWR sky130_fd_sc_hd__decap_3
XFILLER_34_36 VGND VGND VPWR VPWR sky130_fd_sc_hd__decap_3
XFILLER_19_1127 VGND VGND VPWR VPWR sky130_fd_sc_hd__decap_3
XFILLER_24_565 VGND VGND VPWR VPWR sky130_fd_sc_hd__decap_3
XFILLER_54_1018 VGND VGND VPWR VPWR sky130_fd_sc_hd__fill_2
XFILLER_58_1187 VGND VGND VPWR VPWR sky130_fd_sc_hd__decap_3
XFILLER_54_1029 VGND VGND VPWR VPWR sky130_fd_sc_hd__decap_3
XFILLER_71_1310 VGND VGND VPWR VPWR sky130_fd_sc_hd__decap_3
XFILLER_36_1441 VGND VGND VPWR VPWR sky130_fd_sc_hd__decap_3
XFILLER_51_384 VGND VGND VPWR VPWR sky130_fd_sc_hd__decap_3
XFILLER_71_1343 VGND VGND VPWR VPWR sky130_fd_sc_hd__fill_1
XFILLER_71_1354 VGND VGND VPWR VPWR sky130_fd_sc_hd__decap_3
X_6719_ _7004_/CLK _6719_/D fanout841/X VGND VGND VPWR VPWR _6719_/Q sky130_fd_sc_hd__dfrtp_2
Xclkload2 clkload2/A VGND VGND VPWR VPWR clkload2/X sky130_fd_sc_hd__clkbuf_8
XFILLER_7_219 VGND VGND VPWR VPWR sky130_fd_sc_hd__decap_3
XFILLER_20_760 VGND VGND VPWR VPWR sky130_fd_sc_hd__decap_3
XTAP_TAPCELL_ROW_22_766 VGND VPWR sky130_fd_sc_hd__tapvpwrvgnd_1
XFILLER_71_1387 VGND VGND VPWR VPWR sky130_fd_sc_hd__decap_3
XTAP_TAPCELL_ROW_22_777 VGND VPWR sky130_fd_sc_hd__tapvpwrvgnd_1
XFILLER_32_1338 VGND VGND VPWR VPWR sky130_fd_sc_hd__decap_3
XFILLER_50_46 VGND VGND VPWR VPWR sky130_fd_sc_hd__decap_3
XFILLER_4_915 VGND VGND VPWR VPWR sky130_fd_sc_hd__decap_3
XTAP_TAPCELL_ROW_76_2174 VGND VPWR sky130_fd_sc_hd__tapvpwrvgnd_1
XFILLER_4_937 VGND VGND VPWR VPWR sky130_fd_sc_hd__fill_1
XFILLER_3_414 VGND VGND VPWR VPWR sky130_fd_sc_hd__decap_3
XTAP_TAPCELL_ROW_76_2185 VGND VPWR sky130_fd_sc_hd__tapvpwrvgnd_1
XFILLER_4_959 VGND VGND VPWR VPWR sky130_fd_sc_hd__decap_3
XFILLER_69_1272 VGND VGND VPWR VPWR sky130_fd_sc_hd__decap_3
XFILLER_3_447 VGND VGND VPWR VPWR sky130_fd_sc_hd__fill_1
XFILLER_3_458 VGND VGND VPWR VPWR sky130_fd_sc_hd__fill_2
XFILLER_79_716 VGND VGND VPWR VPWR sky130_fd_sc_hd__decap_3
XFILLER_79_738 VGND VGND VPWR VPWR sky130_fd_sc_hd__decap_3
XFILLER_59_55 VGND VGND VPWR VPWR sky130_fd_sc_hd__fill_1
XFILLER_43_1401 VGND VGND VPWR VPWR sky130_fd_sc_hd__decap_3
XFILLER_59_99 VGND VGND VPWR VPWR sky130_fd_sc_hd__fill_2
XFILLER_43_1434 VGND VGND VPWR VPWR sky130_fd_sc_hd__decap_3
Xfanout250 _5453_/A2 VGND VGND VPWR VPWR _5461_/A2 sky130_fd_sc_hd__clkdlybuf4s25_1
XFILLER_8_1052 VGND VGND VPWR VPWR sky130_fd_sc_hd__decap_3
XTAP_TAPCELL_ROW_31_1001 VGND VPWR sky130_fd_sc_hd__tapvpwrvgnd_1
Xfanout261 _4645_/A VGND VGND VPWR VPWR _4624_/A sky130_fd_sc_hd__clkdlybuf4s25_1
XTAP_TAPCELL_ROW_31_1012 VGND VPWR sky130_fd_sc_hd__tapvpwrvgnd_1
XFILLER_8_1074 VGND VGND VPWR VPWR sky130_fd_sc_hd__decap_3
Xfanout272 fanout274/X VGND VGND VPWR VPWR _4413_/A sky130_fd_sc_hd__clkdlybuf4s25_1
XFILLER_75_922 VGND VGND VPWR VPWR sky130_fd_sc_hd__decap_3
XFILLER_75_21 VGND VGND VPWR VPWR sky130_fd_sc_hd__decap_3
Xfanout294 _4758_/A2 VGND VGND VPWR VPWR wire295/A sky130_fd_sc_hd__clkdlybuf4s25_1
XFILLER_8_1096 VGND VGND VPWR VPWR sky130_fd_sc_hd__fill_1
XFILLER_41_1180 VGND VGND VPWR VPWR sky130_fd_sc_hd__decap_3
XFILLER_47_679 VGND VGND VPWR VPWR sky130_fd_sc_hd__decap_3
Xload_slew58 _4782_/S VGND VGND VPWR VPWR _4775_/A2 sky130_fd_sc_hd__clkbuf_4
XFILLER_34_329 VGND VGND VPWR VPWR sky130_fd_sc_hd__decap_3
XFILLER_76_1232 VGND VGND VPWR VPWR sky130_fd_sc_hd__decap_3
XFILLER_43_830 VGND VGND VPWR VPWR sky130_fd_sc_hd__decap_3
XFILLER_43_841 VGND VGND VPWR VPWR sky130_fd_sc_hd__decap_3
XFILLER_15_543 VGND VGND VPWR VPWR sky130_fd_sc_hd__decap_3
XFILLER_15_554 VGND VGND VPWR VPWR sky130_fd_sc_hd__decap_3
XFILLER_43_863 VGND VGND VPWR VPWR sky130_fd_sc_hd__decap_3
XFILLER_76_1276 VGND VGND VPWR VPWR sky130_fd_sc_hd__decap_3
XFILLER_42_351 VGND VGND VPWR VPWR sky130_fd_sc_hd__decap_3
XFILLER_72_1129 VGND VGND VPWR VPWR sky130_fd_sc_hd__decap_3
XFILLER_15_576 VGND VGND VPWR VPWR sky130_fd_sc_hd__decap_3
XFILLER_15_598 VGND VGND VPWR VPWR sky130_fd_sc_hd__decap_3
XFILLER_42_384 VGND VGND VPWR VPWR sky130_fd_sc_hd__decap_3
XTAP_TAPCELL_ROW_61_1775 VGND VPWR sky130_fd_sc_hd__tapvpwrvgnd_1
XFILLER_11_760 VGND VGND VPWR VPWR sky130_fd_sc_hd__decap_3
XFILLER_50_1427 VGND VGND VPWR VPWR sky130_fd_sc_hd__fill_1
XTAP_TAPCELL_ROW_61_1786 VGND VPWR sky130_fd_sc_hd__tapvpwrvgnd_1
XFILLER_50_1438 VGND VGND VPWR VPWR sky130_fd_sc_hd__decap_3
XTAP_TAPCELL_ROW_61_1797 VGND VPWR sky130_fd_sc_hd__tapvpwrvgnd_1
XFILLER_13_1260 VGND VGND VPWR VPWR sky130_fd_sc_hd__decap_3
XFILLER_7_797 VGND VGND VPWR VPWR sky130_fd_sc_hd__decap_3
XFILLER_6_296 VGND VGND VPWR VPWR sky130_fd_sc_hd__decap_3
XFILLER_48_1312 VGND VGND VPWR VPWR sky130_fd_sc_hd__decap_3
XFILLER_48_1323 VGND VGND VPWR VPWR sky130_fd_sc_hd__decap_3
X_3380_ _6309_/Q _6421_/Q VGND VGND VPWR VPWR _3380_/X sky130_fd_sc_hd__xor2_2
XFILLER_48_1356 VGND VGND VPWR VPWR sky130_fd_sc_hd__decap_3
X_5050_ _6429_/Q _5050_/B VGND VGND VPWR VPWR _5261_/B sky130_fd_sc_hd__xnor2_2
XFILLER_2_491 VGND VGND VPWR VPWR sky130_fd_sc_hd__fill_1
Xload_slew645 fanout644/X VGND VGND VPWR VPWR load_slew645/X sky130_fd_sc_hd__clkbuf_4
XFILLER_27_3 VGND VGND VPWR VPWR sky130_fd_sc_hd__fill_2
Xhold1409 _6519_/Q VGND VGND VPWR VPWR _5407_/A1 sky130_fd_sc_hd__dlygate4sd3_1
XFILLER_78_760 VGND VGND VPWR VPWR sky130_fd_sc_hd__decap_3
X_4001_ _6230_/Q _4081_/A2 _3999_/X _4000_/X VGND VGND VPWR VPWR _6230_/D sky130_fd_sc_hd__o22a_2
XFILLER_38_613 VGND VGND VPWR VPWR sky130_fd_sc_hd__fill_2
XFILLER_66_922 VGND VGND VPWR VPWR sky130_fd_sc_hd__fill_2
XFILLER_77_292 VGND VGND VPWR VPWR sky130_fd_sc_hd__fill_1
XFILLER_1_51 VGND VGND VPWR VPWR sky130_fd_sc_hd__decap_3
XFILLER_4_1450 VGND VGND VPWR VPWR sky130_fd_sc_hd__decap_3
XFILLER_37_145 VGND VGND VPWR VPWR sky130_fd_sc_hd__decap_3
XFILLER_19_860 VGND VGND VPWR VPWR sky130_fd_sc_hd__decap_3
XFILLER_20_1231 VGND VGND VPWR VPWR sky130_fd_sc_hd__decap_3
XFILLER_25_307 VGND VGND VPWR VPWR sky130_fd_sc_hd__decap_3
XFILLER_66_999 VGND VGND VPWR VPWR sky130_fd_sc_hd__decap_3
XFILLER_80_402 VGND VGND VPWR VPWR sky130_fd_sc_hd__fill_1
XFILLER_1_84 VGND VGND VPWR VPWR sky130_fd_sc_hd__decap_3
XFILLER_65_476 VGND VGND VPWR VPWR sky130_fd_sc_hd__fill_2
XFILLER_37_178 VGND VGND VPWR VPWR sky130_fd_sc_hd__decap_3
XFILLER_20_1264 VGND VGND VPWR VPWR sky130_fd_sc_hd__decap_3
XFILLER_37_189 VGND VGND VPWR VPWR sky130_fd_sc_hd__decap_3
X_5952_ hold987/X _6956_/Q _6048_/S VGND VGND VPWR VPWR _5952_/X sky130_fd_sc_hd__mux2_1
XFILLER_59_1452 VGND VGND VPWR VPWR sky130_fd_sc_hd__decap_3
XFILLER_59_1463 VGND VGND VPWR VPWR sky130_fd_sc_hd__decap_3
XFILLER_80_457 VGND VGND VPWR VPWR sky130_fd_sc_hd__decap_3
XFILLER_0_1369 VGND VGND VPWR VPWR sky130_fd_sc_hd__decap_3
XFILLER_20_1297 VGND VGND VPWR VPWR sky130_fd_sc_hd__decap_3
X_4903_ _6408_/Q _4903_/B VGND VGND VPWR VPWR _5198_/B sky130_fd_sc_hd__xnor2_2
XFILLER_55_1316 VGND VGND VPWR VPWR sky130_fd_sc_hd__decap_3
X_5883_ _5793_/C _5883_/A1 _5887_/S VGND VGND VPWR VPWR _6893_/D sky130_fd_sc_hd__mux2_1
XFILLER_33_362 VGND VGND VPWR VPWR sky130_fd_sc_hd__fill_1
X_4834_ _6334_/Q wire52/X _4831_/X _4833_/X VGND VGND VPWR VPWR _6334_/D sky130_fd_sc_hd__o22a_2
XFILLER_21_535 VGND VGND VPWR VPWR sky130_fd_sc_hd__fill_1
XFILLER_21_557 VGND VGND VPWR VPWR sky130_fd_sc_hd__decap_3
XFILLER_53_1051 VGND VGND VPWR VPWR sky130_fd_sc_hd__decap_3
XFILLER_53_1062 VGND VGND VPWR VPWR sky130_fd_sc_hd__fill_2
X_4765_ _6253_/Q _4765_/A2 _3428_/X _4765_/B2 VGND VGND VPWR VPWR _4765_/X sky130_fd_sc_hd__a22o_2
XFILLER_14_1046 VGND VGND VPWR VPWR sky130_fd_sc_hd__decap_3
X_6504_ _6912_/CLK _6504_/D load_slew718/X VGND VGND VPWR VPWR _6504_/Q sky130_fd_sc_hd__dfrtp_2
X_3716_ _4008_/A _4547_/B VGND VGND VPWR VPWR _4108_/B sky130_fd_sc_hd__or2_2
X_4696_ _6556_/Q _4696_/B VGND VGND VPWR VPWR _4696_/Y sky130_fd_sc_hd__nand2_2
XFILLER_31_1360 VGND VGND VPWR VPWR sky130_fd_sc_hd__decap_3
X_6435_ _7092_/CLK _6435_/D fanout689/X VGND VGND VPWR VPWR _6435_/Q sky130_fd_sc_hd__dfrtp_2
XFILLER_20_27 VGND VGND VPWR VPWR sky130_fd_sc_hd__fill_1
X_3647_ _3648_/A _3648_/B VGND VGND VPWR VPWR _3683_/A sky130_fd_sc_hd__xnor2_2
XFILLER_31_1393 VGND VGND VPWR VPWR sky130_fd_sc_hd__decap_3
XFILLER_20_49 VGND VGND VPWR VPWR sky130_fd_sc_hd__decap_3
XFILLER_66_1412 VGND VGND VPWR VPWR sky130_fd_sc_hd__decap_3
X_6366_ _7056_/CLK _6366_/D load_slew700/X VGND VGND VPWR VPWR _6366_/Q sky130_fd_sc_hd__dfrtp_2
X_3578_ _3579_/B _3579_/C VGND VGND VPWR VPWR _3615_/A sky130_fd_sc_hd__and2_2
XFILLER_1_918 VGND VGND VPWR VPWR sky130_fd_sc_hd__decap_3
XFILLER_27_1407 VGND VGND VPWR VPWR sky130_fd_sc_hd__decap_3
XFILLER_66_1456 VGND VGND VPWR VPWR sky130_fd_sc_hd__decap_3
X_5317_ _6451_/Q _5316_/X _5333_/S VGND VGND VPWR VPWR _6451_/D sky130_fd_sc_hd__mux2_1
XFILLER_0_417 VGND VGND VPWR VPWR sky130_fd_sc_hd__decap_3
XFILLER_62_1309 VGND VGND VPWR VPWR sky130_fd_sc_hd__decap_3
XFILLER_0_439 VGND VGND VPWR VPWR sky130_fd_sc_hd__decap_3
X_6297_ _7036_/CLK _6297_/D load_slew822/X VGND VGND VPWR VPWR _6297_/Q sky130_fd_sc_hd__dfrtp_2
X_5248_ _6424_/Q _5248_/A2 _5247_/X VGND VGND VPWR VPWR _6424_/D sky130_fd_sc_hd__a21o_2
XFILLER_9_1372 VGND VGND VPWR VPWR sky130_fd_sc_hd__decap_3
XFILLER_57_922 VGND VGND VPWR VPWR sky130_fd_sc_hd__decap_3
XFILLER_69_782 VGND VGND VPWR VPWR sky130_fd_sc_hd__fill_2
XFILLER_5_1225 VGND VGND VPWR VPWR sky130_fd_sc_hd__decap_3
XFILLER_5_1236 VGND VGND VPWR VPWR sky130_fd_sc_hd__decap_3
X_5179_ _6398_/Q _5248_/A2 _5062_/S _5178_/X VGND VGND VPWR VPWR _6398_/D sky130_fd_sc_hd__a22o_2
XFILLER_25_1186 VGND VGND VPWR VPWR sky130_fd_sc_hd__fill_1
XFILLER_29_646 VGND VGND VPWR VPWR sky130_fd_sc_hd__decap_3
XFILLER_21_1028 VGND VGND VPWR VPWR sky130_fd_sc_hd__decap_3
XFILLER_28_134 VGND VGND VPWR VPWR sky130_fd_sc_hd__decap_3
XFILLER_72_903 VGND VGND VPWR VPWR sky130_fd_sc_hd__decap_3
XFILLER_5_1269 VGND VGND VPWR VPWR sky130_fd_sc_hd__decap_3
XTAP_TAPCELL_ROW_3_266 VGND VPWR sky130_fd_sc_hd__tapvpwrvgnd_1
XTAP_TAPCELL_ROW_3_277 VGND VPWR sky130_fd_sc_hd__tapvpwrvgnd_1
XFILLER_56_465 VGND VGND VPWR VPWR sky130_fd_sc_hd__decap_3
XFILLER_72_925 VGND VGND VPWR VPWR sky130_fd_sc_hd__decap_3
XTAP_TAPCELL_ROW_3_288 VGND VPWR sky130_fd_sc_hd__tapvpwrvgnd_1
XFILLER_16_318 VGND VGND VPWR VPWR sky130_fd_sc_hd__decap_3
XFILLER_28_178 VGND VGND VPWR VPWR sky130_fd_sc_hd__decap_3
XTAP_TAPCELL_ROW_80_2307 VGND VPWR sky130_fd_sc_hd__tapvpwrvgnd_1
XFILLER_45_57 VGND VGND VPWR VPWR sky130_fd_sc_hd__decap_3
XTAP_TAPCELL_ROW_80_2318 VGND VPWR sky130_fd_sc_hd__tapvpwrvgnd_1
XFILLER_71_446 VGND VGND VPWR VPWR sky130_fd_sc_hd__fill_2
XFILLER_25_841 VGND VGND VPWR VPWR sky130_fd_sc_hd__decap_3
XFILLER_73_1416 VGND VGND VPWR VPWR sky130_fd_sc_hd__decap_3
XFILLER_24_351 VGND VGND VPWR VPWR sky130_fd_sc_hd__decap_3
XFILLER_40_811 VGND VGND VPWR VPWR sky130_fd_sc_hd__fill_1
XFILLER_73_1449 VGND VGND VPWR VPWR sky130_fd_sc_hd__decap_3
XFILLER_40_822 VGND VGND VPWR VPWR sky130_fd_sc_hd__decap_3
XFILLER_61_12 VGND VGND VPWR VPWR sky130_fd_sc_hd__fill_1
XFILLER_12_546 VGND VGND VPWR VPWR sky130_fd_sc_hd__decap_3
XFILLER_61_45 VGND VGND VPWR VPWR sky130_fd_sc_hd__fill_2
XFILLER_71_1162 VGND VGND VPWR VPWR sky130_fd_sc_hd__decap_3
XFILLER_36_1282 VGND VGND VPWR VPWR sky130_fd_sc_hd__decap_3
XTAP_TAPCELL_ROW_78_2225 VGND VPWR sky130_fd_sc_hd__tapvpwrvgnd_1
XFILLER_8_539 VGND VGND VPWR VPWR sky130_fd_sc_hd__decap_3
XTAP_TAPCELL_ROW_78_2236 VGND VPWR sky130_fd_sc_hd__tapvpwrvgnd_1
XPHY_EDGE_ROW_7_Left_88 VGND VGND VPWR VPWR sky130_fd_sc_hd__decap_3
XFILLER_71_1195 VGND VGND VPWR VPWR sky130_fd_sc_hd__decap_3
XFILLER_32_1146 VGND VGND VPWR VPWR sky130_fd_sc_hd__fill_2
XFILLER_6_18 VGND VGND VPWR VPWR sky130_fd_sc_hd__decap_3
XFILLER_10_1400 VGND VGND VPWR VPWR sky130_fd_sc_hd__decap_3
XFILLER_6_29 VGND VGND VPWR VPWR sky130_fd_sc_hd__decap_3
XFILLER_4_701 VGND VGND VPWR VPWR sky130_fd_sc_hd__decap_3
XFILLER_10_1444 VGND VGND VPWR VPWR sky130_fd_sc_hd__decap_3
XFILLER_3_233 VGND VGND VPWR VPWR sky130_fd_sc_hd__decap_3
XFILLER_79_535 VGND VGND VPWR VPWR sky130_fd_sc_hd__decap_3
XFILLER_0_940 VGND VGND VPWR VPWR sky130_fd_sc_hd__decap_3
XFILLER_0_962 VGND VGND VPWR VPWR sky130_fd_sc_hd__decap_3
XFILLER_48_911 VGND VGND VPWR VPWR sky130_fd_sc_hd__decap_3
XFILLER_0_984 VGND VGND VPWR VPWR sky130_fd_sc_hd__decap_3
XFILLER_43_1242 VGND VGND VPWR VPWR sky130_fd_sc_hd__decap_3
XFILLER_47_410 VGND VGND VPWR VPWR sky130_fd_sc_hd__decap_3
XFILLER_13_9 VGND VGND VPWR VPWR sky130_fd_sc_hd__decap_3
XFILLER_48_944 VGND VGND VPWR VPWR sky130_fd_sc_hd__decap_3
XFILLER_59_281 VGND VGND VPWR VPWR sky130_fd_sc_hd__decap_3
XFILLER_75_741 VGND VGND VPWR VPWR sky130_fd_sc_hd__decap_3
XFILLER_19_123 VGND VGND VPWR VPWR sky130_fd_sc_hd__fill_2
XFILLER_43_1275 VGND VGND VPWR VPWR sky130_fd_sc_hd__decap_3
XFILLER_47_432 VGND VGND VPWR VPWR sky130_fd_sc_hd__decap_3
XFILLER_48_977 VGND VGND VPWR VPWR sky130_fd_sc_hd__decap_3
XTAP_TAPCELL_ROW_50_1498 VGND VPWR sky130_fd_sc_hd__tapvpwrvgnd_1
XFILLER_75_785 VGND VGND VPWR VPWR sky130_fd_sc_hd__decap_3
XFILLER_78_1338 VGND VGND VPWR VPWR sky130_fd_sc_hd__decap_3
XFILLER_62_435 VGND VGND VPWR VPWR sky130_fd_sc_hd__decap_3
XTAP_TAPCELL_ROW_67_1940 VGND VPWR sky130_fd_sc_hd__tapvpwrvgnd_1
XTAP_TAPCELL_ROW_67_1951 VGND VPWR sky130_fd_sc_hd__tapvpwrvgnd_1
XFILLER_16_841 VGND VGND VPWR VPWR sky130_fd_sc_hd__decap_3
XFILLER_76_1040 VGND VGND VPWR VPWR sky130_fd_sc_hd__decap_3
XFILLER_62_468 VGND VGND VPWR VPWR sky130_fd_sc_hd__decap_3
XFILLER_31_800 VGND VGND VPWR VPWR sky130_fd_sc_hd__decap_3
XFILLER_15_351 VGND VGND VPWR VPWR sky130_fd_sc_hd__decap_3
XTAP_TAPCELL_ROW_63_1826 VGND VPWR sky130_fd_sc_hd__tapvpwrvgnd_1
XFILLER_76_1073 VGND VGND VPWR VPWR sky130_fd_sc_hd__decap_3
XFILLER_43_671 VGND VGND VPWR VPWR sky130_fd_sc_hd__fill_1
XTAP_TAPCELL_ROW_63_1837 VGND VPWR sky130_fd_sc_hd__tapvpwrvgnd_1
XFILLER_43_682 VGND VGND VPWR VPWR sky130_fd_sc_hd__decap_3
XTAP_TAPCELL_ROW_63_1848 VGND VPWR sky130_fd_sc_hd__tapvpwrvgnd_1
XTAP_TAPCELL_ROW_26_880 VGND VPWR sky130_fd_sc_hd__tapvpwrvgnd_1
XFILLER_30_321 VGND VGND VPWR VPWR sky130_fd_sc_hd__decap_3
XFILLER_31_855 VGND VGND VPWR VPWR sky130_fd_sc_hd__fill_1
XTAP_TAPCELL_ROW_13_530 VGND VPWR sky130_fd_sc_hd__tapvpwrvgnd_1
XTAP_TAPCELL_ROW_13_541 VGND VPWR sky130_fd_sc_hd__tapvpwrvgnd_1
XFILLER_15_1322 VGND VGND VPWR VPWR sky130_fd_sc_hd__decap_3
XFILLER_50_1202 VGND VGND VPWR VPWR sky130_fd_sc_hd__fill_2
XFILLER_54_1371 VGND VGND VPWR VPWR sky130_fd_sc_hd__fill_1
XFILLER_30_365 VGND VGND VPWR VPWR sky130_fd_sc_hd__decap_3
XFILLER_54_1382 VGND VGND VPWR VPWR sky130_fd_sc_hd__decap_3
XFILLER_15_1366 VGND VGND VPWR VPWR sky130_fd_sc_hd__decap_3
X_4550_ _4549_/B _4725_/B _4549_/Y _4769_/B1 VGND VGND VPWR VPWR _4551_/C sky130_fd_sc_hd__o211ai_2
XFILLER_50_1246 VGND VGND VPWR VPWR sky130_fd_sc_hd__decap_3
XFILLER_11_1219 VGND VGND VPWR VPWR sky130_fd_sc_hd__decap_3
XFILLER_7_550 VGND VGND VPWR VPWR sky130_fd_sc_hd__decap_3
XFILLER_15_1399 VGND VGND VPWR VPWR sky130_fd_sc_hd__fill_1
XFILLER_50_1279 VGND VGND VPWR VPWR sky130_fd_sc_hd__decap_3
XFILLER_7_561 VGND VGND VPWR VPWR sky130_fd_sc_hd__decap_3
X_3501_ _4355_/A _3501_/B VGND VGND VPWR VPWR _3501_/X sky130_fd_sc_hd__or2_2
X_4481_ _4541_/A _4836_/B VGND VGND VPWR VPWR _4481_/Y sky130_fd_sc_hd__nor2_2
Xmax_cap236 _5567_/Y VGND VGND VPWR VPWR _5602_/B1 sky130_fd_sc_hd__buf_2
X_6220_ _7088_/CLK _6220_/D fanout772/X VGND VGND VPWR VPWR _6220_/Q sky130_fd_sc_hd__dfrtp_2
X_3432_ _6327_/Q _6447_/Q VGND VGND VPWR VPWR _3432_/X sky130_fd_sc_hd__xor2_2
X_6151_ _6970_/CLK _6151_/D fanout675/X VGND VGND VPWR VPWR _6151_/Q sky130_fd_sc_hd__dfrtp_2
X_3363_ _6002_/A0 _3362_/X _3477_/S VGND VGND VPWR VPWR _6155_/D sky130_fd_sc_hd__mux2_1
XFILLER_44_1017 VGND VGND VPWR VPWR sky130_fd_sc_hd__decap_3
X_5102_ _6614_/Q _6654_/Q VGND VGND VPWR VPWR _5103_/B sky130_fd_sc_hd__xnor2_2
X_3294_ _6274_/Q _6378_/Q VGND VGND VPWR VPWR _3294_/X sky130_fd_sc_hd__xor2_2
X_6082_ _6081_/X _6078_/X _6082_/S VGND VGND VPWR VPWR _7077_/D sky130_fd_sc_hd__mux2_1
Xhold1206 _6128_/Q VGND VGND VPWR VPWR _5975_/A0 sky130_fd_sc_hd__dlygate4sd3_1
XFILLER_61_1331 VGND VGND VPWR VPWR sky130_fd_sc_hd__decap_3
Xhold1217 _6802_/Q VGND VGND VPWR VPWR _5759_/A1 sky130_fd_sc_hd__dlygate4sd3_1
XFILLER_26_1462 VGND VGND VPWR VPWR sky130_fd_sc_hd__decap_3
X_5033_ _6700_/Q _3066_/Y _5314_/S VGND VGND VPWR VPWR _5033_/X sky130_fd_sc_hd__mux2_1
Xhold1228 _6691_/Q VGND VGND VPWR VPWR _5632_/A1 sky130_fd_sc_hd__dlygate4sd3_1
Xhold1239 _6106_/Q VGND VGND VPWR VPWR _5953_/A0 sky130_fd_sc_hd__dlygate4sd3_1
XFILLER_22_1315 VGND VGND VPWR VPWR sky130_fd_sc_hd__fill_1
XFILLER_22_1326 VGND VGND VPWR VPWR sky130_fd_sc_hd__decap_3
XFILLER_61_1375 VGND VGND VPWR VPWR sky130_fd_sc_hd__decap_3
XFILLER_2_1409 VGND VGND VPWR VPWR sky130_fd_sc_hd__decap_3
XFILLER_54_903 VGND VGND VPWR VPWR sky130_fd_sc_hd__decap_3
XTAP_TAPCELL_ROW_0_203 VGND VPWR sky130_fd_sc_hd__tapvpwrvgnd_1
XFILLER_22_1359 VGND VGND VPWR VPWR sky130_fd_sc_hd__decap_3
XFILLER_38_465 VGND VGND VPWR VPWR sky130_fd_sc_hd__decap_3
XFILLER_54_914 VGND VGND VPWR VPWR sky130_fd_sc_hd__decap_3
XFILLER_54_925 VGND VGND VPWR VPWR sky130_fd_sc_hd__decap_3
XFILLER_53_402 VGND VGND VPWR VPWR sky130_fd_sc_hd__decap_3
XFILLER_0_1111 VGND VGND VPWR VPWR sky130_fd_sc_hd__decap_3
XFILLER_4_1291 VGND VGND VPWR VPWR sky130_fd_sc_hd__decap_3
X_6984_ _7048_/CLK _6984_/D load_slew658/X VGND VGND VPWR VPWR _6984_/Q sky130_fd_sc_hd__dfrtp_2
XFILLER_0_1133 VGND VGND VPWR VPWR sky130_fd_sc_hd__decap_3
XFILLER_65_295 VGND VGND VPWR VPWR sky130_fd_sc_hd__decap_3
XFILLER_0_1155 VGND VGND VPWR VPWR sky130_fd_sc_hd__decap_3
XFILLER_59_1260 VGND VGND VPWR VPWR sky130_fd_sc_hd__decap_3
X_5935_ hold894/X _6939_/Q _6032_/S VGND VGND VPWR VPWR _5935_/X sky130_fd_sc_hd__mux2_1
XFILLER_0_1177 VGND VGND VPWR VPWR sky130_fd_sc_hd__decap_3
XTAP_TAPCELL_ROW_24_817 VGND VPWR sky130_fd_sc_hd__tapvpwrvgnd_1
XTAP_TAPCELL_ROW_24_828 VGND VPWR sky130_fd_sc_hd__tapvpwrvgnd_1
XFILLER_55_1135 VGND VGND VPWR VPWR sky130_fd_sc_hd__decap_3
X_5866_ _5866_/A0 _5904_/A0 _5867_/S VGND VGND VPWR VPWR _6880_/D sky130_fd_sc_hd__mux2_1
Xclkbuf_leaf_60_clk clkload5/A VGND VGND VPWR VPWR _7011_/CLK sky130_fd_sc_hd__clkbuf_8
X_4817_ _4817_/A1 _4814_/X _4815_/Y _4816_/X _4874_/C1 VGND VGND VPWR VPWR _4817_/X
+ sky130_fd_sc_hd__o221a_2
XFILLER_33_1422 VGND VGND VPWR VPWR sky130_fd_sc_hd__decap_3
X_5797_ _5801_/A_N _5868_/B _5797_/C VGND VGND VPWR VPWR _5797_/X sky130_fd_sc_hd__and3b_2
XFILLER_33_1455 VGND VGND VPWR VPWR sky130_fd_sc_hd__fill_1
XFILLER_33_1466 VGND VGND VPWR VPWR sky130_fd_sc_hd__decap_3
X_4748_ _6571_/Q _4747_/A _4769_/B1 VGND VGND VPWR VPWR _4748_/X sky130_fd_sc_hd__a21bo_2
XTAP_TAPCELL_ROW_73_2100 VGND VPWR sky130_fd_sc_hd__tapvpwrvgnd_1
XTAP_TAPCELL_ROW_73_2111 VGND VPWR sky130_fd_sc_hd__tapvpwrvgnd_1
X_4679_ _6313_/Q _4863_/A2 _4676_/X _4678_/X VGND VGND VPWR VPWR _6313_/D sky130_fd_sc_hd__o22a_2
XPHY_EDGE_ROW_1_Right_1 VGND VGND VPWR VPWR sky130_fd_sc_hd__decap_3
X_6418_ _7020_/CLK _6418_/D fanout807/X VGND VGND VPWR VPWR _6418_/Q sky130_fd_sc_hd__dfrtp_2
XFILLER_66_1220 VGND VGND VPWR VPWR sky130_fd_sc_hd__decap_3
XFILLER_1_715 VGND VGND VPWR VPWR sky130_fd_sc_hd__decap_3
XFILLER_0_203 VGND VGND VPWR VPWR sky130_fd_sc_hd__decap_3
XFILLER_66_1253 VGND VGND VPWR VPWR sky130_fd_sc_hd__decap_3
X_6349_ _7019_/CLK _6349_/D fanout836/X VGND VGND VPWR VPWR _6349_/Q sky130_fd_sc_hd__dfrtp_2
XFILLER_66_1264 VGND VGND VPWR VPWR sky130_fd_sc_hd__decap_3
XFILLER_0_225 VGND VGND VPWR VPWR sky130_fd_sc_hd__decap_3
XFILLER_1_759 VGND VGND VPWR VPWR sky130_fd_sc_hd__decap_3
XFILLER_27_1248 VGND VGND VPWR VPWR sky130_fd_sc_hd__decap_3
XFILLER_66_1297 VGND VGND VPWR VPWR sky130_fd_sc_hd__decap_3
XFILLER_9_1180 VGND VGND VPWR VPWR sky130_fd_sc_hd__decap_3
XFILLER_48_229 VGND VGND VPWR VPWR sky130_fd_sc_hd__decap_3
XFILLER_56_12 VGND VGND VPWR VPWR sky130_fd_sc_hd__decap_3
XFILLER_40_1415 VGND VGND VPWR VPWR sky130_fd_sc_hd__decap_3
XFILLER_5_1077 VGND VGND VPWR VPWR sky130_fd_sc_hd__decap_3
XFILLER_40_1459 VGND VGND VPWR VPWR sky130_fd_sc_hd__decap_3
XFILLER_45_914 VGND VGND VPWR VPWR sky130_fd_sc_hd__decap_3
XFILLER_44_402 VGND VGND VPWR VPWR sky130_fd_sc_hd__decap_3
XFILLER_72_722 VGND VGND VPWR VPWR sky130_fd_sc_hd__decap_3
XFILLER_57_796 VGND VGND VPWR VPWR sky130_fd_sc_hd__decap_3
XFILLER_29_498 VGND VGND VPWR VPWR sky130_fd_sc_hd__decap_3
XFILLER_44_424 VGND VGND VPWR VPWR sky130_fd_sc_hd__decap_3
XFILLER_16_126 VGND VGND VPWR VPWR sky130_fd_sc_hd__decap_3
XFILLER_72_755 VGND VGND VPWR VPWR sky130_fd_sc_hd__fill_1
XFILLER_45_969 VGND VGND VPWR VPWR sky130_fd_sc_hd__fill_2
XFILLER_72_766 VGND VGND VPWR VPWR sky130_fd_sc_hd__decap_3
XFILLER_38_1300 VGND VGND VPWR VPWR sky130_fd_sc_hd__decap_3
XFILLER_44_468 VGND VGND VPWR VPWR sky130_fd_sc_hd__decap_3
XFILLER_77_1360 VGND VGND VPWR VPWR sky130_fd_sc_hd__decap_3
XFILLER_71_265 VGND VGND VPWR VPWR sky130_fd_sc_hd__fill_2
XFILLER_73_1213 VGND VGND VPWR VPWR sky130_fd_sc_hd__decap_3
XFILLER_72_44 VGND VGND VPWR VPWR sky130_fd_sc_hd__decap_3
XFILLER_71_276 VGND VGND VPWR VPWR sky130_fd_sc_hd__decap_3
XFILLER_25_671 VGND VGND VPWR VPWR sky130_fd_sc_hd__fill_1
XFILLER_77_1393 VGND VGND VPWR VPWR sky130_fd_sc_hd__decap_3
XFILLER_71_287 VGND VGND VPWR VPWR sky130_fd_sc_hd__fill_1
XFILLER_38_1344 VGND VGND VPWR VPWR sky130_fd_sc_hd__decap_3
XFILLER_73_1257 VGND VGND VPWR VPWR sky130_fd_sc_hd__decap_3
Xclkbuf_leaf_51_clk clkload5/A VGND VGND VPWR VPWR _7019_/CLK sky130_fd_sc_hd__clkbuf_8
XFILLER_38_1388 VGND VGND VPWR VPWR sky130_fd_sc_hd__decap_3
XFILLER_12_365 VGND VGND VPWR VPWR sky130_fd_sc_hd__decap_3
XFILLER_9_837 VGND VGND VPWR VPWR sky130_fd_sc_hd__decap_3
XFILLER_40_685 VGND VGND VPWR VPWR sky130_fd_sc_hd__decap_3
XFILLER_9_859 VGND VGND VPWR VPWR sky130_fd_sc_hd__fill_1
XFILLER_36_1090 VGND VGND VPWR VPWR sky130_fd_sc_hd__fill_2
XFILLER_10_1241 VGND VGND VPWR VPWR sky130_fd_sc_hd__decap_3
XFILLER_4_542 VGND VGND VPWR VPWR sky130_fd_sc_hd__decap_3
XFILLER_67_1039 VGND VGND VPWR VPWR sky130_fd_sc_hd__decap_3
XFILLER_49_1440 VGND VGND VPWR VPWR sky130_fd_sc_hd__decap_3
XFILLER_4_575 VGND VGND VPWR VPWR sky130_fd_sc_hd__decap_3
XFILLER_10_1285 VGND VGND VPWR VPWR sky130_fd_sc_hd__decap_3
XTAP_TAPCELL_ROW_56_1652 VGND VPWR sky130_fd_sc_hd__tapvpwrvgnd_1
XFILLER_45_1304 VGND VGND VPWR VPWR sky130_fd_sc_hd__decap_3
XTAP_TAPCELL_ROW_56_1663 VGND VPWR sky130_fd_sc_hd__tapvpwrvgnd_1
XFILLER_80_1217 VGND VGND VPWR VPWR sky130_fd_sc_hd__decap_3
XFILLER_45_1337 VGND VGND VPWR VPWR sky130_fd_sc_hd__decap_3
XFILLER_45_1348 VGND VGND VPWR VPWR sky130_fd_sc_hd__decap_3
XFILLER_80_1239 VGND VGND VPWR VPWR sky130_fd_sc_hd__decap_3
XTAP_TAPCELL_ROW_52_1549 VGND VPWR sky130_fd_sc_hd__tapvpwrvgnd_1
XFILLER_39_207 VGND VGND VPWR VPWR sky130_fd_sc_hd__decap_3
XTAP_TAPCELL_ROW_7_380 VGND VPWR sky130_fd_sc_hd__tapvpwrvgnd_1
XTAP_TAPCELL_ROW_7_391 VGND VPWR sky130_fd_sc_hd__tapvpwrvgnd_1
XFILLER_0_781 VGND VGND VPWR VPWR sky130_fd_sc_hd__decap_3
XFILLER_48_730 VGND VGND VPWR VPWR sky130_fd_sc_hd__decap_3
XFILLER_11_6 VGND VGND VPWR VPWR sky130_fd_sc_hd__decap_3
XFILLER_78_1102 VGND VGND VPWR VPWR sky130_fd_sc_hd__decap_3
XFILLER_35_402 VGND VGND VPWR VPWR sky130_fd_sc_hd__decap_3
XFILLER_36_925 VGND VGND VPWR VPWR sky130_fd_sc_hd__decap_3
XFILLER_78_1135 VGND VGND VPWR VPWR sky130_fd_sc_hd__decap_3
XFILLER_1_1431 VGND VGND VPWR VPWR sky130_fd_sc_hd__decap_3
XFILLER_63_744 VGND VGND VPWR VPWR sky130_fd_sc_hd__decap_3
XFILLER_35_446 VGND VGND VPWR VPWR sky130_fd_sc_hd__fill_2
XFILLER_21_1381 VGND VGND VPWR VPWR sky130_fd_sc_hd__decap_3
XFILLER_78_1179 VGND VGND VPWR VPWR sky130_fd_sc_hd__decap_3
XFILLER_56_1400 VGND VGND VPWR VPWR sky130_fd_sc_hd__decap_3
XFILLER_63_777 VGND VGND VPWR VPWR sky130_fd_sc_hd__decap_3
XTAP_TAPCELL_ROW_18_666 VGND VPWR sky130_fd_sc_hd__tapvpwrvgnd_1
XFILLER_63_788 VGND VGND VPWR VPWR sky130_fd_sc_hd__decap_3
XTAP_TAPCELL_ROW_18_677 VGND VPWR sky130_fd_sc_hd__tapvpwrvgnd_1
XFILLER_51_939 VGND VGND VPWR VPWR sky130_fd_sc_hd__fill_1
X_3981_ _4061_/A1 _3978_/X _3979_/Y _3980_/X _4013_/A VGND VGND VPWR VPWR _3981_/X
+ sky130_fd_sc_hd__o221a_2
XFILLER_56_1444 VGND VGND VPWR VPWR sky130_fd_sc_hd__decap_3
X_5720_ _5913_/A0 _5720_/A1 wire88/X VGND VGND VPWR VPWR _6768_/D sky130_fd_sc_hd__mux2_1
Xclkbuf_leaf_42_clk clkload6/A VGND VGND VPWR VPWR _6807_/CLK sky130_fd_sc_hd__clkbuf_8
XFILLER_17_1428 VGND VGND VPWR VPWR sky130_fd_sc_hd__decap_3
X_5651_ _5651_/A0 _5899_/A0 _5657_/S VGND VGND VPWR VPWR _6707_/D sky130_fd_sc_hd__mux2_1
X_4602_ _6543_/Q _4602_/B VGND VGND VPWR VPWR _4602_/Y sky130_fd_sc_hd__nand2_2
X_5582_ _5582_/A VGND VGND VPWR VPWR _5582_/Y sky130_fd_sc_hd__inv_2
X_4533_ _6526_/Q _4487_/X _4888_/C1 VGND VGND VPWR VPWR _4533_/X sky130_fd_sc_hd__a21o_2
XFILLER_11_1049 VGND VGND VPWR VPWR sky130_fd_sc_hd__fill_2
X_4464_ _6854_/Q wire295/X _4462_/X _4463_/X VGND VGND VPWR VPWR _4464_/X sky130_fd_sc_hd__a211o_2
X_6203_ _7046_/CLK _6203_/D load_slew754/X VGND VGND VPWR VPWR _6203_/Q sky130_fd_sc_hd__dfrtp_2
Xclkbuf_4_3__f_clk clkbuf_3_1_0_clk/X VGND VGND VPWR VPWR clkload1/A sky130_fd_sc_hd__clkbuf_16
X_3415_ hold911/X _3414_/X _3415_/S VGND VGND VPWR VPWR _6181_/D sky130_fd_sc_hd__mux2_1
XFILLER_63_1404 VGND VGND VPWR VPWR sky130_fd_sc_hd__decap_3
X_4395_ _4403_/A _4394_/X _4360_/X _6508_/Q VGND VGND VPWR VPWR _4395_/X sky130_fd_sc_hd__a2bb2o_2
Xfanout816 fanout817/X VGND VGND VPWR VPWR fanout816/X sky130_fd_sc_hd__clkdlybuf4s25_1
X_6134_ _6993_/CLK _6134_/D load_slew710/X VGND VGND VPWR VPWR _6134_/Q sky130_fd_sc_hd__dfrtp_2
XFILLER_63_1437 VGND VGND VPWR VPWR sky130_fd_sc_hd__decap_3
Xfanout838 fanout841/X VGND VGND VPWR VPWR fanout838/X sky130_fd_sc_hd__clkdlybuf4s25_1
X_3346_ _6228_/Q _6404_/Q VGND VGND VPWR VPWR _3346_/X sky130_fd_sc_hd__xor2_2
XTAP_TAPCELL_ROW_5_328 VGND VPWR sky130_fd_sc_hd__tapvpwrvgnd_1
XFILLER_58_516 VGND VGND VPWR VPWR sky130_fd_sc_hd__decap_3
XTAP_TAPCELL_ROW_5_339 VGND VPWR sky130_fd_sc_hd__tapvpwrvgnd_1
Xhold1003 _7007_/Q VGND VGND VPWR VPWR _6003_/A1 sky130_fd_sc_hd__dlygate4sd3_1
XFILLER_6_1320 VGND VGND VPWR VPWR sky130_fd_sc_hd__decap_3
Xhold1014 _6140_/Q VGND VGND VPWR VPWR _5987_/A0 sky130_fd_sc_hd__dlygate4sd3_1
X_6065_ _6062_/B _5731_/B _5722_/A VGND VGND VPWR VPWR _6065_/Y sky130_fd_sc_hd__o21ai_2
Xhold1025 _6693_/Q VGND VGND VPWR VPWR _5634_/A1 sky130_fd_sc_hd__dlygate4sd3_1
Xload_slew283 _4635_/A2 VGND VGND VPWR VPWR _4869_/A2 sky130_fd_sc_hd__clkbuf_4
XFILLER_26_1270 VGND VGND VPWR VPWR sky130_fd_sc_hd__decap_3
X_3277_ hold884/X _3276_/X _3389_/S VGND VGND VPWR VPWR _6112_/D sky130_fd_sc_hd__mux2_1
XFILLER_6_1353 VGND VGND VPWR VPWR sky130_fd_sc_hd__decap_3
Xhold1036 _6630_/Q VGND VGND VPWR VPWR _5547_/B1 sky130_fd_sc_hd__dlygate4sd3_1
Xhold1047 _5940_/X VGND VGND VPWR VPWR _6944_/D sky130_fd_sc_hd__dlygate4sd3_1
Xhold1058 _6173_/Q VGND VGND VPWR VPWR _6020_/A0 sky130_fd_sc_hd__dlygate4sd3_1
X_5016_ _6392_/Q _5246_/B VGND VGND VPWR VPWR _5016_/X sky130_fd_sc_hd__or2_2
XFILLER_38_240 VGND VGND VPWR VPWR sky130_fd_sc_hd__fill_1
XFILLER_39_774 VGND VGND VPWR VPWR sky130_fd_sc_hd__decap_3
XFILLER_2_1217 VGND VGND VPWR VPWR sky130_fd_sc_hd__decap_3
Xhold1069 _5938_/X VGND VGND VPWR VPWR _6942_/D sky130_fd_sc_hd__dlygate4sd3_1
XFILLER_6_1397 VGND VGND VPWR VPWR sky130_fd_sc_hd__decap_3
XFILLER_26_402 VGND VGND VPWR VPWR sky130_fd_sc_hd__decap_3
XFILLER_39_785 VGND VGND VPWR VPWR sky130_fd_sc_hd__decap_3
XFILLER_27_936 VGND VGND VPWR VPWR sky130_fd_sc_hd__decap_3
XFILLER_38_284 VGND VGND VPWR VPWR sky130_fd_sc_hd__fill_2
XFILLER_54_744 VGND VGND VPWR VPWR sky130_fd_sc_hd__decap_3
XFILLER_38_295 VGND VGND VPWR VPWR sky130_fd_sc_hd__decap_3
XFILLER_53_243 VGND VGND VPWR VPWR sky130_fd_sc_hd__decap_3
XFILLER_14_608 VGND VGND VPWR VPWR sky130_fd_sc_hd__decap_3
XFILLER_53_265 VGND VGND VPWR VPWR sky130_fd_sc_hd__decap_3
X_6967_ _7039_/CLK _6967_/D fanout820/X VGND VGND VPWR VPWR _6967_/Q sky130_fd_sc_hd__dfrtp_2
XFILLER_41_427 VGND VGND VPWR VPWR sky130_fd_sc_hd__fill_2
XFILLER_53_298 VGND VGND VPWR VPWR sky130_fd_sc_hd__decap_3
X_5918_ _5918_/A0 _5918_/A1 _5923_/S VGND VGND VPWR VPWR _6924_/D sky130_fd_sc_hd__mux2_1
XFILLER_41_449 VGND VGND VPWR VPWR sky130_fd_sc_hd__decap_3
XFILLER_50_950 VGND VGND VPWR VPWR sky130_fd_sc_hd__decap_3
Xclkbuf_leaf_33_clk clkbuf_4_6__f_clk/X VGND VGND VPWR VPWR _6913_/CLK sky130_fd_sc_hd__clkbuf_8
X_6898_ _7000_/CLK _6898_/D load_slew694/X VGND VGND VPWR VPWR _6898_/Q sky130_fd_sc_hd__dfrtp_2
X_5849_ _5849_/A0 _5801_/C _5849_/S VGND VGND VPWR VPWR _6865_/D sky130_fd_sc_hd__mux2_1
XFILLER_21_151 VGND VGND VPWR VPWR sky130_fd_sc_hd__decap_3
XFILLER_42_58 VGND VGND VPWR VPWR sky130_fd_sc_hd__decap_3
XFILLER_33_1230 VGND VGND VPWR VPWR sky130_fd_sc_hd__fill_2
XFILLER_10_869 VGND VGND VPWR VPWR sky130_fd_sc_hd__decap_3
XFILLER_33_1263 VGND VGND VPWR VPWR sky130_fd_sc_hd__decap_3
XFILLER_68_1315 VGND VGND VPWR VPWR sky130_fd_sc_hd__fill_1
XFILLER_68_1326 VGND VGND VPWR VPWR sky130_fd_sc_hd__decap_3
XFILLER_68_1359 VGND VGND VPWR VPWR sky130_fd_sc_hd__decap_3
XFILLER_1_523 VGND VGND VPWR VPWR sky130_fd_sc_hd__decap_3
Xhold870 _6029_/X VGND VGND VPWR VPWR _7033_/D sky130_fd_sc_hd__dlygate4sd3_1
Xhold881 _5936_/X VGND VGND VPWR VPWR _6940_/D sky130_fd_sc_hd__dlygate4sd3_1
Xhold892 _6198_/Q VGND VGND VPWR VPWR hold892/X sky130_fd_sc_hd__dlygate4sd3_1
XFILLER_1_556 VGND VGND VPWR VPWR sky130_fd_sc_hd__decap_3
XFILLER_1_567 VGND VGND VPWR VPWR sky130_fd_sc_hd__decap_3
XFILLER_49_505 VGND VGND VPWR VPWR sky130_fd_sc_hd__decap_3
XFILLER_67_33 VGND VGND VPWR VPWR sky130_fd_sc_hd__decap_3
XFILLER_7_1139 VGND VGND VPWR VPWR sky130_fd_sc_hd__decap_3
XFILLER_49_538 VGND VGND VPWR VPWR sky130_fd_sc_hd__fill_1
XFILLER_67_66 VGND VGND VPWR VPWR sky130_fd_sc_hd__decap_3
XFILLER_79_1422 VGND VGND VPWR VPWR sky130_fd_sc_hd__decap_3
XFILLER_18_925 VGND VGND VPWR VPWR sky130_fd_sc_hd__decap_3
XFILLER_45_711 VGND VGND VPWR VPWR sky130_fd_sc_hd__decap_3
XFILLER_45_722 VGND VGND VPWR VPWR sky130_fd_sc_hd__decap_3
Xhold1570 _6664_/Q VGND VGND VPWR VPWR _5591_/B2 sky130_fd_sc_hd__dlygate4sd3_1
XTAP_TAPCELL_ROW_28_920 VGND VPWR sky130_fd_sc_hd__tapvpwrvgnd_1
XFILLER_40_1267 VGND VGND VPWR VPWR sky130_fd_sc_hd__decap_3
XFILLER_79_1455 VGND VGND VPWR VPWR sky130_fd_sc_hd__fill_1
XFILLER_29_284 VGND VGND VPWR VPWR sky130_fd_sc_hd__fill_2
XTAP_TAPCELL_ROW_28_931 VGND VPWR sky130_fd_sc_hd__tapvpwrvgnd_1
XFILLER_45_744 VGND VGND VPWR VPWR sky130_fd_sc_hd__fill_2
XFILLER_79_1466 VGND VGND VPWR VPWR sky130_fd_sc_hd__decap_3
XFILLER_45_766 VGND VGND VPWR VPWR sky130_fd_sc_hd__decap_3
XFILLER_75_1319 VGND VGND VPWR VPWR sky130_fd_sc_hd__decap_3
XFILLER_17_479 VGND VGND VPWR VPWR sky130_fd_sc_hd__decap_3
XFILLER_32_405 VGND VGND VPWR VPWR sky130_fd_sc_hd__decap_3
XFILLER_45_788 VGND VGND VPWR VPWR sky130_fd_sc_hd__decap_3
XTAP_TAPCELL_ROW_15_603 VGND VPWR sky130_fd_sc_hd__tapvpwrvgnd_1
XFILLER_32_449 VGND VGND VPWR VPWR sky130_fd_sc_hd__decap_3
Xclkbuf_leaf_24_clk clkload2/A VGND VGND VPWR VPWR _7032_/CLK sky130_fd_sc_hd__clkbuf_8
XFILLER_13_652 VGND VGND VPWR VPWR sky130_fd_sc_hd__decap_3
XTAP_TAPCELL_ROW_45_1364 VGND VPWR sky130_fd_sc_hd__tapvpwrvgnd_1
XFILLER_9_612 VGND VGND VPWR VPWR sky130_fd_sc_hd__decap_3
XTAP_TAPCELL_ROW_45_1375 VGND VPWR sky130_fd_sc_hd__tapvpwrvgnd_1
XFILLER_80_9 VGND VGND VPWR VPWR sky130_fd_sc_hd__decap_3
XFILLER_73_1087 VGND VGND VPWR VPWR sky130_fd_sc_hd__decap_3
XFILLER_9_634 VGND VGND VPWR VPWR sky130_fd_sc_hd__fill_1
XFILLER_41_994 VGND VGND VPWR VPWR sky130_fd_sc_hd__decap_3
XFILLER_34_1049 VGND VGND VPWR VPWR sky130_fd_sc_hd__decap_3
XFILLER_8_122 VGND VGND VPWR VPWR sky130_fd_sc_hd__decap_3
XFILLER_16_1450 VGND VGND VPWR VPWR sky130_fd_sc_hd__decap_3
XFILLER_40_493 VGND VGND VPWR VPWR sky130_fd_sc_hd__fill_1
XFILLER_9_667 VGND VGND VPWR VPWR sky130_fd_sc_hd__decap_3
XFILLER_12_1303 VGND VGND VPWR VPWR sky130_fd_sc_hd__decap_3
XFILLER_51_1363 VGND VGND VPWR VPWR sky130_fd_sc_hd__decap_3
XFILLER_32_91 VGND VGND VPWR VPWR sky130_fd_sc_hd__decap_3
XTAP_TAPCELL_ROW_58_1703 VGND VPWR sky130_fd_sc_hd__tapvpwrvgnd_1
XFILLER_12_1347 VGND VGND VPWR VPWR sky130_fd_sc_hd__decap_3
XFILLER_51_1396 VGND VGND VPWR VPWR sky130_fd_sc_hd__decap_3
XTAP_TAPCELL_ROW_58_1714 VGND VPWR sky130_fd_sc_hd__tapvpwrvgnd_1
XFILLER_59_6 VGND VGND VPWR VPWR sky130_fd_sc_hd__decap_3
XFILLER_5_884 VGND VGND VPWR VPWR sky130_fd_sc_hd__decap_3
XFILLER_10_1093 VGND VGND VPWR VPWR sky130_fd_sc_hd__decap_3
XFILLER_4_394 VGND VGND VPWR VPWR sky130_fd_sc_hd__decap_3
XFILLER_49_1281 VGND VGND VPWR VPWR sky130_fd_sc_hd__decap_3
X_3200_ _6952_/Q _6960_/Q _3200_/S VGND VGND VPWR VPWR _3200_/X sky130_fd_sc_hd__mux2_1
XFILLER_49_1292 VGND VGND VPWR VPWR sky130_fd_sc_hd__decap_3
X_4180_ _4303_/A _4347_/A VGND VGND VPWR VPWR _4259_/A sky130_fd_sc_hd__xnor2_2
XFILLER_67_302 VGND VGND VPWR VPWR sky130_fd_sc_hd__decap_3
XFILLER_68_836 VGND VGND VPWR VPWR sky130_fd_sc_hd__decap_3
XFILLER_80_1058 VGND VGND VPWR VPWR sky130_fd_sc_hd__decap_3
X_3131_ _3126_/X _3127_/X _3130_/X _3217_/A VGND VGND VPWR VPWR _3131_/X sky130_fd_sc_hd__o211a_2
XFILLER_23_1410 VGND VGND VPWR VPWR sky130_fd_sc_hd__decap_3
X_3062_ _6358_/Q VGND VGND VPWR VPWR _3062_/Y sky130_fd_sc_hd__inv_2
XFILLER_23_1443 VGND VGND VPWR VPWR sky130_fd_sc_hd__decap_3
XFILLER_67_379 VGND VGND VPWR VPWR sky130_fd_sc_hd__decap_3
Xclkbuf_4_11__f_clk clkbuf_3_5_0_clk/X VGND VGND VPWR VPWR clkload5/A sky130_fd_sc_hd__clkbuf_16
XFILLER_35_243 VGND VGND VPWR VPWR sky130_fd_sc_hd__decap_3
X_6821_ _7016_/CLK _6821_/D load_slew664/X VGND VGND VPWR VPWR _6821_/Q sky130_fd_sc_hd__dfrtp_2
XFILLER_51_703 VGND VGND VPWR VPWR sky130_fd_sc_hd__fill_1
XFILLER_23_405 VGND VGND VPWR VPWR sky130_fd_sc_hd__decap_3
XFILLER_24_928 VGND VGND VPWR VPWR sky130_fd_sc_hd__fill_2
XFILLER_1_1272 VGND VGND VPWR VPWR sky130_fd_sc_hd__decap_3
XFILLER_17_980 VGND VGND VPWR VPWR sky130_fd_sc_hd__decap_3
XFILLER_50_224 VGND VGND VPWR VPWR sky130_fd_sc_hd__decap_3
XFILLER_23_449 VGND VGND VPWR VPWR sky130_fd_sc_hd__decap_3
X_6752_ _6752_/CLK _6752_/D load_slew671/X VGND VGND VPWR VPWR _6752_/Q sky130_fd_sc_hd__dfrtp_2
XFILLER_56_1241 VGND VGND VPWR VPWR sky130_fd_sc_hd__decap_3
Xclkbuf_leaf_15_clk clkbuf_4_4__f_clk/X VGND VGND VPWR VPWR _6752_/CLK sky130_fd_sc_hd__clkbuf_8
X_3964_ _3338_/X _4080_/A2 _4080_/B1 _6866_/Q _4080_/C1 VGND VGND VPWR VPWR _3964_/X
+ sky130_fd_sc_hd__a221o_2
XFILLER_17_1214 VGND VGND VPWR VPWR sky130_fd_sc_hd__decap_3
XFILLER_52_1105 VGND VGND VPWR VPWR sky130_fd_sc_hd__decap_3
X_5703_ _5703_/A _5703_/B VGND VGND VPWR VPWR _5758_/C sky130_fd_sc_hd__nand2_2
XFILLER_32_972 VGND VGND VPWR VPWR sky130_fd_sc_hd__decap_3
XFILLER_17_1236 VGND VGND VPWR VPWR sky130_fd_sc_hd__decap_3
XFILLER_56_1285 VGND VGND VPWR VPWR sky130_fd_sc_hd__decap_3
X_6683_ _7004_/CLK _6683_/D fanout839/X VGND VGND VPWR VPWR _6683_/Q sky130_fd_sc_hd__dfrtp_2
X_3895_ _4010_/A _6317_/Q VGND VGND VPWR VPWR _3895_/X sky130_fd_sc_hd__and2b_2
XFILLER_17_1269 VGND VGND VPWR VPWR sky130_fd_sc_hd__decap_3
X_5634_ _5910_/A0 _5634_/A1 wire93/A VGND VGND VPWR VPWR _6693_/D sky130_fd_sc_hd__mux2_1
XFILLER_30_1403 VGND VGND VPWR VPWR sky130_fd_sc_hd__decap_3
X_5565_ _6366_/Q _5565_/A2 _5565_/B1 _5502_/D VGND VGND VPWR VPWR _6648_/D sky130_fd_sc_hd__a22o_2
XFILLER_30_1447 VGND VGND VPWR VPWR sky130_fd_sc_hd__decap_3
X_4516_ _6291_/Q wire49/X _4513_/X _4515_/X VGND VGND VPWR VPWR _6291_/D sky130_fd_sc_hd__o22a_2
X_5496_ _7082_/Q _5499_/B _5489_/Y VGND VGND VPWR VPWR _5498_/A sky130_fd_sc_hd__a21o_2
XFILLER_2_309 VGND VGND VPWR VPWR sky130_fd_sc_hd__decap_3
X_4447_ _6514_/Q _4526_/B _4880_/C1 VGND VGND VPWR VPWR _4447_/X sky130_fd_sc_hd__a21bo_2
Xfanout602 input9/X VGND VGND VPWR VPWR _5858_/A1 sky130_fd_sc_hd__clkdlybuf4s25_1
XFILLER_28_1332 VGND VGND VPWR VPWR sky130_fd_sc_hd__decap_3
XFILLER_63_1212 VGND VGND VPWR VPWR sky130_fd_sc_hd__decap_3
XFILLER_67_1381 VGND VGND VPWR VPWR sky130_fd_sc_hd__decap_3
XFILLER_8_1415 VGND VGND VPWR VPWR sky130_fd_sc_hd__decap_3
Xfanout624 _5826_/A0 VGND VGND VPWR VPWR _5688_/A1 sky130_fd_sc_hd__clkdlybuf4s25_1
Xfanout635 input2/X VGND VGND VPWR VPWR _5889_/A0 sky130_fd_sc_hd__clkdlybuf4s25_1
XFILLER_28_1365 VGND VGND VPWR VPWR sky130_fd_sc_hd__decap_3
X_4378_ _4403_/A _4738_/B VGND VGND VPWR VPWR _4378_/Y sky130_fd_sc_hd__nor2_2
XFILLER_63_1245 VGND VGND VPWR VPWR sky130_fd_sc_hd__decap_3
Xfanout646 fanout653/X VGND VGND VPWR VPWR fanout646/X sky130_fd_sc_hd__clkdlybuf4s25_1
XFILLER_28_1376 VGND VGND VPWR VPWR sky130_fd_sc_hd__decap_3
Xfanout657 fanout657/A VGND VGND VPWR VPWR fanout657/X sky130_fd_sc_hd__clkdlybuf4s25_1
XFILLER_8_1459 VGND VGND VPWR VPWR sky130_fd_sc_hd__decap_3
X_6117_ _7040_/CLK _6117_/D wire687/A VGND VGND VPWR VPWR _6117_/Q sky130_fd_sc_hd__dfrtp_2
X_3329_ hold882/X _3328_/X _3457_/S VGND VGND VPWR VPWR _6138_/D sky130_fd_sc_hd__mux2_1
XFILLER_24_1229 VGND VGND VPWR VPWR sky130_fd_sc_hd__decap_3
Xfanout668 fanout672/X VGND VGND VPWR VPWR fanout668/X sky130_fd_sc_hd__clkdlybuf4s25_1
XFILLER_63_1278 VGND VGND VPWR VPWR sky130_fd_sc_hd__decap_3
XFILLER_59_869 VGND VGND VPWR VPWR sky130_fd_sc_hd__decap_3
XFILLER_63_1289 VGND VGND VPWR VPWR sky130_fd_sc_hd__decap_3
XFILLER_58_357 VGND VGND VPWR VPWR sky130_fd_sc_hd__decap_3
XFILLER_46_508 VGND VGND VPWR VPWR sky130_fd_sc_hd__decap_3
XFILLER_6_1161 VGND VGND VPWR VPWR sky130_fd_sc_hd__decap_3
X_6048_ hold973/X _6048_/A1 _6048_/S VGND VGND VPWR VPWR _7052_/D sky130_fd_sc_hd__mux2_1
XFILLER_2_1014 VGND VGND VPWR VPWR sky130_fd_sc_hd__decap_3
XFILLER_27_722 VGND VGND VPWR VPWR sky130_fd_sc_hd__decap_3
XFILLER_39_582 VGND VGND VPWR VPWR sky130_fd_sc_hd__decap_3
XFILLER_67_891 VGND VGND VPWR VPWR sky130_fd_sc_hd__decap_3
XFILLER_6_1194 VGND VGND VPWR VPWR sky130_fd_sc_hd__decap_3
XFILLER_2_1058 VGND VGND VPWR VPWR sky130_fd_sc_hd__decap_3
XFILLER_27_788 VGND VGND VPWR VPWR sky130_fd_sc_hd__decap_3
XFILLER_41_202 VGND VGND VPWR VPWR sky130_fd_sc_hd__decap_3
XFILLER_14_427 VGND VGND VPWR VPWR sky130_fd_sc_hd__decap_3
XFILLER_26_298 VGND VGND VPWR VPWR sky130_fd_sc_hd__decap_3
XFILLER_53_46 VGND VGND VPWR VPWR sky130_fd_sc_hd__fill_2
XFILLER_74_1341 VGND VGND VPWR VPWR sky130_fd_sc_hd__decap_3
XFILLER_53_57 VGND VGND VPWR VPWR sky130_fd_sc_hd__decap_3
XFILLER_41_246 VGND VGND VPWR VPWR sky130_fd_sc_hd__decap_3
XFILLER_23_961 VGND VGND VPWR VPWR sky130_fd_sc_hd__decap_3
XFILLER_70_1205 VGND VGND VPWR VPWR sky130_fd_sc_hd__decap_3
XFILLER_35_1325 VGND VGND VPWR VPWR sky130_fd_sc_hd__decap_3
XFILLER_74_1385 VGND VGND VPWR VPWR sky130_fd_sc_hd__decap_3
XFILLER_70_1238 VGND VGND VPWR VPWR sky130_fd_sc_hd__decap_3
XFILLER_35_1369 VGND VGND VPWR VPWR sky130_fd_sc_hd__decap_3
XFILLER_50_791 VGND VGND VPWR VPWR sky130_fd_sc_hd__decap_3
XTAP_TAPCELL_ROW_40_1250 VGND VPWR sky130_fd_sc_hd__tapvpwrvgnd_1
XFILLER_6_626 VGND VGND VPWR VPWR sky130_fd_sc_hd__decap_3
XFILLER_10_699 VGND VGND VPWR VPWR sky130_fd_sc_hd__fill_1
XFILLER_6_659 VGND VGND VPWR VPWR sky130_fd_sc_hd__decap_3
XFILLER_5_169 VGND VGND VPWR VPWR sky130_fd_sc_hd__decap_3
XFILLER_78_21 VGND VGND VPWR VPWR sky130_fd_sc_hd__decap_3
XTAP_TAPCELL_ROW_9_431 VGND VPWR sky130_fd_sc_hd__tapvpwrvgnd_1
XTAP_TAPCELL_ROW_9_442 VGND VPWR sky130_fd_sc_hd__tapvpwrvgnd_1
XFILLER_68_1178 VGND VGND VPWR VPWR sky130_fd_sc_hd__decap_3
XFILLER_78_32 VGND VGND VPWR VPWR sky130_fd_sc_hd__decap_3
XFILLER_2_843 VGND VGND VPWR VPWR sky130_fd_sc_hd__decap_3
XFILLER_1_320 VGND VGND VPWR VPWR sky130_fd_sc_hd__decap_3
XFILLER_46_1421 VGND VGND VPWR VPWR sky130_fd_sc_hd__decap_3
XFILLER_78_65 VGND VGND VPWR VPWR sky130_fd_sc_hd__decap_3
XFILLER_46_1432 VGND VGND VPWR VPWR sky130_fd_sc_hd__decap_3
XFILLER_2_887 VGND VGND VPWR VPWR sky130_fd_sc_hd__decap_3
XFILLER_1_364 VGND VGND VPWR VPWR sky130_fd_sc_hd__decap_3
XTAP_TAPCELL_ROW_38_1190 VGND VPWR sky130_fd_sc_hd__tapvpwrvgnd_1
XFILLER_46_1465 VGND VGND VPWR VPWR sky130_fd_sc_hd__decap_3
XFILLER_77_644 VGND VGND VPWR VPWR sky130_fd_sc_hd__decap_3
XFILLER_42_1329 VGND VGND VPWR VPWR sky130_fd_sc_hd__decap_3
XTAP_TAPCELL_ROW_34_1076 VGND VPWR sky130_fd_sc_hd__tapvpwrvgnd_1
XTAP_TAPCELL_ROW_34_1087 VGND VPWR sky130_fd_sc_hd__tapvpwrvgnd_1
XFILLER_37_508 VGND VGND VPWR VPWR sky130_fd_sc_hd__decap_3
XFILLER_65_817 VGND VGND VPWR VPWR sky130_fd_sc_hd__fill_2
XFILLER_40_1020 VGND VGND VPWR VPWR sky130_fd_sc_hd__decap_3
XFILLER_64_305 VGND VGND VPWR VPWR sky130_fd_sc_hd__decap_3
XFILLER_18_733 VGND VGND VPWR VPWR sky130_fd_sc_hd__decap_3
XFILLER_18_755 VGND VGND VPWR VPWR sky130_fd_sc_hd__fill_1
XFILLER_79_1263 VGND VGND VPWR VPWR sky130_fd_sc_hd__decap_3
XFILLER_75_1105 VGND VGND VPWR VPWR sky130_fd_sc_hd__decap_3
XFILLER_73_872 VGND VGND VPWR VPWR sky130_fd_sc_hd__fill_2
XTAP_TAPCELL_ROW_47_1415 VGND VPWR sky130_fd_sc_hd__tapvpwrvgnd_1
XFILLER_72_360 VGND VGND VPWR VPWR sky130_fd_sc_hd__decap_3
XTAP_TAPCELL_ROW_47_1426 VGND VPWR sky130_fd_sc_hd__tapvpwrvgnd_1
XFILLER_75_1127 VGND VGND VPWR VPWR sky130_fd_sc_hd__decap_3
XFILLER_60_533 VGND VGND VPWR VPWR sky130_fd_sc_hd__decap_3
XFILLER_21_909 VGND VGND VPWR VPWR sky130_fd_sc_hd__decap_3
XFILLER_20_408 VGND VGND VPWR VPWR sky130_fd_sc_hd__decap_3
XFILLER_32_268 VGND VGND VPWR VPWR sky130_fd_sc_hd__decap_3
XFILLER_53_1425 VGND VGND VPWR VPWR sky130_fd_sc_hd__decap_3
XFILLER_13_471 VGND VGND VPWR VPWR sky130_fd_sc_hd__decap_3
XFILLER_9_420 VGND VGND VPWR VPWR sky130_fd_sc_hd__decap_3
XFILLER_41_780 VGND VGND VPWR VPWR sky130_fd_sc_hd__decap_3
XFILLER_14_1409 VGND VGND VPWR VPWR sky130_fd_sc_hd__decap_3
X_3680_ _3693_/C _3678_/Y _3786_/B VGND VGND VPWR VPWR _3680_/Y sky130_fd_sc_hd__o21ai_2
XFILLER_9_475 VGND VGND VPWR VPWR sky130_fd_sc_hd__decap_3
XFILLER_16_1291 VGND VGND VPWR VPWR sky130_fd_sc_hd__decap_3
XFILLER_51_1193 VGND VGND VPWR VPWR sky130_fd_sc_hd__decap_3
X_5350_ _6806_/Q _5104_/B _5350_/S VGND VGND VPWR VPWR _5350_/X sky130_fd_sc_hd__mux2_1
XFILLER_12_1177 VGND VGND VPWR VPWR sky130_fd_sc_hd__decap_3
XFILLER_57_3 VGND VGND VPWR VPWR sky130_fd_sc_hd__decap_3
X_4301_ _4420_/C _4335_/A2 _4300_/X _4267_/X _6491_/Q VGND VGND VPWR VPWR _4301_/X
+ sky130_fd_sc_hd__a32o_2
X_5281_ _6435_/Q _5281_/A2 _5280_/X VGND VGND VPWR VPWR _6435_/D sky130_fd_sc_hd__a21o_2
X_7020_ _7020_/CLK _7020_/D fanout817/X VGND VGND VPWR VPWR _7020_/Q sky130_fd_sc_hd__dfrtp_2
X_4232_ _4316_/B _4232_/B VGND VGND VPWR VPWR _4233_/B sky130_fd_sc_hd__xor2_2
XFILLER_4_62 VGND VGND VPWR VPWR sky130_fd_sc_hd__decap_3
Xclkbuf_leaf_4_clk clkload0/A VGND VGND VPWR VPWR _6858_/CLK sky130_fd_sc_hd__clkbuf_8
XFILLER_60_1418 VGND VGND VPWR VPWR sky130_fd_sc_hd__decap_3
X_4163_ _4318_/A _4163_/B VGND VGND VPWR VPWR _4163_/Y sky130_fd_sc_hd__nand2_2
XFILLER_60_1429 VGND VGND VPWR VPWR sky130_fd_sc_hd__decap_3
X_3114_ _7077_/Q _3114_/B VGND VGND VPWR VPWR _3225_/S sky130_fd_sc_hd__or2_2
XFILLER_3_1301 VGND VGND VPWR VPWR sky130_fd_sc_hd__decap_3
X_4094_ _5512_/A _3717_/A _5609_/A3 _5515_/A1 _6598_/Q VGND VGND VPWR VPWR _4094_/X
+ sky130_fd_sc_hd__a32o_2
XFILLER_23_1251 VGND VGND VPWR VPWR sky130_fd_sc_hd__decap_3
XFILLER_3_1334 VGND VGND VPWR VPWR sky130_fd_sc_hd__decap_3
XFILLER_3_1345 VGND VGND VPWR VPWR sky130_fd_sc_hd__decap_3
XFILLER_67_198 VGND VGND VPWR VPWR sky130_fd_sc_hd__fill_1
XFILLER_23_1284 VGND VGND VPWR VPWR sky130_fd_sc_hd__decap_3
X_3045_ _7066_/Q VGND VGND VPWR VPWR _5749_/A sky130_fd_sc_hd__inv_2
XFILLER_23_1295 VGND VGND VPWR VPWR sky130_fd_sc_hd__decap_3
XFILLER_48_390 VGND VGND VPWR VPWR sky130_fd_sc_hd__decap_3
XFILLER_58_1303 VGND VGND VPWR VPWR sky130_fd_sc_hd__decap_3
XFILLER_3_1378 VGND VGND VPWR VPWR sky130_fd_sc_hd__decap_3
XFILLER_58_1347 VGND VGND VPWR VPWR sky130_fd_sc_hd__decap_3
X_6804_ _7060_/CLK _6804_/D fanout787/X VGND VGND VPWR VPWR _6804_/Q sky130_fd_sc_hd__dfrtp_2
XFILLER_1_1080 VGND VGND VPWR VPWR sky130_fd_sc_hd__decap_3
XFILLER_63_393 VGND VGND VPWR VPWR sky130_fd_sc_hd__decap_3
XFILLER_23_235 VGND VGND VPWR VPWR sky130_fd_sc_hd__decap_3
X_4996_ _6389_/Q _5237_/B _5031_/B1 VGND VGND VPWR VPWR _4996_/Y sky130_fd_sc_hd__a21oi_2
XFILLER_11_419 VGND VGND VPWR VPWR sky130_fd_sc_hd__decap_3
X_6735_ _7054_/CLK _6735_/D load_slew757/X VGND VGND VPWR VPWR _6735_/Q sky130_fd_sc_hd__dfrtp_2
X_3947_ _5517_/B2 _6303_/Q VGND VGND VPWR VPWR _3947_/X sky130_fd_sc_hd__and2b_2
XFILLER_56_1082 VGND VGND VPWR VPWR sky130_fd_sc_hd__fill_1
XFILLER_56_1093 VGND VGND VPWR VPWR sky130_fd_sc_hd__fill_1
X_6666_ _6882_/CLK _6666_/D load_slew662/X VGND VGND VPWR VPWR _6666_/Q sky130_fd_sc_hd__dfrtp_2
XFILLER_31_290 VGND VGND VPWR VPWR sky130_fd_sc_hd__fill_2
XFILLER_20_964 VGND VGND VPWR VPWR sky130_fd_sc_hd__decap_3
X_3878_ _6220_/Q wire77/A _3876_/X _3877_/X VGND VGND VPWR VPWR _6220_/D sky130_fd_sc_hd__o22a_2
XTAP_TAPCELL_ROW_30_970 VGND VPWR sky130_fd_sc_hd__tapvpwrvgnd_1
X_5617_ _5722_/A _5731_/B VGND VGND VPWR VPWR _5694_/C sky130_fd_sc_hd__nor2_2
XFILLER_34_1391 VGND VGND VPWR VPWR sky130_fd_sc_hd__decap_3
XTAP_TAPCELL_ROW_30_981 VGND VPWR sky130_fd_sc_hd__tapvpwrvgnd_1
X_6597_ _6910_/CLK _6597_/D load_slew784/X VGND VGND VPWR VPWR _6597_/Q sky130_fd_sc_hd__dfrtp_2
XFILLER_69_1410 VGND VGND VPWR VPWR sky130_fd_sc_hd__decap_3
XFILLER_30_1244 VGND VGND VPWR VPWR sky130_fd_sc_hd__decap_3
XTAP_TAPCELL_ROW_30_992 VGND VPWR sky130_fd_sc_hd__tapvpwrvgnd_1
X_5548_ _6349_/Q _5564_/A2 _5548_/B1 _5552_/B2 VGND VGND VPWR VPWR _6631_/D sky130_fd_sc_hd__a22o_2
XFILLER_69_1443 VGND VGND VPWR VPWR sky130_fd_sc_hd__decap_3
XFILLER_2_106 VGND VGND VPWR VPWR sky130_fd_sc_hd__decap_3
XFILLER_30_1288 VGND VGND VPWR VPWR sky130_fd_sc_hd__decap_3
XFILLER_65_1307 VGND VGND VPWR VPWR sky130_fd_sc_hd__decap_3
XFILLER_79_909 VGND VGND VPWR VPWR sky130_fd_sc_hd__decap_3
XFILLER_2_139 VGND VGND VPWR VPWR sky130_fd_sc_hd__fill_1
X_5479_ _5479_/A1 _5479_/A2 _4896_/X VGND VGND VPWR VPWR _6591_/D sky130_fd_sc_hd__a21o_2
XFILLER_78_408 VGND VGND VPWR VPWR sky130_fd_sc_hd__decap_3
Xfanout410 _4382_/C1 VGND VGND VPWR VPWR _4734_/C1 sky130_fd_sc_hd__clkdlybuf4s25_1
XFILLER_8_1223 VGND VGND VPWR VPWR sky130_fd_sc_hd__decap_3
Xfanout421 _3098_/X VGND VGND VPWR VPWR _3933_/A sky130_fd_sc_hd__clkdlybuf4s25_1
Xfanout454 _3042_/Y VGND VGND VPWR VPWR _4842_/A sky130_fd_sc_hd__clkdlybuf4s25_1
XFILLER_59_644 VGND VGND VPWR VPWR sky130_fd_sc_hd__decap_3
XFILLER_8_1256 VGND VGND VPWR VPWR sky130_fd_sc_hd__decap_3
XFILLER_48_57 VGND VGND VPWR VPWR sky130_fd_sc_hd__decap_3
XFILLER_8_1267 VGND VGND VPWR VPWR sky130_fd_sc_hd__decap_3
Xfanout465 _5358_/C VGND VGND VPWR VPWR _4771_/C1 sky130_fd_sc_hd__clkdlybuf4s25_1
Xfanout476 _4680_/C1 VGND VGND VPWR VPWR _4647_/A1 sky130_fd_sc_hd__clkdlybuf4s25_1
XFILLER_24_1037 VGND VGND VPWR VPWR sky130_fd_sc_hd__fill_2
XFILLER_63_1086 VGND VGND VPWR VPWR sky130_fd_sc_hd__decap_3
Xfanout487 fanout488/X VGND VGND VPWR VPWR _4381_/C1 sky130_fd_sc_hd__clkdlybuf4s25_1
Xfanout498 _4832_/A2 VGND VGND VPWR VPWR _4847_/A2 sky130_fd_sc_hd__clkdlybuf4s25_1
XFILLER_46_305 VGND VGND VPWR VPWR sky130_fd_sc_hd__decap_3
XFILLER_41_1340 VGND VGND VPWR VPWR sky130_fd_sc_hd__decap_3
XFILLER_41_1351 VGND VGND VPWR VPWR sky130_fd_sc_hd__decap_3
XFILLER_73_113 VGND VGND VPWR VPWR sky130_fd_sc_hd__decap_3
XFILLER_64_12 VGND VGND VPWR VPWR sky130_fd_sc_hd__decap_3
XFILLER_41_1384 VGND VGND VPWR VPWR sky130_fd_sc_hd__decap_3
XFILLER_27_541 VGND VGND VPWR VPWR sky130_fd_sc_hd__decap_3
XFILLER_76_1403 VGND VGND VPWR VPWR sky130_fd_sc_hd__decap_3
XFILLER_55_861 VGND VGND VPWR VPWR sky130_fd_sc_hd__decap_3
XFILLER_15_714 VGND VGND VPWR VPWR sky130_fd_sc_hd__decap_3
XFILLER_76_1447 VGND VGND VPWR VPWR sky130_fd_sc_hd__decap_3
XFILLER_55_894 VGND VGND VPWR VPWR sky130_fd_sc_hd__fill_2
XFILLER_14_224 VGND VGND VPWR VPWR sky130_fd_sc_hd__fill_2
XFILLER_42_533 VGND VGND VPWR VPWR sky130_fd_sc_hd__fill_2
XFILLER_70_853 VGND VGND VPWR VPWR sky130_fd_sc_hd__decap_3
XFILLER_9_18 VGND VGND VPWR VPWR sky130_fd_sc_hd__decap_3
XFILLER_14_279 VGND VGND VPWR VPWR sky130_fd_sc_hd__decap_3
XFILLER_30_728 VGND VGND VPWR VPWR sky130_fd_sc_hd__decap_3
XTAP_TAPCELL_ROW_42_1301 VGND VPWR sky130_fd_sc_hd__tapvpwrvgnd_1
XFILLER_74_1182 VGND VGND VPWR VPWR sky130_fd_sc_hd__decap_3
Xfanout50 wire52/X VGND VGND VPWR VPWR _4849_/S sky130_fd_sc_hd__clkdlybuf4s25_1
XFILLER_80_44 VGND VGND VPWR VPWR sky130_fd_sc_hd__decap_3
XFILLER_23_791 VGND VGND VPWR VPWR sky130_fd_sc_hd__decap_3
Xfanout61 wire63/X VGND VGND VPWR VPWR _4863_/A2 sky130_fd_sc_hd__clkdlybuf4s25_1
Xfanout72 _3490_/X VGND VGND VPWR VPWR _4092_/C1 sky130_fd_sc_hd__clkdlybuf4s25_1
XFILLER_10_430 VGND VGND VPWR VPWR sky130_fd_sc_hd__decap_3
XFILLER_35_1177 VGND VGND VPWR VPWR sky130_fd_sc_hd__fill_1
XFILLER_80_88 VGND VGND VPWR VPWR sky130_fd_sc_hd__decap_3
XFILLER_13_1431 VGND VGND VPWR VPWR sky130_fd_sc_hd__decap_3
XFILLER_6_467 VGND VGND VPWR VPWR sky130_fd_sc_hd__fill_2
XFILLER_6_489 VGND VGND VPWR VPWR sky130_fd_sc_hd__decap_3
XFILLER_43_9 VGND VGND VPWR VPWR sky130_fd_sc_hd__decap_3
XFILLER_9_1009 VGND VGND VPWR VPWR sky130_fd_sc_hd__decap_3
XTAP_TAPCELL_ROW_36_1127 VGND VPWR sky130_fd_sc_hd__tapvpwrvgnd_1
XFILLER_2_651 VGND VGND VPWR VPWR sky130_fd_sc_hd__decap_3
Xload_slew805 fanout804/X VGND VGND VPWR VPWR load_slew805/X sky130_fd_sc_hd__clkbuf_2
XTAP_TAPCELL_ROW_36_1138 VGND VPWR sky130_fd_sc_hd__tapvpwrvgnd_1
XTAP_TAPCELL_ROW_36_1149 VGND VPWR sky130_fd_sc_hd__tapvpwrvgnd_1
XFILLER_1_161 VGND VGND VPWR VPWR sky130_fd_sc_hd__decap_3
XFILLER_2_684 VGND VGND VPWR VPWR sky130_fd_sc_hd__decap_3
XFILLER_1_172 VGND VGND VPWR VPWR sky130_fd_sc_hd__decap_3
XFILLER_46_1273 VGND VGND VPWR VPWR sky130_fd_sc_hd__decap_3
XFILLER_77_452 VGND VGND VPWR VPWR sky130_fd_sc_hd__decap_3
XFILLER_49_143 VGND VGND VPWR VPWR sky130_fd_sc_hd__decap_3
XFILLER_37_305 VGND VGND VPWR VPWR sky130_fd_sc_hd__decap_3
XFILLER_38_828 VGND VGND VPWR VPWR sky130_fd_sc_hd__decap_3
XFILLER_49_187 VGND VGND VPWR VPWR sky130_fd_sc_hd__decap_3
XFILLER_20_1424 VGND VGND VPWR VPWR sky130_fd_sc_hd__decap_3
XFILLER_53_809 VGND VGND VPWR VPWR sky130_fd_sc_hd__decap_3
XFILLER_20_1435 VGND VGND VPWR VPWR sky130_fd_sc_hd__decap_3
XFILLER_18_552 VGND VGND VPWR VPWR sky130_fd_sc_hd__decap_3
XFILLER_46_861 VGND VGND VPWR VPWR sky130_fd_sc_hd__decap_3
XFILLER_80_617 VGND VGND VPWR VPWR sky130_fd_sc_hd__decap_3
XFILLER_20_1468 VGND VGND VPWR VPWR sky130_fd_sc_hd__fill_1
XFILLER_46_872 VGND VGND VPWR VPWR sky130_fd_sc_hd__decap_3
XFILLER_45_360 VGND VGND VPWR VPWR sky130_fd_sc_hd__decap_3
XFILLER_79_1082 VGND VGND VPWR VPWR sky130_fd_sc_hd__decap_3
XFILLER_33_511 VGND VGND VPWR VPWR sky130_fd_sc_hd__decap_3
X_4850_ _4487_/A _4355_/A _4277_/X _4842_/X _6585_/Q VGND VGND VPWR VPWR _4850_/X
+ sky130_fd_sc_hd__a32o_2
XFILLER_33_544 VGND VGND VPWR VPWR sky130_fd_sc_hd__decap_3
XFILLER_61_853 VGND VGND VPWR VPWR sky130_fd_sc_hd__fill_2
XFILLER_18_1320 VGND VGND VPWR VPWR sky130_fd_sc_hd__decap_3
XFILLER_33_577 VGND VGND VPWR VPWR sky130_fd_sc_hd__decap_3
X_3801_ _3927_/A_N _6298_/Q VGND VGND VPWR VPWR _3801_/X sky130_fd_sc_hd__and2b_2
XFILLER_60_363 VGND VGND VPWR VPWR sky130_fd_sc_hd__fill_1
XFILLER_61_897 VGND VGND VPWR VPWR sky130_fd_sc_hd__decap_3
X_4781_ _6913_/Q _4781_/A2 _4779_/X _4780_/X VGND VGND VPWR VPWR _4781_/X sky130_fd_sc_hd__a211o_2
XFILLER_18_1353 VGND VGND VPWR VPWR sky130_fd_sc_hd__decap_3
XFILLER_53_1233 VGND VGND VPWR VPWR sky130_fd_sc_hd__decap_3
XFILLER_20_238 VGND VGND VPWR VPWR sky130_fd_sc_hd__decap_3
X_6520_ _6888_/CLK _6520_/D load_slew705/X VGND VGND VPWR VPWR _6520_/Q sky130_fd_sc_hd__dfrtp_2
XFILLER_14_1217 VGND VGND VPWR VPWR sky130_fd_sc_hd__decap_3
X_3732_ _3960_/A _6304_/Q VGND VGND VPWR VPWR _3732_/X sky130_fd_sc_hd__and2b_2
XFILLER_53_1266 VGND VGND VPWR VPWR sky130_fd_sc_hd__decap_3
XFILLER_18_1397 VGND VGND VPWR VPWR sky130_fd_sc_hd__decap_3
X_6451_ clkload7/A _6451_/D wire639/X VGND VGND VPWR VPWR _6451_/Q sky130_fd_sc_hd__dfrtp_2
X_3663_ _3663_/A _3755_/A VGND VGND VPWR VPWR _3786_/A sky130_fd_sc_hd__xnor2_2
Xclkload20 _6889_/CLK VGND VGND VPWR VPWR clkload20/X sky130_fd_sc_hd__clkbuf_8
XTAP_TAPCELL_ROW_11_480 VGND VPWR sky130_fd_sc_hd__tapvpwrvgnd_1
X_5402_ _5402_/A1 _5477_/A2 _4448_/X VGND VGND VPWR VPWR _6514_/D sky130_fd_sc_hd__a21o_2
Xclkload31 _7000_/CLK VGND VGND VPWR VPWR clkload31/X sky130_fd_sc_hd__clkbuf_8
XTAP_TAPCELL_ROW_11_491 VGND VPWR sky130_fd_sc_hd__tapvpwrvgnd_1
Xclkload42 _6988_/CLK VGND VGND VPWR VPWR clkload42/X sky130_fd_sc_hd__clkbuf_4
Xclkload53 _7063_/CLK VGND VGND VPWR VPWR clkload53/X sky130_fd_sc_hd__clkbuf_8
X_6382_ _6752_/CLK _6382_/D load_slew669/X VGND VGND VPWR VPWR _6382_/Q sky130_fd_sc_hd__dfrtp_2
X_3594_ _6229_/Q wire431/A _5607_/A2 _6285_/Q VGND VGND VPWR VPWR _3594_/X sky130_fd_sc_hd__a22o_2
X_5333_ _6459_/Q _5332_/X _5333_/S VGND VGND VPWR VPWR _6459_/D sky130_fd_sc_hd__mux2_1
XFILLER_47_1026 VGND VGND VPWR VPWR sky130_fd_sc_hd__decap_3
X_5264_ _5338_/S _5264_/B VGND VGND VPWR VPWR _5264_/Y sky130_fd_sc_hd__nand2_2
XFILLER_29_1460 VGND VGND VPWR VPWR sky130_fd_sc_hd__decap_3
X_7003_ _7027_/CLK _7003_/D fanout846/X VGND VGND VPWR VPWR _7003_/Q sky130_fd_sc_hd__dfrtp_2
XFILLER_25_1313 VGND VGND VPWR VPWR sky130_fd_sc_hd__decap_3
X_4215_ _6306_/Q _4861_/A2 _3246_/X _4861_/B2 VGND VGND VPWR VPWR _4215_/X sky130_fd_sc_hd__a22o_2
XFILLER_64_1362 VGND VGND VPWR VPWR sky130_fd_sc_hd__decap_3
XFILLER_64_1373 VGND VGND VPWR VPWR sky130_fd_sc_hd__decap_3
XFILLER_69_953 VGND VGND VPWR VPWR sky130_fd_sc_hd__decap_3
X_5195_ _5194_/Y _5122_/X _5281_/A2 _6406_/Q VGND VGND VPWR VPWR _6406_/D sky130_fd_sc_hd__a2bb2o_2
XFILLER_5_1407 VGND VGND VPWR VPWR sky130_fd_sc_hd__decap_3
XFILLER_60_1226 VGND VGND VPWR VPWR sky130_fd_sc_hd__decap_3
XFILLER_25_1357 VGND VGND VPWR VPWR sky130_fd_sc_hd__decap_3
XFILLER_69_986 VGND VGND VPWR VPWR sky130_fd_sc_hd__decap_3
X_4146_ _6275_/Q _4750_/A2 _3232_/X _4750_/B2 VGND VGND VPWR VPWR _4146_/X sky130_fd_sc_hd__a22o_2
XFILLER_60_1259 VGND VGND VPWR VPWR sky130_fd_sc_hd__fill_1
XFILLER_18_49 VGND VGND VPWR VPWR sky130_fd_sc_hd__decap_3
XFILLER_55_113 VGND VGND VPWR VPWR sky130_fd_sc_hd__decap_3
XFILLER_3_1142 VGND VGND VPWR VPWR sky130_fd_sc_hd__decap_3
X_4077_ _4747_/A _4077_/B VGND VGND VPWR VPWR _4077_/Y sky130_fd_sc_hd__nor2_2
XFILLER_3_1175 VGND VGND VPWR VPWR sky130_fd_sc_hd__fill_1
XFILLER_3_1186 VGND VGND VPWR VPWR sky130_fd_sc_hd__decap_3
XFILLER_36_382 VGND VGND VPWR VPWR sky130_fd_sc_hd__decap_3
XFILLER_52_831 VGND VGND VPWR VPWR sky130_fd_sc_hd__fill_1
XFILLER_58_1144 VGND VGND VPWR VPWR sky130_fd_sc_hd__decap_3
XFILLER_19_1117 VGND VGND VPWR VPWR sky130_fd_sc_hd__decap_3
XFILLER_63_190 VGND VGND VPWR VPWR sky130_fd_sc_hd__decap_3
XFILLER_52_875 VGND VGND VPWR VPWR sky130_fd_sc_hd__decap_3
XFILLER_12_717 VGND VGND VPWR VPWR sky130_fd_sc_hd__fill_2
XFILLER_24_577 VGND VGND VPWR VPWR sky130_fd_sc_hd__decap_3
XFILLER_51_363 VGND VGND VPWR VPWR sky130_fd_sc_hd__decap_3
XFILLER_71_1322 VGND VGND VPWR VPWR sky130_fd_sc_hd__decap_3
X_4979_ _6451_/Q _6669_/Q VGND VGND VPWR VPWR _4980_/B sky130_fd_sc_hd__xor2_2
XFILLER_36_1453 VGND VGND VPWR VPWR sky130_fd_sc_hd__decap_3
XFILLER_51_396 VGND VGND VPWR VPWR sky130_fd_sc_hd__decap_3
XFILLER_11_238 VGND VGND VPWR VPWR sky130_fd_sc_hd__fill_2
XFILLER_32_1306 VGND VGND VPWR VPWR sky130_fd_sc_hd__decap_3
XFILLER_71_1366 VGND VGND VPWR VPWR sky130_fd_sc_hd__decap_3
XFILLER_32_1317 VGND VGND VPWR VPWR sky130_fd_sc_hd__decap_3
X_6718_ _7009_/CLK _6718_/D fanout765/X VGND VGND VPWR VPWR _6718_/Q sky130_fd_sc_hd__dfrtp_2
XTAP_TAPCELL_ROW_22_767 VGND VPWR sky130_fd_sc_hd__tapvpwrvgnd_1
Xclkload3 clkload3/A VGND VGND VPWR VPWR clkload3/X sky130_fd_sc_hd__clkbuf_8
Xwire129 _5357_/S VGND VGND VPWR VPWR _5355_/S sky130_fd_sc_hd__buf_4
XTAP_TAPCELL_ROW_22_778 VGND VPWR sky130_fd_sc_hd__tapvpwrvgnd_1
XFILLER_71_1399 VGND VGND VPWR VPWR sky130_fd_sc_hd__fill_1
X_6649_ _6990_/CLK _6649_/D load_slew748/X VGND VGND VPWR VPWR _6649_/Q sky130_fd_sc_hd__dfrtp_2
XTAP_TAPCELL_ROW_76_2164 VGND VPWR sky130_fd_sc_hd__tapvpwrvgnd_1
XTAP_TAPCELL_ROW_76_2175 VGND VPWR sky130_fd_sc_hd__tapvpwrvgnd_1
XTAP_TAPCELL_ROW_76_2186 VGND VPWR sky130_fd_sc_hd__tapvpwrvgnd_1
XFILLER_3_426 VGND VGND VPWR VPWR sky130_fd_sc_hd__decap_3
XFILLER_69_1251 VGND VGND VPWR VPWR sky130_fd_sc_hd__decap_3
XFILLER_69_1284 VGND VGND VPWR VPWR sky130_fd_sc_hd__decap_3
XFILLER_69_1295 VGND VGND VPWR VPWR sky130_fd_sc_hd__decap_3
XFILLER_43_1413 VGND VGND VPWR VPWR sky130_fd_sc_hd__decap_3
Xfanout240 _5359_/X VGND VGND VPWR VPWR _5479_/A2 sky130_fd_sc_hd__clkdlybuf4s25_1
XTAP_TAPCELL_ROW_31_1002 VGND VPWR sky130_fd_sc_hd__tapvpwrvgnd_1
Xfanout251 _5453_/A2 VGND VGND VPWR VPWR _5485_/A2 sky130_fd_sc_hd__clkdlybuf4s25_1
XTAP_TAPCELL_ROW_31_1013 VGND VPWR sky130_fd_sc_hd__tapvpwrvgnd_1
XFILLER_43_1446 VGND VGND VPWR VPWR sky130_fd_sc_hd__decap_3
XFILLER_59_452 VGND VGND VPWR VPWR sky130_fd_sc_hd__decap_3
XFILLER_43_1457 VGND VGND VPWR VPWR sky130_fd_sc_hd__decap_3
Xfanout284 _4833_/A2 VGND VGND VPWR VPWR _4790_/A2 sky130_fd_sc_hd__clkdlybuf4s25_1
XFILLER_75_33 VGND VGND VPWR VPWR sky130_fd_sc_hd__decap_3
XFILLER_74_411 VGND VGND VPWR VPWR sky130_fd_sc_hd__decap_3
XFILLER_75_44 VGND VGND VPWR VPWR sky130_fd_sc_hd__decap_3
XFILLER_19_327 VGND VGND VPWR VPWR sky130_fd_sc_hd__decap_3
XFILLER_75_967 VGND VGND VPWR VPWR sky130_fd_sc_hd__decap_3
XFILLER_76_1200 VGND VGND VPWR VPWR sky130_fd_sc_hd__decap_3
XFILLER_28_872 VGND VGND VPWR VPWR sky130_fd_sc_hd__decap_3
XFILLER_76_1211 VGND VGND VPWR VPWR sky130_fd_sc_hd__decap_3
XFILLER_46_179 VGND VGND VPWR VPWR sky130_fd_sc_hd__fill_1
XFILLER_15_522 VGND VGND VPWR VPWR sky130_fd_sc_hd__decap_3
XFILLER_76_1244 VGND VGND VPWR VPWR sky130_fd_sc_hd__decap_3
XFILLER_27_393 VGND VGND VPWR VPWR sky130_fd_sc_hd__decap_3
XFILLER_42_330 VGND VGND VPWR VPWR sky130_fd_sc_hd__decap_3
XFILLER_54_190 VGND VGND VPWR VPWR sky130_fd_sc_hd__decap_3
XFILLER_76_1288 VGND VGND VPWR VPWR sky130_fd_sc_hd__decap_3
XFILLER_37_1239 VGND VGND VPWR VPWR sky130_fd_sc_hd__decap_3
XFILLER_15_588 VGND VGND VPWR VPWR sky130_fd_sc_hd__decap_3
XFILLER_42_363 VGND VGND VPWR VPWR sky130_fd_sc_hd__fill_1
XFILLER_43_897 VGND VGND VPWR VPWR sky130_fd_sc_hd__decap_3
XFILLER_70_683 VGND VGND VPWR VPWR sky130_fd_sc_hd__decap_3
XFILLER_42_374 VGND VGND VPWR VPWR sky130_fd_sc_hd__decap_3
XTAP_TAPCELL_ROW_65_1890 VGND VPWR sky130_fd_sc_hd__tapvpwrvgnd_1
XFILLER_24_81 VGND VGND VPWR VPWR sky130_fd_sc_hd__decap_3
XFILLER_50_1406 VGND VGND VPWR VPWR sky130_fd_sc_hd__decap_3
XTAP_TAPCELL_ROW_61_1776 VGND VPWR sky130_fd_sc_hd__tapvpwrvgnd_1
XTAP_TAPCELL_ROW_61_1787 VGND VPWR sky130_fd_sc_hd__tapvpwrvgnd_1
XFILLER_11_772 VGND VGND VPWR VPWR sky130_fd_sc_hd__decap_3
XTAP_TAPCELL_ROW_61_1798 VGND VPWR sky130_fd_sc_hd__tapvpwrvgnd_1
XFILLER_11_783 VGND VGND VPWR VPWR sky130_fd_sc_hd__fill_1
Xwire641 wire641/A VGND VGND VPWR VPWR wire641/X sky130_fd_sc_hd__clkbuf_4
Xwire652 wire652/A VGND VGND VPWR VPWR wire652/X sky130_fd_sc_hd__clkbuf_4
XFILLER_6_231 VGND VGND VPWR VPWR sky130_fd_sc_hd__fill_2
XFILLER_10_293 VGND VGND VPWR VPWR sky130_fd_sc_hd__fill_2
XFILLER_7_765 VGND VGND VPWR VPWR sky130_fd_sc_hd__decap_3
XFILLER_6_253 VGND VGND VPWR VPWR sky130_fd_sc_hd__decap_3
XFILLER_13_1272 VGND VGND VPWR VPWR sky130_fd_sc_hd__decap_3
XFILLER_40_91 VGND VGND VPWR VPWR sky130_fd_sc_hd__decap_3
XFILLER_48_1335 VGND VGND VPWR VPWR sky130_fd_sc_hd__decap_3
XFILLER_41_6 VGND VGND VPWR VPWR sky130_fd_sc_hd__decap_3
XFILLER_3_971 VGND VGND VPWR VPWR sky130_fd_sc_hd__decap_3
XFILLER_48_1368 VGND VGND VPWR VPWR sky130_fd_sc_hd__decap_3
XFILLER_48_1379 VGND VGND VPWR VPWR sky130_fd_sc_hd__decap_3
XFILLER_3_993 VGND VGND VPWR VPWR sky130_fd_sc_hd__decap_3
XFILLER_66_901 VGND VGND VPWR VPWR sky130_fd_sc_hd__decap_3
Xload_slew679 fanout678/X VGND VGND VPWR VPWR load_slew679/X sky130_fd_sc_hd__clkbuf_4
X_4000_ _3350_/X _4080_/A2 _4080_/B1 _6872_/Q _4080_/C1 VGND VGND VPWR VPWR _4000_/X
+ sky130_fd_sc_hd__a221o_2
XFILLER_78_783 VGND VGND VPWR VPWR sky130_fd_sc_hd__decap_3
XFILLER_77_271 VGND VGND VPWR VPWR sky130_fd_sc_hd__fill_1
XFILLER_1_30 VGND VGND VPWR VPWR sky130_fd_sc_hd__decap_3
XFILLER_65_433 VGND VGND VPWR VPWR sky130_fd_sc_hd__decap_3
XFILLER_66_956 VGND VGND VPWR VPWR sky130_fd_sc_hd__decap_3
XFILLER_1_63 VGND VGND VPWR VPWR sky130_fd_sc_hd__decap_3
XFILLER_4_1462 VGND VGND VPWR VPWR sky130_fd_sc_hd__decap_3
XFILLER_0_1304 VGND VGND VPWR VPWR sky130_fd_sc_hd__decap_3
XFILLER_53_617 VGND VGND VPWR VPWR sky130_fd_sc_hd__decap_3
XFILLER_1_96 VGND VGND VPWR VPWR sky130_fd_sc_hd__decap_3
XFILLER_20_1243 VGND VGND VPWR VPWR sky130_fd_sc_hd__decap_3
XFILLER_0_1326 VGND VGND VPWR VPWR sky130_fd_sc_hd__decap_3
X_5951_ _5951_/A0 _5951_/A1 _5975_/S VGND VGND VPWR VPWR _6955_/D sky130_fd_sc_hd__mux2_1
XFILLER_59_1431 VGND VGND VPWR VPWR sky130_fd_sc_hd__decap_3
XFILLER_18_371 VGND VGND VPWR VPWR sky130_fd_sc_hd__fill_1
XFILLER_20_1276 VGND VGND VPWR VPWR sky130_fd_sc_hd__decap_3
XFILLER_34_831 VGND VGND VPWR VPWR sky130_fd_sc_hd__decap_3
XFILLER_52_127 VGND VGND VPWR VPWR sky130_fd_sc_hd__decap_3
XFILLER_0_1348 VGND VGND VPWR VPWR sky130_fd_sc_hd__decap_3
X_4902_ _6440_/Q _6658_/Q VGND VGND VPWR VPWR _4903_/B sky130_fd_sc_hd__xor2_2
XFILLER_80_469 VGND VGND VPWR VPWR sky130_fd_sc_hd__decap_3
X_5882_ _5909_/A0 _5882_/A1 _5887_/S VGND VGND VPWR VPWR _6892_/D sky130_fd_sc_hd__mux2_1
XFILLER_34_875 VGND VGND VPWR VPWR sky130_fd_sc_hd__decap_3
XFILLER_55_1328 VGND VGND VPWR VPWR sky130_fd_sc_hd__decap_3
XFILLER_21_503 VGND VGND VPWR VPWR sky130_fd_sc_hd__fill_1
X_4833_ _6920_/Q _4833_/A2 _4833_/B1 _4832_/X VGND VGND VPWR VPWR _4833_/X sky130_fd_sc_hd__a211o_2
X_4764_ _4760_/Y _4761_/X _4763_/Y _4558_/A VGND VGND VPWR VPWR _4764_/X sky130_fd_sc_hd__o211a_2
XFILLER_14_1025 VGND VGND VPWR VPWR sky130_fd_sc_hd__decap_3
X_6503_ _6905_/CLK _6503_/D wire738/X VGND VGND VPWR VPWR _6503_/Q sky130_fd_sc_hd__dfrtp_2
X_3715_ _4008_/A _4547_/B VGND VGND VPWR VPWR _4169_/S sky130_fd_sc_hd__nor2_4
XFILLER_14_1058 VGND VGND VPWR VPWR sky130_fd_sc_hd__decap_3
X_4695_ _6556_/Q _4665_/X _4817_/A1 VGND VGND VPWR VPWR _4695_/X sky130_fd_sc_hd__a21o_2
X_6434_ _6772_/CLK _6434_/D load_slew825/X VGND VGND VPWR VPWR _6434_/Q sky130_fd_sc_hd__dfrtp_2
X_3646_ _3646_/A _3646_/B VGND VGND VPWR VPWR _3648_/B sky130_fd_sc_hd__xnor2_2
XFILLER_31_1372 VGND VGND VPWR VPWR sky130_fd_sc_hd__decap_3
X_6365_ _7054_/CLK _6365_/D load_slew757/X VGND VGND VPWR VPWR _6365_/Q sky130_fd_sc_hd__dfrtp_2
X_3577_ _3576_/B _3576_/C _3670_/A VGND VGND VPWR VPWR _3579_/C sky130_fd_sc_hd__a21o_2
XFILLER_66_1424 VGND VGND VPWR VPWR sky130_fd_sc_hd__decap_3
XFILLER_66_1435 VGND VGND VPWR VPWR sky130_fd_sc_hd__decap_3
X_5316_ _6789_/Q _4980_/B _5332_/S VGND VGND VPWR VPWR _5316_/X sky130_fd_sc_hd__mux2_1
XTAP_TAPCELL_ROW_71_2050 VGND VPWR sky130_fd_sc_hd__tapvpwrvgnd_1
XFILLER_27_1419 VGND VGND VPWR VPWR sky130_fd_sc_hd__decap_3
X_6296_ _7072_/CLK _6296_/D load_slew684/X VGND VGND VPWR VPWR _6296_/Q sky130_fd_sc_hd__dfrtp_2
XFILLER_66_1468 VGND VGND VPWR VPWR sky130_fd_sc_hd__fill_1
XFILLER_9_1340 VGND VGND VPWR VPWR sky130_fd_sc_hd__decap_3
X_5247_ _6762_/Q _5326_/S _5327_/S _5246_/Y VGND VGND VPWR VPWR _5247_/X sky130_fd_sc_hd__o211a_2
XFILLER_9_1351 VGND VGND VPWR VPWR sky130_fd_sc_hd__decap_3
XFILLER_64_1170 VGND VGND VPWR VPWR sky130_fd_sc_hd__decap_3
XFILLER_5_1204 VGND VGND VPWR VPWR sky130_fd_sc_hd__decap_3
XFILLER_25_1132 VGND VGND VPWR VPWR sky130_fd_sc_hd__decap_3
XFILLER_9_1384 VGND VGND VPWR VPWR sky130_fd_sc_hd__decap_3
XFILLER_29_603 VGND VGND VPWR VPWR sky130_fd_sc_hd__fill_1
XFILLER_25_1154 VGND VGND VPWR VPWR sky130_fd_sc_hd__fill_1
X_5178_ _6736_/Q _5178_/B VGND VGND VPWR VPWR _5178_/X sky130_fd_sc_hd__or2_2
XFILLER_28_102 VGND VGND VPWR VPWR sky130_fd_sc_hd__decap_3
XFILLER_21_1007 VGND VGND VPWR VPWR sky130_fd_sc_hd__fill_1
XFILLER_5_1248 VGND VGND VPWR VPWR sky130_fd_sc_hd__decap_3
XFILLER_29_658 VGND VGND VPWR VPWR sky130_fd_sc_hd__decap_3
X_4129_ _4302_/A _4293_/A VGND VGND VPWR VPWR _4132_/A sky130_fd_sc_hd__xnor2_2
XTAP_TAPCELL_ROW_3_267 VGND VPWR sky130_fd_sc_hd__tapvpwrvgnd_1
XTAP_TAPCELL_ROW_3_278 VGND VPWR sky130_fd_sc_hd__tapvpwrvgnd_1
XTAP_TAPCELL_ROW_3_289 VGND VPWR sky130_fd_sc_hd__tapvpwrvgnd_1
XFILLER_56_488 VGND VGND VPWR VPWR sky130_fd_sc_hd__decap_3
XTAP_TAPCELL_ROW_80_2308 VGND VPWR sky130_fd_sc_hd__tapvpwrvgnd_1
XTAP_TAPCELL_ROW_80_2319 VGND VPWR sky130_fd_sc_hd__tapvpwrvgnd_1
XFILLER_73_1428 VGND VGND VPWR VPWR sky130_fd_sc_hd__decap_3
XFILLER_12_503 VGND VGND VPWR VPWR sky130_fd_sc_hd__decap_3
XFILLER_24_363 VGND VGND VPWR VPWR sky130_fd_sc_hd__fill_1
XFILLER_24_374 VGND VGND VPWR VPWR sky130_fd_sc_hd__decap_3
XFILLER_71_1141 VGND VGND VPWR VPWR sky130_fd_sc_hd__decap_3
XFILLER_12_558 VGND VGND VPWR VPWR sky130_fd_sc_hd__decap_3
XFILLER_8_507 VGND VGND VPWR VPWR sky130_fd_sc_hd__decap_3
XFILLER_36_1261 VGND VGND VPWR VPWR sky130_fd_sc_hd__decap_3
XFILLER_61_57 VGND VGND VPWR VPWR sky130_fd_sc_hd__fill_2
XTAP_TAPCELL_ROW_78_2226 VGND VPWR sky130_fd_sc_hd__tapvpwrvgnd_1
XFILLER_71_1174 VGND VGND VPWR VPWR sky130_fd_sc_hd__fill_2
XFILLER_32_1125 VGND VGND VPWR VPWR sky130_fd_sc_hd__fill_2
XFILLER_36_1294 VGND VGND VPWR VPWR sky130_fd_sc_hd__decap_3
XTAP_TAPCELL_ROW_78_2237 VGND VPWR sky130_fd_sc_hd__tapvpwrvgnd_1
XFILLER_10_1412 VGND VGND VPWR VPWR sky130_fd_sc_hd__decap_3
XFILLER_3_201 VGND VGND VPWR VPWR sky130_fd_sc_hd__fill_2
XFILLER_10_1456 VGND VGND VPWR VPWR sky130_fd_sc_hd__decap_3
XFILLER_4_757 VGND VGND VPWR VPWR sky130_fd_sc_hd__decap_3
XFILLER_3_245 VGND VGND VPWR VPWR sky130_fd_sc_hd__decap_3
XFILLER_79_514 VGND VGND VPWR VPWR sky130_fd_sc_hd__decap_3
XFILLER_10_94 VGND VGND VPWR VPWR sky130_fd_sc_hd__decap_3
XFILLER_47_1390 VGND VGND VPWR VPWR sky130_fd_sc_hd__decap_3
XFILLER_0_974 VGND VGND VPWR VPWR sky130_fd_sc_hd__decap_3
XFILLER_47_400 VGND VGND VPWR VPWR sky130_fd_sc_hd__decap_3
XFILLER_0_996 VGND VGND VPWR VPWR sky130_fd_sc_hd__decap_3
XFILLER_43_1254 VGND VGND VPWR VPWR sky130_fd_sc_hd__decap_3
XFILLER_43_1287 VGND VGND VPWR VPWR sky130_fd_sc_hd__fill_1
XFILLER_78_1306 VGND VGND VPWR VPWR sky130_fd_sc_hd__decap_3
XFILLER_43_1298 VGND VGND VPWR VPWR sky130_fd_sc_hd__decap_3
XTAP_TAPCELL_ROW_50_1488 VGND VPWR sky130_fd_sc_hd__tapvpwrvgnd_1
XFILLER_78_1317 VGND VGND VPWR VPWR sky130_fd_sc_hd__decap_3
XFILLER_75_764 VGND VGND VPWR VPWR sky130_fd_sc_hd__decap_3
XFILLER_19_146 VGND VGND VPWR VPWR sky130_fd_sc_hd__decap_3
XTAP_TAPCELL_ROW_50_1499 VGND VPWR sky130_fd_sc_hd__tapvpwrvgnd_1
XFILLER_19_157 VGND VGND VPWR VPWR sky130_fd_sc_hd__decap_3
XFILLER_35_617 VGND VGND VPWR VPWR sky130_fd_sc_hd__decap_3
XFILLER_47_499 VGND VGND VPWR VPWR sky130_fd_sc_hd__decap_3
XTAP_TAPCELL_ROW_67_1930 VGND VPWR sky130_fd_sc_hd__tapvpwrvgnd_1
XTAP_TAPCELL_ROW_67_1941 VGND VPWR sky130_fd_sc_hd__tapvpwrvgnd_1
XFILLER_76_1030 VGND VGND VPWR VPWR sky130_fd_sc_hd__decap_3
XTAP_TAPCELL_ROW_67_1952 VGND VPWR sky130_fd_sc_hd__tapvpwrvgnd_1
XFILLER_50_609 VGND VGND VPWR VPWR sky130_fd_sc_hd__fill_1
XFILLER_43_650 VGND VGND VPWR VPWR sky130_fd_sc_hd__decap_3
XFILLER_16_875 VGND VGND VPWR VPWR sky130_fd_sc_hd__fill_2
XTAP_TAPCELL_ROW_63_1827 VGND VPWR sky130_fd_sc_hd__tapvpwrvgnd_1
XFILLER_15_363 VGND VGND VPWR VPWR sky130_fd_sc_hd__decap_3
XFILLER_76_1085 VGND VGND VPWR VPWR sky130_fd_sc_hd__decap_3
XTAP_TAPCELL_ROW_26_870 VGND VPWR sky130_fd_sc_hd__tapvpwrvgnd_1
XTAP_TAPCELL_ROW_63_1838 VGND VPWR sky130_fd_sc_hd__tapvpwrvgnd_1
XFILLER_35_91 VGND VGND VPWR VPWR sky130_fd_sc_hd__decap_3
XTAP_TAPCELL_ROW_63_1849 VGND VPWR sky130_fd_sc_hd__tapvpwrvgnd_1
XFILLER_76_1096 VGND VGND VPWR VPWR sky130_fd_sc_hd__decap_3
XFILLER_15_385 VGND VGND VPWR VPWR sky130_fd_sc_hd__decap_3
XTAP_TAPCELL_ROW_26_881 VGND VPWR sky130_fd_sc_hd__tapvpwrvgnd_1
XFILLER_42_171 VGND VGND VPWR VPWR sky130_fd_sc_hd__decap_3
XFILLER_15_396 VGND VGND VPWR VPWR sky130_fd_sc_hd__decap_3
XFILLER_15_1301 VGND VGND VPWR VPWR sky130_fd_sc_hd__decap_3
XFILLER_54_1350 VGND VGND VPWR VPWR sky130_fd_sc_hd__decap_3
XTAP_TAPCELL_ROW_13_531 VGND VPWR sky130_fd_sc_hd__tapvpwrvgnd_1
XTAP_TAPCELL_ROW_13_542 VGND VPWR sky130_fd_sc_hd__tapvpwrvgnd_1
XFILLER_15_1334 VGND VGND VPWR VPWR sky130_fd_sc_hd__decap_3
XFILLER_15_1345 VGND VGND VPWR VPWR sky130_fd_sc_hd__decap_3
XFILLER_54_1394 VGND VGND VPWR VPWR sky130_fd_sc_hd__decap_3
XFILLER_11_580 VGND VGND VPWR VPWR sky130_fd_sc_hd__decap_3
XFILLER_50_1258 VGND VGND VPWR VPWR sky130_fd_sc_hd__fill_2
XFILLER_15_1378 VGND VGND VPWR VPWR sky130_fd_sc_hd__decap_3
X_3500_ _6255_/Q _6263_/Q _6271_/Q _6223_/Q _3504_/S0 _4386_/A VGND VGND VPWR VPWR
+ _3501_/B sky130_fd_sc_hd__mux4_2
XFILLER_7_573 VGND VGND VPWR VPWR sky130_fd_sc_hd__decap_3
X_4480_ _4344_/B _6519_/Q _4480_/S VGND VGND VPWR VPWR _4480_/X sky130_fd_sc_hd__mux2_1
X_3431_ _6036_/A0 _3430_/X _3463_/S VGND VGND VPWR VPWR _6189_/D sky130_fd_sc_hd__mux2_1
XFILLER_48_1132 VGND VGND VPWR VPWR sky130_fd_sc_hd__fill_2
X_6150_ _6905_/CLK _6150_/D fanout768/X VGND VGND VPWR VPWR _6150_/Q sky130_fd_sc_hd__dfrtp_2
X_3362_ _6300_/Q _6412_/Q VGND VGND VPWR VPWR _3362_/X sky130_fd_sc_hd__xor2_2
X_5101_ _6371_/Q _5098_/X _5100_/X _5307_/S VGND VGND VPWR VPWR _6371_/D sky130_fd_sc_hd__a22o_2
XFILLER_44_1029 VGND VGND VPWR VPWR sky130_fd_sc_hd__decap_3
Xload_slew432 wire431/A VGND VGND VPWR VPWR _5589_/A2 sky130_fd_sc_hd__buf_4
X_6081_ _6081_/A _6081_/B _6081_/C VGND VGND VPWR VPWR _6081_/X sky130_fd_sc_hd__and3_2
X_3293_ hold924/X _3292_/X _3389_/S VGND VGND VPWR VPWR _6120_/D sky130_fd_sc_hd__mux2_1
XFILLER_61_1310 VGND VGND VPWR VPWR sky130_fd_sc_hd__decap_3
XFILLER_26_1441 VGND VGND VPWR VPWR sky130_fd_sc_hd__decap_3
Xhold1207 _6867_/Q VGND VGND VPWR VPWR _5852_/A0 sky130_fd_sc_hd__dlygate4sd3_1
X_5032_ _5030_/X _5031_/Y _5254_/A2 VGND VGND VPWR VPWR _5034_/S sky130_fd_sc_hd__a21oi_2
XFILLER_61_1343 VGND VGND VPWR VPWR sky130_fd_sc_hd__fill_1
Xhold1218 _6695_/Q VGND VGND VPWR VPWR _5636_/A1 sky130_fd_sc_hd__dlygate4sd3_1
Xhold1229 _6878_/Q VGND VGND VPWR VPWR _5864_/A0 sky130_fd_sc_hd__dlygate4sd3_1
XFILLER_61_1354 VGND VGND VPWR VPWR sky130_fd_sc_hd__decap_3
XFILLER_39_945 VGND VGND VPWR VPWR sky130_fd_sc_hd__decap_3
XFILLER_22_1338 VGND VGND VPWR VPWR sky130_fd_sc_hd__decap_3
XFILLER_61_1387 VGND VGND VPWR VPWR sky130_fd_sc_hd__decap_3
XFILLER_65_241 VGND VGND VPWR VPWR sky130_fd_sc_hd__decap_3
XTAP_TAPCELL_ROW_0_204 VGND VPWR sky130_fd_sc_hd__tapvpwrvgnd_1
XFILLER_38_477 VGND VGND VPWR VPWR sky130_fd_sc_hd__decap_3
XFILLER_4_1270 VGND VGND VPWR VPWR sky130_fd_sc_hd__decap_3
X_6983_ _7055_/CLK _6983_/D load_slew792/X VGND VGND VPWR VPWR _6983_/Q sky130_fd_sc_hd__dfrtp_2
XFILLER_54_959 VGND VGND VPWR VPWR sky130_fd_sc_hd__fill_1
XFILLER_0_1145 VGND VGND VPWR VPWR sky130_fd_sc_hd__decap_3
X_5934_ hold917/X _6938_/Q _5998_/S VGND VGND VPWR VPWR _5934_/X sky130_fd_sc_hd__mux2_1
XFILLER_53_469 VGND VGND VPWR VPWR sky130_fd_sc_hd__decap_3
XFILLER_0_1167 VGND VGND VPWR VPWR sky130_fd_sc_hd__decap_3
XFILLER_59_1272 VGND VGND VPWR VPWR sky130_fd_sc_hd__decap_3
XTAP_TAPCELL_ROW_24_818 VGND VPWR sky130_fd_sc_hd__tapvpwrvgnd_1
XFILLER_0_1189 VGND VGND VPWR VPWR sky130_fd_sc_hd__decap_3
XTAP_TAPCELL_ROW_24_829 VGND VPWR sky130_fd_sc_hd__tapvpwrvgnd_1
XFILLER_34_672 VGND VGND VPWR VPWR sky130_fd_sc_hd__decap_3
XFILLER_62_981 VGND VGND VPWR VPWR sky130_fd_sc_hd__fill_1
X_5865_ _5865_/A0 _5930_/A0 _5867_/S VGND VGND VPWR VPWR _6879_/D sky130_fd_sc_hd__mux2_1
XFILLER_55_1147 VGND VGND VPWR VPWR sky130_fd_sc_hd__decap_3
XFILLER_21_333 VGND VGND VPWR VPWR sky130_fd_sc_hd__decap_3
XFILLER_72_1450 VGND VGND VPWR VPWR sky130_fd_sc_hd__decap_3
X_4816_ _6580_/Q _4872_/A _4817_/A1 VGND VGND VPWR VPWR _4816_/X sky130_fd_sc_hd__a21bo_2
XFILLER_33_1401 VGND VGND VPWR VPWR sky130_fd_sc_hd__decap_3
X_5796_ _5796_/A1 _5783_/X _5841_/C _5795_/X VGND VGND VPWR VPWR _6822_/D sky130_fd_sc_hd__a22o_2
XFILLER_33_1434 VGND VGND VPWR VPWR sky130_fd_sc_hd__decap_3
XFILLER_21_388 VGND VGND VPWR VPWR sky130_fd_sc_hd__decap_3
X_4747_ _4747_/A _4747_/B VGND VGND VPWR VPWR _4747_/Y sky130_fd_sc_hd__nor2_2
X_4678_ _6891_/Q _4855_/A2 _4862_/B1 _4677_/X VGND VGND VPWR VPWR _4678_/X sky130_fd_sc_hd__a211o_2
XTAP_TAPCELL_ROW_73_2101 VGND VPWR sky130_fd_sc_hd__tapvpwrvgnd_1
X_6417_ _7051_/CLK _6417_/D load_slew815/X VGND VGND VPWR VPWR _6417_/Q sky130_fd_sc_hd__dfrtp_2
X_3629_ _4783_/A _3627_/X _3628_/X VGND VGND VPWR VPWR _3629_/X sky130_fd_sc_hd__a21o_2
XFILLER_66_1232 VGND VGND VPWR VPWR sky130_fd_sc_hd__decap_3
XFILLER_1_727 VGND VGND VPWR VPWR sky130_fd_sc_hd__fill_1
X_6348_ _7009_/CLK _6348_/D fanout765/X VGND VGND VPWR VPWR _6348_/Q sky130_fd_sc_hd__dfrtp_2
XFILLER_0_215 VGND VGND VPWR VPWR sky130_fd_sc_hd__decap_3
XFILLER_1_738 VGND VGND VPWR VPWR sky130_fd_sc_hd__decap_3
XFILLER_27_1227 VGND VGND VPWR VPWR sky130_fd_sc_hd__decap_3
XFILLER_66_1276 VGND VGND VPWR VPWR sky130_fd_sc_hd__decap_3
XFILLER_0_237 VGND VGND VPWR VPWR sky130_fd_sc_hd__decap_3
X_6279_ _6913_/CLK _6279_/D load_slew728/X VGND VGND VPWR VPWR _6279_/Q sky130_fd_sc_hd__dfrtp_2
XFILLER_0_259 VGND VGND VPWR VPWR sky130_fd_sc_hd__decap_3
XFILLER_76_517 VGND VGND VPWR VPWR sky130_fd_sc_hd__decap_3
XFILLER_29_411 VGND VGND VPWR VPWR sky130_fd_sc_hd__decap_3
XFILLER_9_1192 VGND VGND VPWR VPWR sky130_fd_sc_hd__decap_3
XFILLER_40_1427 VGND VGND VPWR VPWR sky130_fd_sc_hd__fill_1
XFILLER_29_444 VGND VGND VPWR VPWR sky130_fd_sc_hd__decap_3
XFILLER_40_1438 VGND VGND VPWR VPWR sky130_fd_sc_hd__decap_3
XFILLER_29_455 VGND VGND VPWR VPWR sky130_fd_sc_hd__decap_3
XFILLER_57_764 VGND VGND VPWR VPWR sky130_fd_sc_hd__decap_3
XFILLER_5_1089 VGND VGND VPWR VPWR sky130_fd_sc_hd__decap_3
XFILLER_56_79 VGND VGND VPWR VPWR sky130_fd_sc_hd__decap_3
XFILLER_44_414 VGND VGND VPWR VPWR sky130_fd_sc_hd__decap_3
XFILLER_16_138 VGND VGND VPWR VPWR sky130_fd_sc_hd__fill_2
XFILLER_72_12 VGND VGND VPWR VPWR sky130_fd_sc_hd__decap_3
XFILLER_38_1312 VGND VGND VPWR VPWR sky130_fd_sc_hd__decap_3
XFILLER_72_789 VGND VGND VPWR VPWR sky130_fd_sc_hd__fill_1
XFILLER_77_1372 VGND VGND VPWR VPWR sky130_fd_sc_hd__decap_3
XFILLER_38_1323 VGND VGND VPWR VPWR sky130_fd_sc_hd__decap_3
XFILLER_13_812 VGND VGND VPWR VPWR sky130_fd_sc_hd__decap_3
XFILLER_73_1225 VGND VGND VPWR VPWR sky130_fd_sc_hd__decap_3
XFILLER_72_56 VGND VGND VPWR VPWR sky130_fd_sc_hd__decap_3
XFILLER_73_1236 VGND VGND VPWR VPWR sky130_fd_sc_hd__decap_3
XFILLER_24_160 VGND VGND VPWR VPWR sky130_fd_sc_hd__decap_3
XFILLER_38_1356 VGND VGND VPWR VPWR sky130_fd_sc_hd__decap_3
XFILLER_40_642 VGND VGND VPWR VPWR sky130_fd_sc_hd__fill_2
XFILLER_73_1269 VGND VGND VPWR VPWR sky130_fd_sc_hd__decap_3
XFILLER_13_878 VGND VGND VPWR VPWR sky130_fd_sc_hd__decap_3
XFILLER_40_697 VGND VGND VPWR VPWR sky130_fd_sc_hd__decap_3
XFILLER_10_1220 VGND VGND VPWR VPWR sky130_fd_sc_hd__decap_3
XFILLER_4_521 VGND VGND VPWR VPWR sky130_fd_sc_hd__decap_3
XFILLER_21_60 VGND VGND VPWR VPWR sky130_fd_sc_hd__decap_3
XFILLER_10_1253 VGND VGND VPWR VPWR sky130_fd_sc_hd__decap_3
XFILLER_4_554 VGND VGND VPWR VPWR sky130_fd_sc_hd__decap_3
XFILLER_10_1264 VGND VGND VPWR VPWR sky130_fd_sc_hd__decap_3
XFILLER_49_1452 VGND VGND VPWR VPWR sky130_fd_sc_hd__decap_3
XFILLER_10_1297 VGND VGND VPWR VPWR sky130_fd_sc_hd__decap_3
XFILLER_4_587 VGND VGND VPWR VPWR sky130_fd_sc_hd__fill_1
XFILLER_49_1463 VGND VGND VPWR VPWR sky130_fd_sc_hd__decap_3
XTAP_TAPCELL_ROW_56_1653 VGND VPWR sky130_fd_sc_hd__tapvpwrvgnd_1
XFILLER_4_598 VGND VGND VPWR VPWR sky130_fd_sc_hd__decap_3
XTAP_TAPCELL_ROW_56_1664 VGND VPWR sky130_fd_sc_hd__tapvpwrvgnd_1
XFILLER_79_322 VGND VGND VPWR VPWR sky130_fd_sc_hd__decap_3
XFILLER_45_1316 VGND VGND VPWR VPWR sky130_fd_sc_hd__decap_3
XFILLER_80_1229 VGND VGND VPWR VPWR sky130_fd_sc_hd__decap_3
XTAP_TAPCELL_ROW_7_370 VGND VPWR sky130_fd_sc_hd__tapvpwrvgnd_1
XFILLER_0_760 VGND VGND VPWR VPWR sky130_fd_sc_hd__decap_3
XTAP_TAPCELL_ROW_7_381 VGND VPWR sky130_fd_sc_hd__tapvpwrvgnd_1
XFILLER_43_1040 VGND VGND VPWR VPWR sky130_fd_sc_hd__decap_3
XTAP_TAPCELL_ROW_7_392 VGND VPWR sky130_fd_sc_hd__tapvpwrvgnd_1
XFILLER_43_1062 VGND VGND VPWR VPWR sky130_fd_sc_hd__fill_2
XFILLER_43_1073 VGND VGND VPWR VPWR sky130_fd_sc_hd__decap_3
XFILLER_36_904 VGND VGND VPWR VPWR sky130_fd_sc_hd__decap_3
XFILLER_75_561 VGND VGND VPWR VPWR sky130_fd_sc_hd__decap_3
XFILLER_78_1114 VGND VGND VPWR VPWR sky130_fd_sc_hd__decap_3
XFILLER_1_1410 VGND VGND VPWR VPWR sky130_fd_sc_hd__decap_3
XFILLER_48_797 VGND VGND VPWR VPWR sky130_fd_sc_hd__fill_2
XFILLER_36_948 VGND VGND VPWR VPWR sky130_fd_sc_hd__decap_3
XFILLER_62_200 VGND VGND VPWR VPWR sky130_fd_sc_hd__decap_3
XFILLER_78_1147 VGND VGND VPWR VPWR sky130_fd_sc_hd__fill_1
XFILLER_21_1360 VGND VGND VPWR VPWR sky130_fd_sc_hd__decap_3
XFILLER_78_1158 VGND VGND VPWR VPWR sky130_fd_sc_hd__decap_3
XFILLER_1_1443 VGND VGND VPWR VPWR sky130_fd_sc_hd__decap_3
XFILLER_35_458 VGND VGND VPWR VPWR sky130_fd_sc_hd__fill_2
XTAP_TAPCELL_ROW_18_656 VGND VPWR sky130_fd_sc_hd__tapvpwrvgnd_1
XFILLER_21_1393 VGND VGND VPWR VPWR sky130_fd_sc_hd__decap_3
XFILLER_51_918 VGND VGND VPWR VPWR sky130_fd_sc_hd__decap_3
XTAP_TAPCELL_ROW_18_667 VGND VPWR sky130_fd_sc_hd__tapvpwrvgnd_1
XFILLER_56_1412 VGND VGND VPWR VPWR sky130_fd_sc_hd__decap_3
X_3980_ _6531_/Q _4388_/A _4061_/A1 VGND VGND VPWR VPWR _3980_/X sky130_fd_sc_hd__a21bo_2
Xmax_cap91 _5674_/S VGND VGND VPWR VPWR _5675_/S sky130_fd_sc_hd__clkbuf_8
XFILLER_44_970 VGND VGND VPWR VPWR sky130_fd_sc_hd__decap_3
XTAP_TAPCELL_ROW_18_678 VGND VPWR sky130_fd_sc_hd__tapvpwrvgnd_1
XFILLER_22_108 VGND VGND VPWR VPWR sky130_fd_sc_hd__fill_1
XFILLER_44_981 VGND VGND VPWR VPWR sky130_fd_sc_hd__decap_3
XFILLER_17_1407 VGND VGND VPWR VPWR sky130_fd_sc_hd__decap_3
XFILLER_56_1456 VGND VGND VPWR VPWR sky130_fd_sc_hd__decap_3
XFILLER_15_182 VGND VGND VPWR VPWR sky130_fd_sc_hd__decap_3
XFILLER_52_1309 VGND VGND VPWR VPWR sky130_fd_sc_hd__decap_3
Xclkbuf_0_clk clk VGND VGND VPWR VPWR clkbuf_0_clk/X sky130_fd_sc_hd__clkbuf_16
X_5650_ _5650_/A0 _5889_/A0 _5657_/S VGND VGND VPWR VPWR _6706_/D sky130_fd_sc_hd__mux2_1
XFILLER_30_141 VGND VGND VPWR VPWR sky130_fd_sc_hd__decap_3
X_4601_ _4419_/X _4444_/Y _4547_/X _6543_/Q _3098_/A VGND VGND VPWR VPWR _4604_/B
+ sky130_fd_sc_hd__a221o_2
X_5581_ _5581_/A _5581_/B VGND VGND VPWR VPWR _5582_/A sky130_fd_sc_hd__nand2_2
XFILLER_15_1164 VGND VGND VPWR VPWR sky130_fd_sc_hd__decap_3
XFILLER_11_1006 VGND VGND VPWR VPWR sky130_fd_sc_hd__fill_2
X_4532_ _4783_/A _4532_/B _4532_/C VGND VGND VPWR VPWR _4532_/X sky130_fd_sc_hd__and3_2
XFILLER_7_62 VGND VGND VPWR VPWR sky130_fd_sc_hd__decap_3
XFILLER_50_1088 VGND VGND VPWR VPWR sky130_fd_sc_hd__decap_3
X_4463_ _6332_/Q wire507/X _3314_/X _4875_/B2 VGND VGND VPWR VPWR _4463_/X sky130_fd_sc_hd__a22o_2
X_6202_ clkload7/A _6202_/D load_slew643/X VGND VGND VPWR VPWR _6202_/Q sky130_fd_sc_hd__dfrtp_2
X_3414_ _6238_/Q _6438_/Q VGND VGND VPWR VPWR _3414_/X sky130_fd_sc_hd__xor2_2
XPHY_EDGE_ROW_15_Right_15 VGND VGND VPWR VPWR sky130_fd_sc_hd__decap_3
X_4394_ _4394_/A _4394_/B _4723_/B _5589_/A3 VGND VGND VPWR VPWR _4394_/X sky130_fd_sc_hd__or4b_2
Xfanout806 fanout817/X VGND VGND VPWR VPWR fanout806/X sky130_fd_sc_hd__clkdlybuf4s25_1
XFILLER_63_1416 VGND VGND VPWR VPWR sky130_fd_sc_hd__decap_3
X_6133_ _7048_/CLK _6133_/D load_slew658/X VGND VGND VPWR VPWR _6133_/Q sky130_fd_sc_hd__dfrtp_2
Xfanout817 fanout848/X VGND VGND VPWR VPWR fanout817/X sky130_fd_sc_hd__clkdlybuf4s25_1
X_3345_ hold963/X _3344_/X _7087_/D VGND VGND VPWR VPWR _6146_/D sky130_fd_sc_hd__mux2_1
Xfanout828 fanout830/X VGND VGND VPWR VPWR fanout828/X sky130_fd_sc_hd__clkdlybuf4s25_1
XTAP_TAPCELL_ROW_5_318 VGND VPWR sky130_fd_sc_hd__tapvpwrvgnd_1
XFILLER_63_1449 VGND VGND VPWR VPWR sky130_fd_sc_hd__decap_3
Xfanout839 fanout841/X VGND VGND VPWR VPWR fanout839/X sky130_fd_sc_hd__clkdlybuf4s25_1
XTAP_TAPCELL_ROW_5_329 VGND VPWR sky130_fd_sc_hd__tapvpwrvgnd_1
XFILLER_58_528 VGND VGND VPWR VPWR sky130_fd_sc_hd__decap_3
Xhold1004 _6207_/Q VGND VGND VPWR VPWR _6054_/A0 sky130_fd_sc_hd__dlygate4sd3_1
Xload_slew262 _4624_/A VGND VGND VPWR VPWR _4703_/A sky130_fd_sc_hd__buf_4
X_6064_ _5703_/A _5731_/B _5758_/B _6062_/X _7067_/Q VGND VGND VPWR VPWR _7067_/D
+ sky130_fd_sc_hd__a32o_2
Xhold1015 _5987_/X VGND VGND VPWR VPWR _6991_/D sky130_fd_sc_hd__dlygate4sd3_1
Xload_slew273 _4413_/A VGND VGND VPWR VPWR _4388_/A sky130_fd_sc_hd__buf_4
X_3276_ _6217_/Q _6369_/Q VGND VGND VPWR VPWR _3276_/X sky130_fd_sc_hd__xor2_2
XFILLER_6_1332 VGND VGND VPWR VPWR sky130_fd_sc_hd__decap_3
Xhold1026 _6689_/Q VGND VGND VPWR VPWR _5627_/A0 sky130_fd_sc_hd__dlygate4sd3_1
XFILLER_39_742 VGND VGND VPWR VPWR sky130_fd_sc_hd__decap_3
X_5015_ _6424_/Q _5015_/B VGND VGND VPWR VPWR _5246_/B sky130_fd_sc_hd__xnor2_2
XFILLER_26_1282 VGND VGND VPWR VPWR sky130_fd_sc_hd__decap_3
Xhold1037 _6192_/Q VGND VGND VPWR VPWR _6039_/A0 sky130_fd_sc_hd__dlygate4sd3_1
XFILLER_6_1365 VGND VGND VPWR VPWR sky130_fd_sc_hd__decap_3
XFILLER_38_230 VGND VGND VPWR VPWR sky130_fd_sc_hd__decap_3
Xhold1048 _6113_/Q VGND VGND VPWR VPWR _5960_/A0 sky130_fd_sc_hd__dlygate4sd3_1
Xhold1059 _6020_/X VGND VGND VPWR VPWR _7024_/D sky130_fd_sc_hd__dlygate4sd3_1
XFILLER_6_1376 VGND VGND VPWR VPWR sky130_fd_sc_hd__decap_3
XFILLER_22_1146 VGND VGND VPWR VPWR sky130_fd_sc_hd__fill_2
XFILLER_27_915 VGND VGND VPWR VPWR sky130_fd_sc_hd__decap_3
XFILLER_54_701 VGND VGND VPWR VPWR sky130_fd_sc_hd__fill_1
XFILLER_2_1229 VGND VGND VPWR VPWR sky130_fd_sc_hd__decap_3
XFILLER_66_572 VGND VGND VPWR VPWR sky130_fd_sc_hd__decap_3
XPHY_EDGE_ROW_24_Right_24 VGND VGND VPWR VPWR sky130_fd_sc_hd__decap_3
XFILLER_53_255 VGND VGND VPWR VPWR sky130_fd_sc_hd__fill_1
X_6966_ _7088_/CLK _6966_/D fanout768/A VGND VGND VPWR VPWR _6966_/Q sky130_fd_sc_hd__dfrtp_2
XFILLER_35_992 VGND VGND VPWR VPWR sky130_fd_sc_hd__fill_2
X_5917_ _5917_/A0 _5917_/A1 _5923_/S VGND VGND VPWR VPWR _6923_/D sky130_fd_sc_hd__mux2_1
X_6897_ _6897_/CLK _6897_/D wire712/A VGND VGND VPWR VPWR _6897_/Q sky130_fd_sc_hd__dfrtp_2
XFILLER_70_1409 VGND VGND VPWR VPWR sky130_fd_sc_hd__decap_3
XFILLER_42_15 VGND VGND VPWR VPWR sky130_fd_sc_hd__decap_3
XFILLER_22_653 VGND VGND VPWR VPWR sky130_fd_sc_hd__decap_3
XFILLER_50_962 VGND VGND VPWR VPWR sky130_fd_sc_hd__decap_3
X_5848_ _5848_/A0 _5799_/C _5849_/S VGND VGND VPWR VPWR _6864_/D sky130_fd_sc_hd__mux2_1
XFILLER_21_163 VGND VGND VPWR VPWR sky130_fd_sc_hd__decap_3
XFILLER_72_1291 VGND VGND VPWR VPWR sky130_fd_sc_hd__decap_3
XFILLER_33_1242 VGND VGND VPWR VPWR sky130_fd_sc_hd__decap_3
XFILLER_10_859 VGND VGND VPWR VPWR sky130_fd_sc_hd__decap_3
X_5779_ _5779_/A0 _5902_/A0 _5782_/S VGND VGND VPWR VPWR _6814_/D sky130_fd_sc_hd__mux2_1
XFILLER_33_1275 VGND VGND VPWR VPWR sky130_fd_sc_hd__decap_3
XFILLER_68_1338 VGND VGND VPWR VPWR sky130_fd_sc_hd__decap_3
XPHY_EDGE_ROW_33_Right_33 VGND VGND VPWR VPWR sky130_fd_sc_hd__decap_3
XFILLER_66_1040 VGND VGND VPWR VPWR sky130_fd_sc_hd__decap_3
Xhold871 _6175_/Q VGND VGND VPWR VPWR hold871/X sky130_fd_sc_hd__dlygate4sd3_1
Xhold882 _6138_/Q VGND VGND VPWR VPWR hold882/X sky130_fd_sc_hd__dlygate4sd3_1
Xhold893 _6620_/Q VGND VGND VPWR VPWR hold893/X sky130_fd_sc_hd__dlygate4sd3_1
XPHY_EDGE_ROW_10_Left_91 VGND VGND VPWR VPWR sky130_fd_sc_hd__decap_3
XFILLER_7_1107 VGND VGND VPWR VPWR sky130_fd_sc_hd__decap_3
XFILLER_67_12 VGND VGND VPWR VPWR sky130_fd_sc_hd__decap_3
XFILLER_77_837 VGND VGND VPWR VPWR sky130_fd_sc_hd__decap_3
XFILLER_67_45 VGND VGND VPWR VPWR sky130_fd_sc_hd__decap_3
XFILLER_27_1068 VGND VGND VPWR VPWR sky130_fd_sc_hd__decap_3
XFILLER_44_1371 VGND VGND VPWR VPWR sky130_fd_sc_hd__fill_1
XFILLER_67_78 VGND VGND VPWR VPWR sky130_fd_sc_hd__decap_3
XFILLER_44_1382 VGND VGND VPWR VPWR sky130_fd_sc_hd__decap_3
XFILLER_79_1401 VGND VGND VPWR VPWR sky130_fd_sc_hd__decap_3
Xhold1560 _6674_/Q VGND VGND VPWR VPWR _5603_/B2 sky130_fd_sc_hd__dlygate4sd3_1
XFILLER_40_1246 VGND VGND VPWR VPWR sky130_fd_sc_hd__decap_3
XFILLER_57_561 VGND VGND VPWR VPWR sky130_fd_sc_hd__decap_3
XFILLER_17_403 VGND VGND VPWR VPWR sky130_fd_sc_hd__decap_3
XFILLER_18_937 VGND VGND VPWR VPWR sky130_fd_sc_hd__decap_3
Xhold1571 _7077_/Q VGND VGND VPWR VPWR _6082_/S sky130_fd_sc_hd__dlygate4sd3_1
XFILLER_79_1434 VGND VGND VPWR VPWR sky130_fd_sc_hd__decap_3
XFILLER_29_274 VGND VGND VPWR VPWR sky130_fd_sc_hd__decap_3
XFILLER_44_200 VGND VGND VPWR VPWR sky130_fd_sc_hd__decap_3
XTAP_TAPCELL_ROW_28_921 VGND VPWR sky130_fd_sc_hd__tapvpwrvgnd_1
XFILLER_40_1279 VGND VGND VPWR VPWR sky130_fd_sc_hd__decap_3
XTAP_TAPCELL_ROW_28_932 VGND VPWR sky130_fd_sc_hd__tapvpwrvgnd_1
XPHY_EDGE_ROW_42_Right_42 VGND VGND VPWR VPWR sky130_fd_sc_hd__decap_3
XFILLER_72_531 VGND VGND VPWR VPWR sky130_fd_sc_hd__fill_1
XFILLER_72_542 VGND VGND VPWR VPWR sky130_fd_sc_hd__decap_3
XFILLER_45_778 VGND VGND VPWR VPWR sky130_fd_sc_hd__decap_3
XFILLER_60_726 VGND VGND VPWR VPWR sky130_fd_sc_hd__decap_3
XFILLER_77_1180 VGND VGND VPWR VPWR sky130_fd_sc_hd__decap_3
XFILLER_44_288 VGND VGND VPWR VPWR sky130_fd_sc_hd__decap_3
XFILLER_13_620 VGND VGND VPWR VPWR sky130_fd_sc_hd__fill_2
XFILLER_38_1175 VGND VGND VPWR VPWR sky130_fd_sc_hd__decap_3
XFILLER_41_962 VGND VGND VPWR VPWR sky130_fd_sc_hd__decap_3
XFILLER_13_664 VGND VGND VPWR VPWR sky130_fd_sc_hd__decap_3
XTAP_TAPCELL_ROW_45_1365 VGND VPWR sky130_fd_sc_hd__tapvpwrvgnd_1
XFILLER_12_141 VGND VGND VPWR VPWR sky130_fd_sc_hd__decap_3
XTAP_TAPCELL_ROW_45_1376 VGND VPWR sky130_fd_sc_hd__tapvpwrvgnd_1
XFILLER_8_112 VGND VGND VPWR VPWR sky130_fd_sc_hd__fill_1
XFILLER_40_472 VGND VGND VPWR VPWR sky130_fd_sc_hd__decap_3
XFILLER_51_1331 VGND VGND VPWR VPWR sky130_fd_sc_hd__decap_3
XFILLER_12_185 VGND VGND VPWR VPWR sky130_fd_sc_hd__decap_3
XFILLER_16_1462 VGND VGND VPWR VPWR sky130_fd_sc_hd__decap_3
XFILLER_73_9 VGND VGND VPWR VPWR sky130_fd_sc_hd__decap_3
XFILLER_9_679 VGND VGND VPWR VPWR sky130_fd_sc_hd__fill_2
XFILLER_12_1315 VGND VGND VPWR VPWR sky130_fd_sc_hd__fill_1
XFILLER_12_1326 VGND VGND VPWR VPWR sky130_fd_sc_hd__decap_3
XFILLER_32_81 VGND VGND VPWR VPWR sky130_fd_sc_hd__decap_3
XFILLER_51_1375 VGND VGND VPWR VPWR sky130_fd_sc_hd__decap_3
XPHY_EDGE_ROW_51_Right_51 VGND VGND VPWR VPWR sky130_fd_sc_hd__decap_3
XTAP_TAPCELL_ROW_58_1704 VGND VPWR sky130_fd_sc_hd__tapvpwrvgnd_1
XFILLER_12_1359 VGND VGND VPWR VPWR sky130_fd_sc_hd__decap_3
XTAP_TAPCELL_ROW_58_1715 VGND VPWR sky130_fd_sc_hd__tapvpwrvgnd_1
XFILLER_5_841 VGND VGND VPWR VPWR sky130_fd_sc_hd__decap_3
XFILLER_10_1050 VGND VGND VPWR VPWR sky130_fd_sc_hd__decap_3
XFILLER_4_351 VGND VGND VPWR VPWR sky130_fd_sc_hd__decap_3
XFILLER_49_1260 VGND VGND VPWR VPWR sky130_fd_sc_hd__decap_3
XFILLER_45_1124 VGND VGND VPWR VPWR sky130_fd_sc_hd__fill_1
XFILLER_80_1015 VGND VGND VPWR VPWR sky130_fd_sc_hd__decap_3
XFILLER_45_1146 VGND VGND VPWR VPWR sky130_fd_sc_hd__decap_3
XFILLER_80_1037 VGND VGND VPWR VPWR sky130_fd_sc_hd__decap_3
X_3130_ _3193_/A1 _3128_/X _3129_/X _3213_/C1 VGND VGND VPWR VPWR _3130_/X sky130_fd_sc_hd__a211o_2
XFILLER_68_848 VGND VGND VPWR VPWR sky130_fd_sc_hd__decap_3
XFILLER_23_1422 VGND VGND VPWR VPWR sky130_fd_sc_hd__decap_3
X_3061_ _6357_/Q VGND VGND VPWR VPWR _3061_/Y sky130_fd_sc_hd__inv_2
XPHY_EDGE_ROW_60_Right_60 VGND VGND VPWR VPWR sky130_fd_sc_hd__decap_3
XFILLER_23_1455 VGND VGND VPWR VPWR sky130_fd_sc_hd__fill_1
XFILLER_36_701 VGND VGND VPWR VPWR sky130_fd_sc_hd__decap_3
XFILLER_76_881 VGND VGND VPWR VPWR sky130_fd_sc_hd__fill_1
XFILLER_23_1466 VGND VGND VPWR VPWR sky130_fd_sc_hd__decap_3
XFILLER_63_520 VGND VGND VPWR VPWR sky130_fd_sc_hd__decap_3
XFILLER_36_745 VGND VGND VPWR VPWR sky130_fd_sc_hd__decap_3
XFILLER_1_1251 VGND VGND VPWR VPWR sky130_fd_sc_hd__decap_3
X_6820_ _7022_/CLK _6820_/D load_slew751/X VGND VGND VPWR VPWR _6820_/Q sky130_fd_sc_hd__dfrtp_2
XFILLER_36_778 VGND VGND VPWR VPWR sky130_fd_sc_hd__decap_3
XFILLER_35_255 VGND VGND VPWR VPWR sky130_fd_sc_hd__decap_3
XFILLER_1_1284 VGND VGND VPWR VPWR sky130_fd_sc_hd__decap_3
XFILLER_1_1295 VGND VGND VPWR VPWR sky130_fd_sc_hd__decap_3
XFILLER_51_748 VGND VGND VPWR VPWR sky130_fd_sc_hd__decap_3
XFILLER_16_480 VGND VGND VPWR VPWR sky130_fd_sc_hd__decap_3
X_6751_ _7004_/CLK _6751_/D fanout841/X VGND VGND VPWR VPWR _6751_/Q sky130_fd_sc_hd__dfrtp_2
X_3963_ _4061_/A1 _3959_/X _3961_/Y _3962_/X _4013_/A VGND VGND VPWR VPWR _3963_/X
+ sky130_fd_sc_hd__o221a_2
XFILLER_32_940 VGND VGND VPWR VPWR sky130_fd_sc_hd__fill_2
XFILLER_56_1253 VGND VGND VPWR VPWR sky130_fd_sc_hd__decap_3
XFILLER_56_1264 VGND VGND VPWR VPWR sky130_fd_sc_hd__decap_3
XFILLER_17_1226 VGND VGND VPWR VPWR sky130_fd_sc_hd__decap_3
X_5702_ _5702_/A0 _5858_/A1 _5702_/S VGND VGND VPWR VPWR _6753_/D sky130_fd_sc_hd__mux2_1
X_6682_ _6954_/CLK _6682_/D fanout672/X VGND VGND VPWR VPWR _6682_/Q sky130_fd_sc_hd__dfrtp_2
XFILLER_52_1117 VGND VGND VPWR VPWR sky130_fd_sc_hd__decap_3
XFILLER_17_1248 VGND VGND VPWR VPWR sky130_fd_sc_hd__decap_3
XFILLER_31_461 VGND VGND VPWR VPWR sky130_fd_sc_hd__fill_1
XFILLER_32_984 VGND VGND VPWR VPWR sky130_fd_sc_hd__decap_3
X_3894_ _4326_/A _4314_/B VGND VGND VPWR VPWR _3906_/A sky130_fd_sc_hd__xnor2_2
XFILLER_56_1297 VGND VGND VPWR VPWR sky130_fd_sc_hd__decap_3
XFILLER_52_1139 VGND VGND VPWR VPWR sky130_fd_sc_hd__fill_1
X_5633_ _5909_/A0 _5633_/A1 wire93/X VGND VGND VPWR VPWR _6692_/D sky130_fd_sc_hd__mux2_1
XFILLER_31_494 VGND VGND VPWR VPWR sky130_fd_sc_hd__decap_3
XFILLER_12_18 VGND VGND VPWR VPWR sky130_fd_sc_hd__decap_3
XFILLER_12_29 VGND VGND VPWR VPWR sky130_fd_sc_hd__fill_1
XFILLER_30_1415 VGND VGND VPWR VPWR sky130_fd_sc_hd__decap_3
X_5564_ _6365_/Q _5564_/A2 _5564_/B1 _5564_/B2 VGND VGND VPWR VPWR _6647_/D sky130_fd_sc_hd__a22o_2
XFILLER_30_1459 VGND VGND VPWR VPWR sky130_fd_sc_hd__decap_3
X_4515_ _6861_/Q _4869_/A2 _4869_/B1 _4514_/X VGND VGND VPWR VPWR _4515_/X sky130_fd_sc_hd__a211o_2
X_5495_ _6601_/Q _6600_/Q _6602_/Q VGND VGND VPWR VPWR _5499_/B sky130_fd_sc_hd__nand3_2
X_4446_ _4526_/B _4624_/B VGND VGND VPWR VPWR _4446_/Y sky130_fd_sc_hd__nor2_2
XFILLER_28_1300 VGND VGND VPWR VPWR sky130_fd_sc_hd__decap_3
XFILLER_67_1360 VGND VGND VPWR VPWR sky130_fd_sc_hd__decap_3
Xfanout603 _5799_/C VGND VGND VPWR VPWR _5913_/A0 sky130_fd_sc_hd__clkdlybuf4s25_1
XFILLER_63_1224 VGND VGND VPWR VPWR sky130_fd_sc_hd__decap_3
X_4377_ _3796_/A _3796_/B _4562_/C _4768_/B _4586_/A VGND VGND VPWR VPWR _4738_/B
+ sky130_fd_sc_hd__o2111ai_2
Xfanout614 _5795_/C VGND VGND VPWR VPWR _5911_/A0 sky130_fd_sc_hd__clkdlybuf4s25_1
XFILLER_28_1344 VGND VGND VPWR VPWR sky130_fd_sc_hd__decap_3
XFILLER_67_1393 VGND VGND VPWR VPWR sky130_fd_sc_hd__decap_3
XFILLER_8_1427 VGND VGND VPWR VPWR sky130_fd_sc_hd__fill_1
XFILLER_8_1438 VGND VGND VPWR VPWR sky130_fd_sc_hd__decap_3
Xfanout636 wire639/A VGND VGND VPWR VPWR fanout636/X sky130_fd_sc_hd__clkdlybuf4s25_1
XFILLER_59_826 VGND VGND VPWR VPWR sky130_fd_sc_hd__decap_3
Xfanout647 fanout653/X VGND VGND VPWR VPWR fanout647/X sky130_fd_sc_hd__clkdlybuf4s25_1
X_6116_ _7039_/CLK _6116_/D wire827/X VGND VGND VPWR VPWR _6116_/Q sky130_fd_sc_hd__dfrtp_2
XFILLER_63_1257 VGND VGND VPWR VPWR sky130_fd_sc_hd__decap_3
X_3328_ _6291_/Q _6395_/Q VGND VGND VPWR VPWR _3328_/X sky130_fd_sc_hd__xor2_2
XFILLER_28_1388 VGND VGND VPWR VPWR sky130_fd_sc_hd__decap_3
X_7096_ _7096_/CLK _7096_/D load_slew677/X VGND VGND VPWR VPWR _7096_/Q sky130_fd_sc_hd__dfrtp_2
XFILLER_74_807 VGND VGND VPWR VPWR sky130_fd_sc_hd__decap_3
X_6047_ _6047_/A0 _6047_/A1 _6047_/S VGND VGND VPWR VPWR _7051_/D sky130_fd_sc_hd__mux2_1
X_3259_ _5950_/A0 _3258_/X _3435_/S VGND VGND VPWR VPWR _6103_/D sky130_fd_sc_hd__mux2_1
XFILLER_73_306 VGND VGND VPWR VPWR sky130_fd_sc_hd__decap_3
XFILLER_39_561 VGND VGND VPWR VPWR sky130_fd_sc_hd__fill_2
XFILLER_6_1173 VGND VGND VPWR VPWR sky130_fd_sc_hd__decap_3
XFILLER_2_1026 VGND VGND VPWR VPWR sky130_fd_sc_hd__decap_3
XFILLER_26_200 VGND VGND VPWR VPWR sky130_fd_sc_hd__decap_3
XFILLER_2_1037 VGND VGND VPWR VPWR sky130_fd_sc_hd__decap_3
XFILLER_27_745 VGND VGND VPWR VPWR sky130_fd_sc_hd__decap_3
XFILLER_66_391 VGND VGND VPWR VPWR sky130_fd_sc_hd__fill_1
XFILLER_54_575 VGND VGND VPWR VPWR sky130_fd_sc_hd__decap_3
XFILLER_57_1028 VGND VGND VPWR VPWR sky130_fd_sc_hd__fill_1
XFILLER_42_737 VGND VGND VPWR VPWR sky130_fd_sc_hd__fill_1
XFILLER_74_1320 VGND VGND VPWR VPWR sky130_fd_sc_hd__decap_3
XFILLER_39_1440 VGND VGND VPWR VPWR sky130_fd_sc_hd__decap_3
XFILLER_14_439 VGND VGND VPWR VPWR sky130_fd_sc_hd__fill_1
X_6949_ clkload8/A _6949_/D load_slew645/X VGND VGND VPWR VPWR _6949_/Q sky130_fd_sc_hd__dfrtp_2
XFILLER_74_1353 VGND VGND VPWR VPWR sky130_fd_sc_hd__decap_3
XFILLER_35_1304 VGND VGND VPWR VPWR sky130_fd_sc_hd__decap_3
XFILLER_23_951 VGND VGND VPWR VPWR sky130_fd_sc_hd__fill_1
XFILLER_41_258 VGND VGND VPWR VPWR sky130_fd_sc_hd__decap_3
XFILLER_23_973 VGND VGND VPWR VPWR sky130_fd_sc_hd__fill_1
XFILLER_70_1217 VGND VGND VPWR VPWR sky130_fd_sc_hd__decap_3
XFILLER_35_1337 VGND VGND VPWR VPWR sky130_fd_sc_hd__decap_3
XFILLER_74_1397 VGND VGND VPWR VPWR sky130_fd_sc_hd__decap_3
XFILLER_35_1348 VGND VGND VPWR VPWR sky130_fd_sc_hd__decap_3
XFILLER_10_623 VGND VGND VPWR VPWR sky130_fd_sc_hd__decap_3
XFILLER_10_645 VGND VGND VPWR VPWR sky130_fd_sc_hd__decap_3
XFILLER_6_605 VGND VGND VPWR VPWR sky130_fd_sc_hd__decap_3
XFILLER_33_1050 VGND VGND VPWR VPWR sky130_fd_sc_hd__decap_3
XTAP_TAPCELL_ROW_40_1240 VGND VPWR sky130_fd_sc_hd__tapvpwrvgnd_1
XFILLER_10_667 VGND VGND VPWR VPWR sky130_fd_sc_hd__decap_3
XTAP_TAPCELL_ROW_40_1251 VGND VPWR sky130_fd_sc_hd__tapvpwrvgnd_1
XFILLER_2_800 VGND VGND VPWR VPWR sky130_fd_sc_hd__decap_3
XFILLER_29_1108 VGND VGND VPWR VPWR sky130_fd_sc_hd__decap_3
XFILLER_68_1157 VGND VGND VPWR VPWR sky130_fd_sc_hd__decap_3
XFILLER_11_1381 VGND VGND VPWR VPWR sky130_fd_sc_hd__decap_3
XTAP_TAPCELL_ROW_9_432 VGND VPWR sky130_fd_sc_hd__tapvpwrvgnd_1
XFILLER_2_822 VGND VGND VPWR VPWR sky130_fd_sc_hd__decap_3
XTAP_TAPCELL_ROW_9_443 VGND VPWR sky130_fd_sc_hd__tapvpwrvgnd_1
XFILLER_46_1400 VGND VGND VPWR VPWR sky130_fd_sc_hd__decap_3
XFILLER_78_44 VGND VGND VPWR VPWR sky130_fd_sc_hd__decap_3
XFILLER_2_855 VGND VGND VPWR VPWR sky130_fd_sc_hd__decap_3
XFILLER_1_332 VGND VGND VPWR VPWR sky130_fd_sc_hd__decap_3
XFILLER_1_343 VGND VGND VPWR VPWR sky130_fd_sc_hd__decap_3
XFILLER_46_1444 VGND VGND VPWR VPWR sky130_fd_sc_hd__decap_3
XFILLER_78_77 VGND VGND VPWR VPWR sky130_fd_sc_hd__decap_3
XTAP_TAPCELL_ROW_38_1180 VGND VPWR sky130_fd_sc_hd__tapvpwrvgnd_1
XTAP_TAPCELL_ROW_38_1191 VGND VPWR sky130_fd_sc_hd__tapvpwrvgnd_1
XFILLER_2_899 VGND VGND VPWR VPWR sky130_fd_sc_hd__decap_3
XFILLER_1_376 VGND VGND VPWR VPWR sky130_fd_sc_hd__decap_3
XFILLER_49_325 VGND VGND VPWR VPWR sky130_fd_sc_hd__decap_3
XTAP_TAPCELL_ROW_34_1077 VGND VPWR sky130_fd_sc_hd__tapvpwrvgnd_1
XFILLER_76_144 VGND VGND VPWR VPWR sky130_fd_sc_hd__fill_1
XTAP_TAPCELL_ROW_34_1088 VGND VPWR sky130_fd_sc_hd__tapvpwrvgnd_1
XFILLER_49_369 VGND VGND VPWR VPWR sky130_fd_sc_hd__fill_2
XFILLER_40_1032 VGND VGND VPWR VPWR sky130_fd_sc_hd__decap_3
XFILLER_79_1231 VGND VGND VPWR VPWR sky130_fd_sc_hd__fill_1
XFILLER_79_1242 VGND VGND VPWR VPWR sky130_fd_sc_hd__decap_3
Xhold1390 _6548_/Q VGND VGND VPWR VPWR _5436_/A1 sky130_fd_sc_hd__dlygate4sd3_1
XFILLER_57_391 VGND VGND VPWR VPWR sky130_fd_sc_hd__fill_1
XFILLER_79_1275 VGND VGND VPWR VPWR sky130_fd_sc_hd__decap_3
XFILLER_27_81 VGND VGND VPWR VPWR sky130_fd_sc_hd__fill_1
XTAP_TAPCELL_ROW_47_1416 VGND VPWR sky130_fd_sc_hd__tapvpwrvgnd_1
XFILLER_75_1117 VGND VGND VPWR VPWR sky130_fd_sc_hd__decap_3
XTAP_TAPCELL_ROW_47_1427 VGND VPWR sky130_fd_sc_hd__tapvpwrvgnd_1
XFILLER_75_1139 VGND VGND VPWR VPWR sky130_fd_sc_hd__decap_3
XFILLER_53_1404 VGND VGND VPWR VPWR sky130_fd_sc_hd__decap_3
XFILLER_60_578 VGND VGND VPWR VPWR sky130_fd_sc_hd__fill_1
XFILLER_60_589 VGND VGND VPWR VPWR sky130_fd_sc_hd__fill_1
XFILLER_53_1437 VGND VGND VPWR VPWR sky130_fd_sc_hd__decap_3
XFILLER_43_80 VGND VGND VPWR VPWR sky130_fd_sc_hd__decap_3
XFILLER_9_432 VGND VGND VPWR VPWR sky130_fd_sc_hd__decap_3
XFILLER_71_6 VGND VGND VPWR VPWR sky130_fd_sc_hd__decap_3
XFILLER_16_1270 VGND VGND VPWR VPWR sky130_fd_sc_hd__decap_3
XFILLER_12_1134 VGND VGND VPWR VPWR sky130_fd_sc_hd__decap_3
XFILLER_12_1189 VGND VGND VPWR VPWR sky130_fd_sc_hd__decap_3
XFILLER_5_660 VGND VGND VPWR VPWR sky130_fd_sc_hd__decap_3
X_4300_ _4386_/A _4300_/B _4586_/C VGND VGND VPWR VPWR _4300_/X sky130_fd_sc_hd__and3_2
X_5280_ _6773_/Q _5342_/S _5355_/S _5279_/Y VGND VGND VPWR VPWR _5280_/X sky130_fd_sc_hd__o211a_2
XFILLER_4_181 VGND VGND VPWR VPWR sky130_fd_sc_hd__decap_3
XFILLER_4_41 VGND VGND VPWR VPWR sky130_fd_sc_hd__decap_3
X_4231_ _4231_/A _4315_/A VGND VGND VPWR VPWR _4233_/A sky130_fd_sc_hd__xnor2_2
XFILLER_4_74 VGND VGND VPWR VPWR sky130_fd_sc_hd__decap_3
XFILLER_4_85 VGND VGND VPWR VPWR sky130_fd_sc_hd__decap_3
X_4162_ _4162_/A _4162_/B VGND VGND VPWR VPWR _4163_/B sky130_fd_sc_hd__xnor2_2
XFILLER_68_645 VGND VGND VPWR VPWR sky130_fd_sc_hd__fill_1
XFILLER_67_122 VGND VGND VPWR VPWR sky130_fd_sc_hd__decap_3
X_3113_ _6946_/Q _6954_/Q _6075_/S VGND VGND VPWR VPWR _3113_/X sky130_fd_sc_hd__mux2_1
XFILLER_56_807 VGND VGND VPWR VPWR sky130_fd_sc_hd__decap_3
XFILLER_7_1460 VGND VGND VPWR VPWR sky130_fd_sc_hd__decap_3
X_4093_ _6245_/Q wire77/X _4091_/X _4092_/X VGND VGND VPWR VPWR _6245_/D sky130_fd_sc_hd__o22a_2
XFILLER_23_1230 VGND VGND VPWR VPWR sky130_fd_sc_hd__fill_2
XFILLER_3_1313 VGND VGND VPWR VPWR sky130_fd_sc_hd__decap_3
XFILLER_23_1263 VGND VGND VPWR VPWR sky130_fd_sc_hd__decap_3
X_3044_ _3044_/A VGND VGND VPWR VPWR _5569_/A sky130_fd_sc_hd__inv_2
XFILLER_3_1357 VGND VGND VPWR VPWR sky130_fd_sc_hd__decap_3
XFILLER_64_851 VGND VGND VPWR VPWR sky130_fd_sc_hd__fill_2
XFILLER_36_553 VGND VGND VPWR VPWR sky130_fd_sc_hd__decap_3
XFILLER_70_309 VGND VGND VPWR VPWR sky130_fd_sc_hd__decap_3
XFILLER_58_1315 VGND VGND VPWR VPWR sky130_fd_sc_hd__fill_1
XFILLER_58_1326 VGND VGND VPWR VPWR sky130_fd_sc_hd__decap_3
XFILLER_58_1359 VGND VGND VPWR VPWR sky130_fd_sc_hd__decap_3
X_6803_ _6807_/CLK _6803_/D fanout787/X VGND VGND VPWR VPWR _6803_/Q sky130_fd_sc_hd__dfrtp_2
XFILLER_23_225 VGND VGND VPWR VPWR sky130_fd_sc_hd__fill_2
XFILLER_51_534 VGND VGND VPWR VPWR sky130_fd_sc_hd__decap_3
XFILLER_1_1092 VGND VGND VPWR VPWR sky130_fd_sc_hd__decap_3
X_4995_ _6389_/Q _5237_/B VGND VGND VPWR VPWR _4995_/X sky130_fd_sc_hd__or2_2
XFILLER_17_1001 VGND VGND VPWR VPWR sky130_fd_sc_hd__decap_3
X_6734_ _7046_/CLK _6734_/D load_slew744/X VGND VGND VPWR VPWR _6734_/Q sky130_fd_sc_hd__dfrtp_2
XFILLER_20_910 VGND VGND VPWR VPWR sky130_fd_sc_hd__decap_3
X_3946_ _6335_/Q wire339/A _3944_/X _3945_/X VGND VGND VPWR VPWR _4230_/B sky130_fd_sc_hd__o22a_2
XFILLER_32_792 VGND VGND VPWR VPWR sky130_fd_sc_hd__decap_3
X_6665_ _7089_/CLK _6665_/D wire734/X VGND VGND VPWR VPWR _6665_/Q sky130_fd_sc_hd__dfrtp_2
X_3877_ _3282_/X _4583_/B2 _3877_/B1 _6838_/Q _4092_/C1 VGND VGND VPWR VPWR _3877_/X
+ sky130_fd_sc_hd__a221o_2
XFILLER_20_976 VGND VGND VPWR VPWR sky130_fd_sc_hd__decap_3
X_5616_ _7066_/Q _7067_/Q VGND VGND VPWR VPWR _5731_/B sky130_fd_sc_hd__nand2_2
XTAP_TAPCELL_ROW_30_971 VGND VPWR sky130_fd_sc_hd__tapvpwrvgnd_1
X_6596_ _7001_/CLK _6596_/D fanout768/A VGND VGND VPWR VPWR _6596_/Q sky130_fd_sc_hd__dfrtp_2
XTAP_TAPCELL_ROW_30_982 VGND VPWR sky130_fd_sc_hd__tapvpwrvgnd_1
XTAP_TAPCELL_ROW_30_993 VGND VPWR sky130_fd_sc_hd__tapvpwrvgnd_1
XFILLER_69_1422 VGND VGND VPWR VPWR sky130_fd_sc_hd__decap_3
XFILLER_30_1256 VGND VGND VPWR VPWR sky130_fd_sc_hd__decap_3
XFILLER_30_1267 VGND VGND VPWR VPWR sky130_fd_sc_hd__decap_3
X_5547_ _6348_/Q _5566_/A2 _5547_/B1 _5566_/B2 VGND VGND VPWR VPWR _6630_/D sky130_fd_sc_hd__a22o_2
XFILLER_69_1455 VGND VGND VPWR VPWR sky130_fd_sc_hd__fill_1
XFILLER_69_1466 VGND VGND VPWR VPWR sky130_fd_sc_hd__decap_3
XFILLER_2_118 VGND VGND VPWR VPWR sky130_fd_sc_hd__decap_3
X_5478_ _5478_/A1 _5478_/A2 _4889_/X VGND VGND VPWR VPWR _6590_/D sky130_fd_sc_hd__a21o_2
XFILLER_65_1319 VGND VGND VPWR VPWR sky130_fd_sc_hd__decap_3
XFILLER_3_9 VGND VGND VPWR VPWR sky130_fd_sc_hd__decap_3
X_4429_ wire25/X _4480_/S VGND VGND VPWR VPWR _4429_/Y sky130_fd_sc_hd__nor2_2
Xfanout400 _4604_/A VGND VGND VPWR VPWR _4896_/C1 sky130_fd_sc_hd__clkdlybuf4s25_1
XFILLER_28_1141 VGND VGND VPWR VPWR sky130_fd_sc_hd__decap_3
Xfanout411 _4582_/A VGND VGND VPWR VPWR _4382_/C1 sky130_fd_sc_hd__clkdlybuf4s25_1
Xfanout422 _4318_/A VGND VGND VPWR VPWR _4283_/A sky130_fd_sc_hd__clkdlybuf4s25_1
XFILLER_8_1235 VGND VGND VPWR VPWR sky130_fd_sc_hd__decap_3
Xfanout433 wire437/A VGND VGND VPWR VPWR _5075_/A sky130_fd_sc_hd__clkdlybuf4s25_1
Xfanout444 _3948_/A2 VGND VGND VPWR VPWR _3960_/B sky130_fd_sc_hd__clkdlybuf4s25_1
Xfanout455 _3041_/Y VGND VGND VPWR VPWR _5508_/A sky130_fd_sc_hd__clkdlybuf4s25_1
XFILLER_63_1065 VGND VGND VPWR VPWR sky130_fd_sc_hd__fill_2
XFILLER_28_1196 VGND VGND VPWR VPWR sky130_fd_sc_hd__decap_3
Xfanout466 _4049_/A1 VGND VGND VPWR VPWR _4061_/A1 sky130_fd_sc_hd__clkdlybuf4s25_1
Xfanout477 fanout488/X VGND VGND VPWR VPWR _4680_/C1 sky130_fd_sc_hd__clkdlybuf4s25_1
XFILLER_8_1279 VGND VGND VPWR VPWR sky130_fd_sc_hd__decap_3
XFILLER_47_818 VGND VGND VPWR VPWR sky130_fd_sc_hd__decap_3
X_7079_ _7092_/CLK _7079_/D fanout682/X VGND VGND VPWR VPWR _7079_/Q sky130_fd_sc_hd__dfrtp_2
Xfanout488 _7090_/Q VGND VGND VPWR VPWR fanout488/X sky130_fd_sc_hd__clkdlybuf4s25_1
Xfanout499 _4773_/A2 VGND VGND VPWR VPWR _4832_/A2 sky130_fd_sc_hd__clkdlybuf4s25_1
XFILLER_41_1363 VGND VGND VPWR VPWR sky130_fd_sc_hd__decap_3
XFILLER_39_391 VGND VGND VPWR VPWR sky130_fd_sc_hd__fill_1
XFILLER_64_24 VGND VGND VPWR VPWR sky130_fd_sc_hd__decap_3
XFILLER_41_1396 VGND VGND VPWR VPWR sky130_fd_sc_hd__decap_3
XFILLER_64_35 VGND VGND VPWR VPWR sky130_fd_sc_hd__decap_3
XFILLER_76_1415 VGND VGND VPWR VPWR sky130_fd_sc_hd__decap_3
XFILLER_73_169 VGND VGND VPWR VPWR sky130_fd_sc_hd__decap_3
XFILLER_15_726 VGND VGND VPWR VPWR sky130_fd_sc_hd__fill_2
XFILLER_27_586 VGND VGND VPWR VPWR sky130_fd_sc_hd__decap_3
XFILLER_64_68 VGND VGND VPWR VPWR sky130_fd_sc_hd__decap_3
XFILLER_76_1459 VGND VGND VPWR VPWR sky130_fd_sc_hd__decap_3
XFILLER_42_523 VGND VGND VPWR VPWR sky130_fd_sc_hd__decap_3
XFILLER_15_759 VGND VGND VPWR VPWR sky130_fd_sc_hd__decap_3
XFILLER_70_865 VGND VGND VPWR VPWR sky130_fd_sc_hd__decap_3
XFILLER_14_247 VGND VGND VPWR VPWR sky130_fd_sc_hd__decap_3
XFILLER_42_567 VGND VGND VPWR VPWR sky130_fd_sc_hd__decap_3
XFILLER_80_12 VGND VGND VPWR VPWR sky130_fd_sc_hd__decap_3
XFILLER_74_1161 VGND VGND VPWR VPWR sky130_fd_sc_hd__decap_3
XFILLER_39_1281 VGND VGND VPWR VPWR sky130_fd_sc_hd__decap_3
XTAP_TAPCELL_ROW_42_1302 VGND VPWR sky130_fd_sc_hd__tapvpwrvgnd_1
XFILLER_70_1003 VGND VGND VPWR VPWR sky130_fd_sc_hd__decap_3
XFILLER_70_898 VGND VGND VPWR VPWR sky130_fd_sc_hd__decap_3
Xfanout40 fanout47/X VGND VGND VPWR VPWR _4883_/B1 sky130_fd_sc_hd__clkdlybuf4s25_1
XFILLER_42_589 VGND VGND VPWR VPWR sky130_fd_sc_hd__fill_2
Xfanout51 _4775_/A2 VGND VGND VPWR VPWR wire52/A sky130_fd_sc_hd__clkdlybuf4s25_1
XFILLER_23_770 VGND VGND VPWR VPWR sky130_fd_sc_hd__decap_3
XFILLER_39_1292 VGND VGND VPWR VPWR sky130_fd_sc_hd__decap_3
Xfanout62 _4759_/A2 VGND VGND VPWR VPWR wire63/A sky130_fd_sc_hd__clkdlybuf4s25_1
XFILLER_74_1194 VGND VGND VPWR VPWR sky130_fd_sc_hd__decap_3
XFILLER_35_1145 VGND VGND VPWR VPWR sky130_fd_sc_hd__decap_3
Xfanout73 _3490_/X VGND VGND VPWR VPWR _4068_/C1 sky130_fd_sc_hd__clkdlybuf4s25_1
XFILLER_11_943 VGND VGND VPWR VPWR sky130_fd_sc_hd__decap_3
XFILLER_70_1058 VGND VGND VPWR VPWR sky130_fd_sc_hd__decap_3
XFILLER_11_965 VGND VGND VPWR VPWR sky130_fd_sc_hd__decap_3
XFILLER_31_1009 VGND VGND VPWR VPWR sky130_fd_sc_hd__decap_3
XFILLER_13_1410 VGND VGND VPWR VPWR sky130_fd_sc_hd__decap_3
XFILLER_6_413 VGND VGND VPWR VPWR sky130_fd_sc_hd__decap_3
XFILLER_13_1443 VGND VGND VPWR VPWR sky130_fd_sc_hd__decap_3
XFILLER_13_83 VGND VGND VPWR VPWR sky130_fd_sc_hd__fill_2
XFILLER_10_475 VGND VGND VPWR VPWR sky130_fd_sc_hd__fill_1
XFILLER_6_424 VGND VGND VPWR VPWR sky130_fd_sc_hd__decap_3
XFILLER_6_446 VGND VGND VPWR VPWR sky130_fd_sc_hd__decap_3
XTAP_TAPCELL_ROW_36_1128 VGND VPWR sky130_fd_sc_hd__tapvpwrvgnd_1
XTAP_TAPCELL_ROW_36_1139 VGND VPWR sky130_fd_sc_hd__tapvpwrvgnd_1
XFILLER_1_140 VGND VGND VPWR VPWR sky130_fd_sc_hd__decap_3
XFILLER_2_663 VGND VGND VPWR VPWR sky130_fd_sc_hd__decap_3
XFILLER_46_1241 VGND VGND VPWR VPWR sky130_fd_sc_hd__decap_3
XFILLER_2_696 VGND VGND VPWR VPWR sky130_fd_sc_hd__decap_3
XFILLER_1_184 VGND VGND VPWR VPWR sky130_fd_sc_hd__decap_3
XFILLER_46_1285 VGND VGND VPWR VPWR sky130_fd_sc_hd__decap_3
XFILLER_42_1127 VGND VGND VPWR VPWR sky130_fd_sc_hd__decap_3
XFILLER_42_1149 VGND VGND VPWR VPWR sky130_fd_sc_hd__decap_3
XFILLER_65_604 VGND VGND VPWR VPWR sky130_fd_sc_hd__decap_3
XFILLER_37_317 VGND VGND VPWR VPWR sky130_fd_sc_hd__decap_3
XFILLER_20_1403 VGND VGND VPWR VPWR sky130_fd_sc_hd__decap_3
XFILLER_64_125 VGND VGND VPWR VPWR sky130_fd_sc_hd__decap_3
XFILLER_80_607 VGND VGND VPWR VPWR sky130_fd_sc_hd__decap_3
XFILLER_20_1447 VGND VGND VPWR VPWR sky130_fd_sc_hd__decap_3
XFILLER_79_1061 VGND VGND VPWR VPWR sky130_fd_sc_hd__decap_3
XFILLER_18_564 VGND VGND VPWR VPWR sky130_fd_sc_hd__decap_3
XFILLER_52_309 VGND VGND VPWR VPWR sky130_fd_sc_hd__fill_1
XFILLER_33_501 VGND VGND VPWR VPWR sky130_fd_sc_hd__decap_3
XFILLER_79_1094 VGND VGND VPWR VPWR sky130_fd_sc_hd__decap_3
XFILLER_33_556 VGND VGND VPWR VPWR sky130_fd_sc_hd__decap_3
XFILLER_61_865 VGND VGND VPWR VPWR sky130_fd_sc_hd__decap_3
XFILLER_33_567 VGND VGND VPWR VPWR sky130_fd_sc_hd__fill_2
XFILLER_21_718 VGND VGND VPWR VPWR sky130_fd_sc_hd__decap_3
X_3800_ _6338_/Q _3807_/A2 _3798_/X _3799_/X VGND VGND VPWR VPWR _4302_/A sky130_fd_sc_hd__o22a_2
XFILLER_18_1332 VGND VGND VPWR VPWR sky130_fd_sc_hd__decap_3
XFILLER_21_729 VGND VGND VPWR VPWR sky130_fd_sc_hd__decap_3
X_4780_ _6255_/Q _5358_/D _3432_/X _4780_/B2 VGND VGND VPWR VPWR _4780_/X sky130_fd_sc_hd__a22o_2
XFILLER_57_1381 VGND VGND VPWR VPWR sky130_fd_sc_hd__decap_3
XFILLER_18_1365 VGND VGND VPWR VPWR sky130_fd_sc_hd__decap_3
X_3731_ _4111_/A _4303_/A VGND VGND VPWR VPWR _3739_/A sky130_fd_sc_hd__xnor2_2
XFILLER_53_1245 VGND VGND VPWR VPWR sky130_fd_sc_hd__decap_3
XFILLER_18_1376 VGND VGND VPWR VPWR sky130_fd_sc_hd__decap_3
XFILLER_9_240 VGND VGND VPWR VPWR sky130_fd_sc_hd__decap_3
XFILLER_14_1229 VGND VGND VPWR VPWR sky130_fd_sc_hd__decap_3
XFILLER_53_1278 VGND VGND VPWR VPWR sky130_fd_sc_hd__decap_3
XFILLER_53_1289 VGND VGND VPWR VPWR sky130_fd_sc_hd__decap_3
X_3662_ _3673_/A _3649_/B _3671_/A VGND VGND VPWR VPWR _3702_/B sky130_fd_sc_hd__o21ai_2
X_6450_ _7020_/CLK _6450_/D load_slew808/X VGND VGND VPWR VPWR _6450_/Q sky130_fd_sc_hd__dfrtp_2
XFILLER_9_284 VGND VGND VPWR VPWR sky130_fd_sc_hd__decap_3
Xclkload10 _6925_/CLK VGND VGND VPWR VPWR clkload10/X sky130_fd_sc_hd__clkbuf_8
Xclkload21 _7072_/CLK VGND VGND VPWR VPWR clkload21/X sky130_fd_sc_hd__clkbuf_4
Xclkload32 _7064_/CLK VGND VGND VPWR VPWR clkload32/X sky130_fd_sc_hd__clkbuf_4
X_5401_ _5401_/A1 _5465_/A2 _4440_/X VGND VGND VPWR VPWR _6513_/D sky130_fd_sc_hd__a21o_2
XTAP_TAPCELL_ROW_11_481 VGND VPWR sky130_fd_sc_hd__tapvpwrvgnd_1
X_6381_ _7004_/CLK _6381_/D fanout839/X VGND VGND VPWR VPWR _6381_/Q sky130_fd_sc_hd__dfrtp_2
XTAP_TAPCELL_ROW_11_492 VGND VPWR sky130_fd_sc_hd__tapvpwrvgnd_1
Xclkload43 _7015_/CLK VGND VGND VPWR VPWR clkload43/X sky130_fd_sc_hd__clkbuf_4
X_3593_ _5514_/A _3593_/B VGND VGND VPWR VPWR _3593_/X sky130_fd_sc_hd__or2_2
Xclkload54 _7060_/CLK VGND VGND VPWR VPWR clkload54/X sky130_fd_sc_hd__clkbuf_4
X_5332_ _6797_/Q _5036_/B _5332_/S VGND VGND VPWR VPWR _5332_/X sky130_fd_sc_hd__mux2_1
X_5263_ _6429_/Q _5263_/A2 _5262_/X VGND VGND VPWR VPWR _6429_/D sky130_fd_sc_hd__a21o_2
XFILLER_64_1341 VGND VGND VPWR VPWR sky130_fd_sc_hd__decap_3
X_4214_ _4793_/A _4209_/X _4213_/X VGND VGND VPWR VPWR _4214_/X sky130_fd_sc_hd__o21a_2
X_7002_ _7034_/CLK _7002_/D fanout675/X VGND VGND VPWR VPWR _7002_/Q sky130_fd_sc_hd__dfrtp_2
X_5194_ _6744_/Q _5194_/B VGND VGND VPWR VPWR _5194_/Y sky130_fd_sc_hd__nor2_2
XFILLER_25_1325 VGND VGND VPWR VPWR sky130_fd_sc_hd__decap_3
XFILLER_64_1385 VGND VGND VPWR VPWR sky130_fd_sc_hd__decap_3
XFILLER_5_1419 VGND VGND VPWR VPWR sky130_fd_sc_hd__decap_3
X_4145_ _6475_/Q _4174_/A2 _4597_/A _4144_/X VGND VGND VPWR VPWR _4145_/X sky130_fd_sc_hd__o211a_2
XFILLER_60_1238 VGND VGND VPWR VPWR sky130_fd_sc_hd__decap_3
XFILLER_25_1369 VGND VGND VPWR VPWR sky130_fd_sc_hd__decap_3
XFILLER_69_998 VGND VGND VPWR VPWR sky130_fd_sc_hd__fill_2
XFILLER_3_1110 VGND VGND VPWR VPWR sky130_fd_sc_hd__decap_3
XFILLER_3_1121 VGND VGND VPWR VPWR sky130_fd_sc_hd__decap_3
XFILLER_55_125 VGND VGND VPWR VPWR sky130_fd_sc_hd__fill_1
XFILLER_56_648 VGND VGND VPWR VPWR sky130_fd_sc_hd__decap_3
X_4076_ _5512_/A _3717_/A _5588_/A3 _5515_/A1 _6595_/Q VGND VGND VPWR VPWR _4076_/X
+ sky130_fd_sc_hd__a32o_2
XFILLER_23_1071 VGND VGND VPWR VPWR sky130_fd_sc_hd__fill_1
XFILLER_3_1154 VGND VGND VPWR VPWR sky130_fd_sc_hd__decap_3
XFILLER_23_1093 VGND VGND VPWR VPWR sky130_fd_sc_hd__decap_3
XFILLER_37_873 VGND VGND VPWR VPWR sky130_fd_sc_hd__decap_3
XFILLER_36_361 VGND VGND VPWR VPWR sky130_fd_sc_hd__decap_3
XFILLER_37_895 VGND VGND VPWR VPWR sky130_fd_sc_hd__fill_1
XFILLER_3_1198 VGND VGND VPWR VPWR sky130_fd_sc_hd__decap_3
XFILLER_19_1107 VGND VGND VPWR VPWR sky130_fd_sc_hd__fill_1
XFILLER_52_843 VGND VGND VPWR VPWR sky130_fd_sc_hd__decap_3
XFILLER_24_545 VGND VGND VPWR VPWR sky130_fd_sc_hd__decap_3
XFILLER_54_1009 VGND VGND VPWR VPWR sky130_fd_sc_hd__decap_3
XFILLER_58_1178 VGND VGND VPWR VPWR sky130_fd_sc_hd__decap_3
XFILLER_52_887 VGND VGND VPWR VPWR sky130_fd_sc_hd__fill_2
XFILLER_71_1301 VGND VGND VPWR VPWR sky130_fd_sc_hd__decap_3
XFILLER_36_1421 VGND VGND VPWR VPWR sky130_fd_sc_hd__decap_3
XFILLER_24_589 VGND VGND VPWR VPWR sky130_fd_sc_hd__decap_3
XFILLER_36_1432 VGND VGND VPWR VPWR sky130_fd_sc_hd__decap_3
XFILLER_51_375 VGND VGND VPWR VPWR sky130_fd_sc_hd__decap_3
X_4978_ _6354_/Q _4977_/X _4978_/S VGND VGND VPWR VPWR _6354_/D sky130_fd_sc_hd__mux2_1
XFILLER_71_1334 VGND VGND VPWR VPWR sky130_fd_sc_hd__decap_3
XFILLER_11_228 VGND VGND VPWR VPWR sky130_fd_sc_hd__fill_2
XFILLER_71_1345 VGND VGND VPWR VPWR sky130_fd_sc_hd__decap_3
XFILLER_36_1465 VGND VGND VPWR VPWR sky130_fd_sc_hd__decap_3
X_6717_ _7034_/CLK _6717_/D load_slew671/X VGND VGND VPWR VPWR _6717_/Q sky130_fd_sc_hd__dfrtp_2
X_3929_ _6245_/Q _4740_/B _3927_/X _3928_/X VGND VGND VPWR VPWR _4327_/A sky130_fd_sc_hd__o22a_2
Xclkload4 clkload4/A VGND VGND VPWR VPWR clkload4/X sky130_fd_sc_hd__clkbuf_8
XFILLER_71_1378 VGND VGND VPWR VPWR sky130_fd_sc_hd__decap_3
XTAP_TAPCELL_ROW_22_768 VGND VPWR sky130_fd_sc_hd__tapvpwrvgnd_1
XFILLER_32_1329 VGND VGND VPWR VPWR sky130_fd_sc_hd__decap_3
XTAP_TAPCELL_ROW_22_779 VGND VPWR sky130_fd_sc_hd__tapvpwrvgnd_1
X_6648_ _6888_/CLK _6648_/D fanout713/X VGND VGND VPWR VPWR _6648_/Q sky130_fd_sc_hd__dfrtp_2
XFILLER_20_795 VGND VGND VPWR VPWR sky130_fd_sc_hd__decap_3
XFILLER_30_1020 VGND VGND VPWR VPWR sky130_fd_sc_hd__fill_1
XFILLER_4_906 VGND VGND VPWR VPWR sky130_fd_sc_hd__decap_3
XTAP_TAPCELL_ROW_76_2165 VGND VPWR sky130_fd_sc_hd__tapvpwrvgnd_1
X_6579_ _6925_/CLK _6579_/D load_slew658/X VGND VGND VPWR VPWR _6579_/Q sky130_fd_sc_hd__dfrtp_2
XFILLER_3_405 VGND VGND VPWR VPWR sky130_fd_sc_hd__decap_3
XTAP_TAPCELL_ROW_76_2176 VGND VPWR sky130_fd_sc_hd__tapvpwrvgnd_1
XTAP_TAPCELL_ROW_76_2187 VGND VPWR sky130_fd_sc_hd__tapvpwrvgnd_1
XFILLER_69_1263 VGND VGND VPWR VPWR sky130_fd_sc_hd__decap_3
XFILLER_3_438 VGND VGND VPWR VPWR sky130_fd_sc_hd__decap_3
XFILLER_3_449 VGND VGND VPWR VPWR sky130_fd_sc_hd__decap_3
XFILLER_59_24 VGND VGND VPWR VPWR sky130_fd_sc_hd__decap_3
XFILLER_1_6 VGND VGND VPWR VPWR sky130_fd_sc_hd__decap_3
XFILLER_79_729 VGND VGND VPWR VPWR sky130_fd_sc_hd__decap_3
XFILLER_59_46 VGND VGND VPWR VPWR sky130_fd_sc_hd__decap_3
XFILLER_59_57 VGND VGND VPWR VPWR sky130_fd_sc_hd__decap_3
XFILLER_43_1425 VGND VGND VPWR VPWR sky130_fd_sc_hd__decap_3
Xfanout241 _5486_/A2 VGND VGND VPWR VPWR _5456_/A2 sky130_fd_sc_hd__clkdlybuf4s25_1
XFILLER_8_1043 VGND VGND VPWR VPWR sky130_fd_sc_hd__decap_3
XTAP_TAPCELL_ROW_31_1003 VGND VPWR sky130_fd_sc_hd__tapvpwrvgnd_1
Xfanout252 _5484_/A2 VGND VGND VPWR VPWR _5453_/A2 sky130_fd_sc_hd__clkdlybuf4s25_1
XTAP_TAPCELL_ROW_31_1014 VGND VPWR sky130_fd_sc_hd__tapvpwrvgnd_1
Xfanout263 _4645_/A VGND VGND VPWR VPWR _4564_/B sky130_fd_sc_hd__clkdlybuf4s25_1
XFILLER_75_913 VGND VGND VPWR VPWR sky130_fd_sc_hd__decap_3
XFILLER_75_12 VGND VGND VPWR VPWR sky130_fd_sc_hd__decap_3
Xfanout274 _3960_/Y VGND VGND VPWR VPWR fanout274/X sky130_fd_sc_hd__clkdlybuf4s25_1
XFILLER_59_464 VGND VGND VPWR VPWR sky130_fd_sc_hd__fill_1
Xfanout285 fanout304/X VGND VGND VPWR VPWR _4833_/A2 sky130_fd_sc_hd__clkdlybuf4s25_1
Xfanout296 fanout298/X VGND VGND VPWR VPWR _4805_/A2 sky130_fd_sc_hd__clkdlybuf4s25_1
XFILLER_46_114 VGND VGND VPWR VPWR sky130_fd_sc_hd__decap_3
XFILLER_28_840 VGND VGND VPWR VPWR sky130_fd_sc_hd__decap_3
Xload_slew38 _4891_/B1 VGND VGND VPWR VPWR _4606_/B1 sky130_fd_sc_hd__buf_4
XFILLER_27_361 VGND VGND VPWR VPWR sky130_fd_sc_hd__decap_3
XFILLER_28_884 VGND VGND VPWR VPWR sky130_fd_sc_hd__decap_3
XFILLER_76_1223 VGND VGND VPWR VPWR sky130_fd_sc_hd__decap_3
XFILLER_43_821 VGND VGND VPWR VPWR sky130_fd_sc_hd__decap_3
XFILLER_15_534 VGND VGND VPWR VPWR sky130_fd_sc_hd__decap_3
XFILLER_76_1256 VGND VGND VPWR VPWR sky130_fd_sc_hd__decap_3
XFILLER_43_854 VGND VGND VPWR VPWR sky130_fd_sc_hd__decap_3
XFILLER_76_1267 VGND VGND VPWR VPWR sky130_fd_sc_hd__decap_3
XFILLER_15_567 VGND VGND VPWR VPWR sky130_fd_sc_hd__decap_3
XFILLER_43_887 VGND VGND VPWR VPWR sky130_fd_sc_hd__decap_3
XTAP_TAPCELL_ROW_65_1880 VGND VPWR sky130_fd_sc_hd__tapvpwrvgnd_1
XFILLER_30_526 VGND VGND VPWR VPWR sky130_fd_sc_hd__decap_3
XTAP_TAPCELL_ROW_65_1891 VGND VPWR sky130_fd_sc_hd__tapvpwrvgnd_1
XFILLER_30_559 VGND VGND VPWR VPWR sky130_fd_sc_hd__decap_3
XFILLER_11_751 VGND VGND VPWR VPWR sky130_fd_sc_hd__decap_3
XFILLER_50_1418 VGND VGND VPWR VPWR sky130_fd_sc_hd__decap_3
XTAP_TAPCELL_ROW_61_1777 VGND VPWR sky130_fd_sc_hd__tapvpwrvgnd_1
XFILLER_7_711 VGND VGND VPWR VPWR sky130_fd_sc_hd__decap_3
XFILLER_50_1429 VGND VGND VPWR VPWR sky130_fd_sc_hd__decap_3
XTAP_TAPCELL_ROW_61_1788 VGND VPWR sky130_fd_sc_hd__tapvpwrvgnd_1
XTAP_TAPCELL_ROW_61_1799 VGND VPWR sky130_fd_sc_hd__tapvpwrvgnd_1
XFILLER_13_1251 VGND VGND VPWR VPWR sky130_fd_sc_hd__decap_3
XFILLER_7_788 VGND VGND VPWR VPWR sky130_fd_sc_hd__decap_3
XFILLER_13_1284 VGND VGND VPWR VPWR sky130_fd_sc_hd__decap_3
XFILLER_13_1295 VGND VGND VPWR VPWR sky130_fd_sc_hd__decap_3
XFILLER_6_287 VGND VGND VPWR VPWR sky130_fd_sc_hd__decap_3
XFILLER_48_1303 VGND VGND VPWR VPWR sky130_fd_sc_hd__decap_3
XFILLER_48_1347 VGND VGND VPWR VPWR sky130_fd_sc_hd__decap_3
XFILLER_3_983 VGND VGND VPWR VPWR sky130_fd_sc_hd__fill_1
Xload_slew625 _5688_/A1 VGND VGND VPWR VPWR _5900_/A0 sky130_fd_sc_hd__clkbuf_4
XFILLER_34_6 VGND VGND VPWR VPWR sky130_fd_sc_hd__decap_3
XFILLER_2_482 VGND VGND VPWR VPWR sky130_fd_sc_hd__decap_3
Xload_slew658 fanout657/X VGND VGND VPWR VPWR load_slew658/X sky130_fd_sc_hd__clkbuf_4
XFILLER_78_751 VGND VGND VPWR VPWR sky130_fd_sc_hd__decap_3
Xload_slew669 fanout668/X VGND VGND VPWR VPWR load_slew669/X sky130_fd_sc_hd__buf_4
XFILLER_66_913 VGND VGND VPWR VPWR sky130_fd_sc_hd__decap_3
XFILLER_1_42 VGND VGND VPWR VPWR sky130_fd_sc_hd__decap_3
XFILLER_4_1441 VGND VGND VPWR VPWR sky130_fd_sc_hd__decap_3
XFILLER_37_136 VGND VGND VPWR VPWR sky130_fd_sc_hd__decap_3
XFILLER_66_968 VGND VGND VPWR VPWR sky130_fd_sc_hd__decap_3
XFILLER_19_851 VGND VGND VPWR VPWR sky130_fd_sc_hd__fill_1
XFILLER_20_1222 VGND VGND VPWR VPWR sky130_fd_sc_hd__decap_3
XFILLER_24_1391 VGND VGND VPWR VPWR sky130_fd_sc_hd__decap_3
XFILLER_65_456 VGND VGND VPWR VPWR sky130_fd_sc_hd__fill_1
XFILLER_1_75 VGND VGND VPWR VPWR sky130_fd_sc_hd__decap_3
XFILLER_65_467 VGND VGND VPWR VPWR sky130_fd_sc_hd__decap_3
XFILLER_37_169 VGND VGND VPWR VPWR sky130_fd_sc_hd__decap_3
XFILLER_59_1410 VGND VGND VPWR VPWR sky130_fd_sc_hd__decap_3
XFILLER_80_415 VGND VGND VPWR VPWR sky130_fd_sc_hd__decap_3
XFILLER_20_1255 VGND VGND VPWR VPWR sky130_fd_sc_hd__decap_3
X_5950_ _5950_/A0 _5950_/A1 _6046_/S VGND VGND VPWR VPWR _6954_/D sky130_fd_sc_hd__mux2_1
XFILLER_0_1338 VGND VGND VPWR VPWR sky130_fd_sc_hd__decap_3
XFILLER_19_895 VGND VGND VPWR VPWR sky130_fd_sc_hd__fill_1
XFILLER_59_1443 VGND VGND VPWR VPWR sky130_fd_sc_hd__decap_3
XFILLER_18_383 VGND VGND VPWR VPWR sky130_fd_sc_hd__fill_2
XFILLER_20_1288 VGND VGND VPWR VPWR sky130_fd_sc_hd__decap_3
XFILLER_52_139 VGND VGND VPWR VPWR sky130_fd_sc_hd__fill_1
X_4901_ _7081_/Q _5354_/S _3483_/B VGND VGND VPWR VPWR _4901_/Y sky130_fd_sc_hd__o21ai_2
X_5881_ _5908_/A0 _5881_/A1 _5887_/S VGND VGND VPWR VPWR _6891_/D sky130_fd_sc_hd__mux2_1
XFILLER_33_331 VGND VGND VPWR VPWR sky130_fd_sc_hd__decap_3
XFILLER_55_1307 VGND VGND VPWR VPWR sky130_fd_sc_hd__decap_3
X_4832_ _6286_/Q _4832_/A2 _3446_/X _4832_/B2 VGND VGND VPWR VPWR _4832_/X sky130_fd_sc_hd__a22o_2
XFILLER_61_684 VGND VGND VPWR VPWR sky130_fd_sc_hd__decap_3
XFILLER_21_526 VGND VGND VPWR VPWR sky130_fd_sc_hd__decap_3
XFILLER_60_194 VGND VGND VPWR VPWR sky130_fd_sc_hd__fill_2
XFILLER_18_1173 VGND VGND VPWR VPWR sky130_fd_sc_hd__decap_3
X_4763_ _4762_/B _4163_/B _4762_/Y _4763_/C1 VGND VGND VPWR VPWR _4763_/Y sky130_fd_sc_hd__o211ai_2
X_6502_ _7000_/CLK _6502_/D fanout721/X VGND VGND VPWR VPWR _6502_/Q sky130_fd_sc_hd__dfrtp_2
XFILLER_14_1037 VGND VGND VPWR VPWR sky130_fd_sc_hd__decap_3
X_3714_ _4428_/A _4547_/B VGND VGND VPWR VPWR _4760_/A sky130_fd_sc_hd__nand2_2
X_4694_ _4723_/B _4694_/B _4694_/C VGND VGND VPWR VPWR _4694_/X sky130_fd_sc_hd__and3_2
XFILLER_53_1097 VGND VGND VPWR VPWR sky130_fd_sc_hd__decap_3
XFILLER_31_1340 VGND VGND VPWR VPWR sky130_fd_sc_hd__decap_3
X_6433_ _6900_/CLK _6433_/D fanout830/X VGND VGND VPWR VPWR _6433_/Q sky130_fd_sc_hd__dfrtp_2
XFILLER_31_1351 VGND VGND VPWR VPWR sky130_fd_sc_hd__decap_3
X_3645_ _3645_/A _3673_/B VGND VGND VPWR VPWR _3646_/B sky130_fd_sc_hd__xnor2_2
XFILLER_20_18 VGND VGND VPWR VPWR sky130_fd_sc_hd__decap_3
XFILLER_31_1384 VGND VGND VPWR VPWR sky130_fd_sc_hd__decap_3
XFILLER_66_1403 VGND VGND VPWR VPWR sky130_fd_sc_hd__decap_3
X_3576_ _3670_/A _3576_/B _3576_/C VGND VGND VPWR VPWR _3579_/B sky130_fd_sc_hd__nand3_2
X_6364_ _7046_/CLK _6364_/D load_slew744/X VGND VGND VPWR VPWR _6364_/Q sky130_fd_sc_hd__dfrtp_2
XFILLER_1_909 VGND VGND VPWR VPWR sky130_fd_sc_hd__decap_3
X_5315_ _6450_/Q _5314_/X _5321_/S VGND VGND VPWR VPWR _6450_/D sky130_fd_sc_hd__mux2_1
XFILLER_66_1447 VGND VGND VPWR VPWR sky130_fd_sc_hd__decap_3
XTAP_TAPCELL_ROW_71_2040 VGND VPWR sky130_fd_sc_hd__tapvpwrvgnd_1
XFILLER_0_408 VGND VGND VPWR VPWR sky130_fd_sc_hd__decap_3
X_6295_ _6865_/CLK _6295_/D wire712/X VGND VGND VPWR VPWR _6295_/Q sky130_fd_sc_hd__dfrtp_2
XTAP_TAPCELL_ROW_71_2051 VGND VPWR sky130_fd_sc_hd__tapvpwrvgnd_1
X_5246_ _5326_/S _5246_/B VGND VGND VPWR VPWR _5246_/Y sky130_fd_sc_hd__nand2_2
XFILLER_9_1363 VGND VGND VPWR VPWR sky130_fd_sc_hd__decap_3
X_5177_ _6397_/Q wire112/X _5055_/S _5176_/X VGND VGND VPWR VPWR _6397_/D sky130_fd_sc_hd__a22o_2
XFILLER_5_1216 VGND VGND VPWR VPWR sky130_fd_sc_hd__decap_3
XFILLER_29_615 VGND VGND VPWR VPWR sky130_fd_sc_hd__fill_1
XFILLER_60_1035 VGND VGND VPWR VPWR sky130_fd_sc_hd__fill_1
XFILLER_9_1396 VGND VGND VPWR VPWR sky130_fd_sc_hd__decap_3
XFILLER_56_401 VGND VGND VPWR VPWR sky130_fd_sc_hd__decap_3
XFILLER_29_626 VGND VGND VPWR VPWR sky130_fd_sc_hd__decap_3
XFILLER_60_1046 VGND VGND VPWR VPWR sky130_fd_sc_hd__fill_1
XFILLER_28_114 VGND VGND VPWR VPWR sky130_fd_sc_hd__fill_2
X_4128_ _6474_/Q _4562_/B _4265_/B VGND VGND VPWR VPWR _4128_/X sky130_fd_sc_hd__mux2_1
XFILLER_60_1079 VGND VGND VPWR VPWR sky130_fd_sc_hd__decap_3
XTAP_TAPCELL_ROW_3_268 VGND VPWR sky130_fd_sc_hd__tapvpwrvgnd_1
XTAP_TAPCELL_ROW_3_279 VGND VPWR sky130_fd_sc_hd__tapvpwrvgnd_1
XFILLER_16_309 VGND VGND VPWR VPWR sky130_fd_sc_hd__decap_3
XFILLER_44_618 VGND VGND VPWR VPWR sky130_fd_sc_hd__decap_3
XFILLER_44_629 VGND VGND VPWR VPWR sky130_fd_sc_hd__decap_3
X_4059_ _4747_/A _4059_/B VGND VGND VPWR VPWR _4059_/Y sky130_fd_sc_hd__nor2_2
XTAP_TAPCELL_ROW_80_2309 VGND VPWR sky130_fd_sc_hd__tapvpwrvgnd_1
XFILLER_71_437 VGND VGND VPWR VPWR sky130_fd_sc_hd__decap_3
XFILLER_43_139 VGND VGND VPWR VPWR sky130_fd_sc_hd__decap_3
XFILLER_36_180 VGND VGND VPWR VPWR sky130_fd_sc_hd__decap_3
XFILLER_73_1407 VGND VGND VPWR VPWR sky130_fd_sc_hd__decap_3
XFILLER_52_640 VGND VGND VPWR VPWR sky130_fd_sc_hd__decap_3
XFILLER_52_662 VGND VGND VPWR VPWR sky130_fd_sc_hd__fill_2
XFILLER_40_813 VGND VGND VPWR VPWR sky130_fd_sc_hd__decap_3
XFILLER_12_515 VGND VGND VPWR VPWR sky130_fd_sc_hd__fill_2
XFILLER_24_397 VGND VGND VPWR VPWR sky130_fd_sc_hd__decap_3
XFILLER_36_1240 VGND VGND VPWR VPWR sky130_fd_sc_hd__decap_3
XFILLER_51_183 VGND VGND VPWR VPWR sky130_fd_sc_hd__decap_3
XFILLER_71_1153 VGND VGND VPWR VPWR sky130_fd_sc_hd__decap_3
XFILLER_36_1273 VGND VGND VPWR VPWR sky130_fd_sc_hd__decap_3
XTAP_TAPCELL_ROW_78_2216 VGND VPWR sky130_fd_sc_hd__tapvpwrvgnd_1
XTAP_TAPCELL_ROW_78_2227 VGND VPWR sky130_fd_sc_hd__tapvpwrvgnd_1
XTAP_TAPCELL_ROW_78_2238 VGND VPWR sky130_fd_sc_hd__tapvpwrvgnd_1
XFILLER_71_1186 VGND VGND VPWR VPWR sky130_fd_sc_hd__decap_3
XFILLER_10_1424 VGND VGND VPWR VPWR sky130_fd_sc_hd__decap_3
XFILLER_10_1435 VGND VGND VPWR VPWR sky130_fd_sc_hd__decap_3
XFILLER_69_1060 VGND VGND VPWR VPWR sky130_fd_sc_hd__decap_3
XFILLER_10_1468 VGND VGND VPWR VPWR sky130_fd_sc_hd__fill_1
XFILLER_69_1071 VGND VGND VPWR VPWR sky130_fd_sc_hd__decap_3
XFILLER_10_73 VGND VGND VPWR VPWR sky130_fd_sc_hd__decap_3
XFILLER_79_526 VGND VGND VPWR VPWR sky130_fd_sc_hd__decap_3
XFILLER_0_931 VGND VGND VPWR VPWR sky130_fd_sc_hd__decap_3
XFILLER_0_953 VGND VGND VPWR VPWR sky130_fd_sc_hd__decap_3
XFILLER_48_902 VGND VGND VPWR VPWR sky130_fd_sc_hd__decap_3
XFILLER_43_1233 VGND VGND VPWR VPWR sky130_fd_sc_hd__decap_3
XFILLER_66_209 VGND VGND VPWR VPWR sky130_fd_sc_hd__fill_2
XTAP_TAPCELL_ROW_54_1592 VGND VPWR sky130_fd_sc_hd__tapvpwrvgnd_1
XFILLER_19_103 VGND VGND VPWR VPWR sky130_fd_sc_hd__decap_3
XFILLER_75_732 VGND VGND VPWR VPWR sky130_fd_sc_hd__decap_3
XFILLER_43_1266 VGND VGND VPWR VPWR sky130_fd_sc_hd__decap_3
XFILLER_47_423 VGND VGND VPWR VPWR sky130_fd_sc_hd__decap_3
XTAP_TAPCELL_ROW_50_1489 VGND VPWR sky130_fd_sc_hd__tapvpwrvgnd_1
XFILLER_75_776 VGND VGND VPWR VPWR sky130_fd_sc_hd__decap_3
XFILLER_47_467 VGND VGND VPWR VPWR sky130_fd_sc_hd__fill_2
XFILLER_78_1329 VGND VGND VPWR VPWR sky130_fd_sc_hd__decap_3
XFILLER_74_253 VGND VGND VPWR VPWR sky130_fd_sc_hd__fill_2
XFILLER_19_169 VGND VGND VPWR VPWR sky130_fd_sc_hd__decap_3
XTAP_TAPCELL_ROW_67_1931 VGND VPWR sky130_fd_sc_hd__tapvpwrvgnd_1
XTAP_TAPCELL_ROW_67_1942 VGND VPWR sky130_fd_sc_hd__tapvpwrvgnd_1
XTAP_TAPCELL_ROW_67_1953 VGND VPWR sky130_fd_sc_hd__tapvpwrvgnd_1
XFILLER_34_139 VGND VGND VPWR VPWR sky130_fd_sc_hd__fill_1
XFILLER_76_1064 VGND VGND VPWR VPWR sky130_fd_sc_hd__decap_3
XFILLER_43_662 VGND VGND VPWR VPWR sky130_fd_sc_hd__decap_3
XTAP_TAPCELL_ROW_63_1828 VGND VPWR sky130_fd_sc_hd__tapvpwrvgnd_1
XFILLER_16_887 VGND VGND VPWR VPWR sky130_fd_sc_hd__decap_3
XFILLER_43_673 VGND VGND VPWR VPWR sky130_fd_sc_hd__decap_3
XTAP_TAPCELL_ROW_63_1839 VGND VPWR sky130_fd_sc_hd__tapvpwrvgnd_1
XTAP_TAPCELL_ROW_26_871 VGND VPWR sky130_fd_sc_hd__tapvpwrvgnd_1
XFILLER_37_1037 VGND VGND VPWR VPWR sky130_fd_sc_hd__decap_3
XTAP_TAPCELL_ROW_26_882 VGND VPWR sky130_fd_sc_hd__tapvpwrvgnd_1
XFILLER_31_835 VGND VGND VPWR VPWR sky130_fd_sc_hd__decap_3
XFILLER_43_695 VGND VGND VPWR VPWR sky130_fd_sc_hd__fill_2
XFILLER_42_183 VGND VGND VPWR VPWR sky130_fd_sc_hd__fill_1
XFILLER_19_1460 VGND VGND VPWR VPWR sky130_fd_sc_hd__decap_3
XFILLER_42_194 VGND VGND VPWR VPWR sky130_fd_sc_hd__fill_2
XTAP_TAPCELL_ROW_13_532 VGND VPWR sky130_fd_sc_hd__tapvpwrvgnd_1
XTAP_TAPCELL_ROW_13_543 VGND VPWR sky130_fd_sc_hd__tapvpwrvgnd_1
XFILLER_15_1313 VGND VGND VPWR VPWR sky130_fd_sc_hd__decap_3
XFILLER_31_879 VGND VGND VPWR VPWR sky130_fd_sc_hd__decap_3
XFILLER_54_1362 VGND VGND VPWR VPWR sky130_fd_sc_hd__decap_3
XFILLER_54_1373 VGND VGND VPWR VPWR sky130_fd_sc_hd__decap_3
XFILLER_15_1357 VGND VGND VPWR VPWR sky130_fd_sc_hd__decap_3
XFILLER_50_1237 VGND VGND VPWR VPWR sky130_fd_sc_hd__decap_3
XFILLER_7_530 VGND VGND VPWR VPWR sky130_fd_sc_hd__fill_1
XFILLER_11_592 VGND VGND VPWR VPWR sky130_fd_sc_hd__decap_3
XFILLER_7_541 VGND VGND VPWR VPWR sky130_fd_sc_hd__decap_3
XFILLER_7_596 VGND VGND VPWR VPWR sky130_fd_sc_hd__decap_3
X_3430_ _6326_/Q _6446_/Q VGND VGND VPWR VPWR _3430_/X sky130_fd_sc_hd__xor2_2
X_3361_ _6001_/A0 _3360_/X _3425_/S VGND VGND VPWR VPWR _6154_/D sky130_fd_sc_hd__mux2_1
XFILLER_48_1155 VGND VGND VPWR VPWR sky130_fd_sc_hd__decap_3
XPHY_EDGE_ROW_29_Left_110 VGND VGND VPWR VPWR sky130_fd_sc_hd__decap_3
X_5100_ _6371_/Q _5099_/X _5123_/A _6709_/Q VGND VGND VPWR VPWR _5100_/X sky130_fd_sc_hd__a2bb2o_2
XFILLER_44_1008 VGND VGND VPWR VPWR sky130_fd_sc_hd__decap_3
XFILLER_3_791 VGND VGND VPWR VPWR sky130_fd_sc_hd__decap_3
XFILLER_32_3 VGND VGND VPWR VPWR sky130_fd_sc_hd__decap_3
X_6080_ _6081_/A _6079_/X _6078_/X VGND VGND VPWR VPWR _7076_/D sky130_fd_sc_hd__o21a_2
X_3292_ _6273_/Q _6377_/Q VGND VGND VPWR VPWR _3292_/X sky130_fd_sc_hd__xor2_2
X_5031_ _6394_/Q _5252_/B _5031_/B1 VGND VGND VPWR VPWR _5031_/Y sky130_fd_sc_hd__a21oi_2
XFILLER_61_1322 VGND VGND VPWR VPWR sky130_fd_sc_hd__decap_3
Xhold1208 _6769_/Q VGND VGND VPWR VPWR _5721_/A1 sky130_fd_sc_hd__dlygate4sd3_1
XFILLER_26_1453 VGND VGND VPWR VPWR sky130_fd_sc_hd__decap_3
Xhold1219 _6797_/Q VGND VGND VPWR VPWR _5753_/A1 sky130_fd_sc_hd__dlygate4sd3_1
XFILLER_66_710 VGND VGND VPWR VPWR sky130_fd_sc_hd__decap_3
XFILLER_22_1306 VGND VGND VPWR VPWR sky130_fd_sc_hd__decap_3
XFILLER_78_581 VGND VGND VPWR VPWR sky130_fd_sc_hd__decap_3
XFILLER_22_1317 VGND VGND VPWR VPWR sky130_fd_sc_hd__decap_3
XFILLER_61_1366 VGND VGND VPWR VPWR sky130_fd_sc_hd__decap_3
XFILLER_78_592 VGND VGND VPWR VPWR sky130_fd_sc_hd__decap_3
XFILLER_38_434 VGND VGND VPWR VPWR sky130_fd_sc_hd__decap_3
XFILLER_61_1399 VGND VGND VPWR VPWR sky130_fd_sc_hd__fill_1
XTAP_TAPCELL_ROW_0_205 VGND VPWR sky130_fd_sc_hd__tapvpwrvgnd_1
XFILLER_66_776 VGND VGND VPWR VPWR sky130_fd_sc_hd__fill_2
XFILLER_0_1102 VGND VGND VPWR VPWR sky130_fd_sc_hd__decap_3
XFILLER_4_1282 VGND VGND VPWR VPWR sky130_fd_sc_hd__decap_3
X_6982_ _6982_/CLK _6982_/D fanout746/X VGND VGND VPWR VPWR _6982_/Q sky130_fd_sc_hd__dfrtp_2
XFILLER_53_426 VGND VGND VPWR VPWR sky130_fd_sc_hd__decap_3
XFILLER_0_1124 VGND VGND VPWR VPWR sky130_fd_sc_hd__decap_3
XFILLER_19_681 VGND VGND VPWR VPWR sky130_fd_sc_hd__fill_1
XFILLER_20_1074 VGND VGND VPWR VPWR sky130_fd_sc_hd__decap_3
X_5933_ _7096_/Q _6073_/D VGND VGND VPWR VPWR _5933_/Y sky130_fd_sc_hd__nand2_2
XFILLER_59_1251 VGND VGND VPWR VPWR sky130_fd_sc_hd__decap_3
XFILLER_18_191 VGND VGND VPWR VPWR sky130_fd_sc_hd__decap_3
XFILLER_34_640 VGND VGND VPWR VPWR sky130_fd_sc_hd__decap_3
XFILLER_15_18 VGND VGND VPWR VPWR sky130_fd_sc_hd__fill_2
XFILLER_20_1096 VGND VGND VPWR VPWR sky130_fd_sc_hd__fill_2
XFILLER_62_960 VGND VGND VPWR VPWR sky130_fd_sc_hd__fill_2
XTAP_TAPCELL_ROW_24_819 VGND VPWR sky130_fd_sc_hd__tapvpwrvgnd_1
XFILLER_55_1115 VGND VGND VPWR VPWR sky130_fd_sc_hd__decap_3
XFILLER_59_1284 VGND VGND VPWR VPWR sky130_fd_sc_hd__decap_3
XFILLER_59_1295 VGND VGND VPWR VPWR sky130_fd_sc_hd__decap_3
XFILLER_34_684 VGND VGND VPWR VPWR sky130_fd_sc_hd__decap_3
X_5864_ _5864_/A0 _5902_/A0 _5867_/S VGND VGND VPWR VPWR _6878_/D sky130_fd_sc_hd__mux2_1
XFILLER_62_993 VGND VGND VPWR VPWR sky130_fd_sc_hd__decap_3
XFILLER_22_835 VGND VGND VPWR VPWR sky130_fd_sc_hd__decap_3
XFILLER_33_183 VGND VGND VPWR VPWR sky130_fd_sc_hd__fill_2
XFILLER_61_492 VGND VGND VPWR VPWR sky130_fd_sc_hd__decap_3
X_4815_ _4872_/A _4815_/B VGND VGND VPWR VPWR _4815_/Y sky130_fd_sc_hd__nor2_2
XFILLER_72_1462 VGND VGND VPWR VPWR sky130_fd_sc_hd__decap_3
X_5795_ _5801_/A_N _5868_/B _5795_/C VGND VGND VPWR VPWR _5795_/X sky130_fd_sc_hd__and3b_2
XFILLER_33_1413 VGND VGND VPWR VPWR sky130_fd_sc_hd__decap_3
XFILLER_21_378 VGND VGND VPWR VPWR sky130_fd_sc_hd__fill_2
XFILLER_33_1446 VGND VGND VPWR VPWR sky130_fd_sc_hd__decap_3
X_4746_ _4738_/A _4386_/X _4723_/X _6571_/Q VGND VGND VPWR VPWR _4746_/X sky130_fd_sc_hd__a2bb2o_2
XFILLER_33_1457 VGND VGND VPWR VPWR sky130_fd_sc_hd__decap_3
X_4677_ _6289_/Q wire515/X _3388_/X _4854_/B2 VGND VGND VPWR VPWR _4677_/X sky130_fd_sc_hd__a22o_2
XTAP_TAPCELL_ROW_73_2102 VGND VPWR sky130_fd_sc_hd__tapvpwrvgnd_1
X_6416_ _6986_/CLK _6416_/D load_slew648/X VGND VGND VPWR VPWR _6416_/Q sky130_fd_sc_hd__dfrtp_2
X_3628_ _4783_/B _3619_/X _3622_/X _4886_/A1 VGND VGND VPWR VPWR _3628_/X sky130_fd_sc_hd__o211a_2
XFILLER_66_1211 VGND VGND VPWR VPWR sky130_fd_sc_hd__decap_3
XFILLER_1_706 VGND VGND VPWR VPWR sky130_fd_sc_hd__decap_3
X_6347_ _6970_/CLK _6347_/D load_slew671/X VGND VGND VPWR VPWR _6347_/Q sky130_fd_sc_hd__dfrtp_2
XFILLER_66_1244 VGND VGND VPWR VPWR sky130_fd_sc_hd__decap_3
X_3559_ _4665_/B _3558_/X _4487_/A VGND VGND VPWR VPWR _3559_/X sky130_fd_sc_hd__o21a_2
XFILLER_27_1239 VGND VGND VPWR VPWR sky130_fd_sc_hd__decap_3
XFILLER_66_1288 VGND VGND VPWR VPWR sky130_fd_sc_hd__decap_3
XFILLER_0_249 VGND VGND VPWR VPWR sky130_fd_sc_hd__decap_3
X_6278_ _6912_/CLK _6278_/D wire715/X VGND VGND VPWR VPWR _6278_/Q sky130_fd_sc_hd__dfrtp_2
XFILLER_9_1160 VGND VGND VPWR VPWR sky130_fd_sc_hd__decap_3
XFILLER_76_529 VGND VGND VPWR VPWR sky130_fd_sc_hd__decap_3
X_5229_ _6756_/Q _5314_/S _5321_/S _5228_/Y VGND VGND VPWR VPWR _5229_/X sky130_fd_sc_hd__o211a_2
XFILLER_69_570 VGND VGND VPWR VPWR sky130_fd_sc_hd__decap_3
XFILLER_40_1406 VGND VGND VPWR VPWR sky130_fd_sc_hd__decap_3
XFILLER_57_721 VGND VGND VPWR VPWR sky130_fd_sc_hd__fill_1
XFILLER_57_743 VGND VGND VPWR VPWR sky130_fd_sc_hd__decap_3
XFILLER_5_1046 VGND VGND VPWR VPWR sky130_fd_sc_hd__decap_3
XFILLER_56_47 VGND VGND VPWR VPWR sky130_fd_sc_hd__decap_3
XFILLER_17_607 VGND VGND VPWR VPWR sky130_fd_sc_hd__decap_3
XFILLER_56_253 VGND VGND VPWR VPWR sky130_fd_sc_hd__fill_2
XFILLER_57_776 VGND VGND VPWR VPWR sky130_fd_sc_hd__decap_3
XFILLER_29_489 VGND VGND VPWR VPWR sky130_fd_sc_hd__decap_3
XFILLER_56_275 VGND VGND VPWR VPWR sky130_fd_sc_hd__decap_3
XFILLER_71_212 VGND VGND VPWR VPWR sky130_fd_sc_hd__decap_3
XFILLER_72_757 VGND VGND VPWR VPWR sky130_fd_sc_hd__decap_3
XFILLER_77_1340 VGND VGND VPWR VPWR sky130_fd_sc_hd__decap_3
XFILLER_77_1351 VGND VGND VPWR VPWR sky130_fd_sc_hd__decap_3
XFILLER_25_640 VGND VGND VPWR VPWR sky130_fd_sc_hd__decap_3
XFILLER_72_24 VGND VGND VPWR VPWR sky130_fd_sc_hd__decap_3
XFILLER_73_1204 VGND VGND VPWR VPWR sky130_fd_sc_hd__decap_3
XFILLER_77_1384 VGND VGND VPWR VPWR sky130_fd_sc_hd__decap_3
XFILLER_72_35 VGND VGND VPWR VPWR sky130_fd_sc_hd__decap_3
XFILLER_38_1335 VGND VGND VPWR VPWR sky130_fd_sc_hd__decap_3
XFILLER_25_673 VGND VGND VPWR VPWR sky130_fd_sc_hd__decap_3
XFILLER_72_68 VGND VGND VPWR VPWR sky130_fd_sc_hd__decap_3
XFILLER_13_835 VGND VGND VPWR VPWR sky130_fd_sc_hd__decap_3
XFILLER_73_1248 VGND VGND VPWR VPWR sky130_fd_sc_hd__decap_3
XFILLER_38_1368 VGND VGND VPWR VPWR sky130_fd_sc_hd__decap_3
XFILLER_38_1379 VGND VGND VPWR VPWR sky130_fd_sc_hd__decap_3
XFILLER_40_676 VGND VGND VPWR VPWR sky130_fd_sc_hd__decap_3
XANTENNA_90 _3087_/Y VGND VGND VPWR VPWR sky130_fd_sc_hd__diode_2
XFILLER_21_50 VGND VGND VPWR VPWR sky130_fd_sc_hd__decap_3
XFILLER_10_1232 VGND VGND VPWR VPWR sky130_fd_sc_hd__decap_3
XFILLER_4_533 VGND VGND VPWR VPWR sky130_fd_sc_hd__decap_3
XFILLER_49_1431 VGND VGND VPWR VPWR sky130_fd_sc_hd__decap_3
XFILLER_4_566 VGND VGND VPWR VPWR sky130_fd_sc_hd__decap_3
XFILLER_10_1276 VGND VGND VPWR VPWR sky130_fd_sc_hd__decap_3
XTAP_TAPCELL_ROW_56_1654 VGND VPWR sky130_fd_sc_hd__tapvpwrvgnd_1
XTAP_TAPCELL_ROW_56_1665 VGND VPWR sky130_fd_sc_hd__tapvpwrvgnd_1
XFILLER_80_1208 VGND VGND VPWR VPWR sky130_fd_sc_hd__decap_3
XFILLER_45_1328 VGND VGND VPWR VPWR sky130_fd_sc_hd__decap_3
XFILLER_0_750 VGND VGND VPWR VPWR sky130_fd_sc_hd__decap_3
XTAP_TAPCELL_ROW_7_371 VGND VPWR sky130_fd_sc_hd__tapvpwrvgnd_1
XTAP_TAPCELL_ROW_7_382 VGND VPWR sky130_fd_sc_hd__tapvpwrvgnd_1
XFILLER_0_772 VGND VGND VPWR VPWR sky130_fd_sc_hd__decap_3
XTAP_TAPCELL_ROW_7_393 VGND VPWR sky130_fd_sc_hd__tapvpwrvgnd_1
XFILLER_48_721 VGND VGND VPWR VPWR sky130_fd_sc_hd__decap_3
XFILLER_0_794 VGND VGND VPWR VPWR sky130_fd_sc_hd__decap_3
XFILLER_43_1085 VGND VGND VPWR VPWR sky130_fd_sc_hd__decap_3
XFILLER_48_765 VGND VGND VPWR VPWR sky130_fd_sc_hd__fill_1
XFILLER_78_1126 VGND VGND VPWR VPWR sky130_fd_sc_hd__decap_3
XFILLER_63_724 VGND VGND VPWR VPWR sky130_fd_sc_hd__decap_3
XFILLER_1_1422 VGND VGND VPWR VPWR sky130_fd_sc_hd__decap_3
XFILLER_63_735 VGND VGND VPWR VPWR sky130_fd_sc_hd__decap_3
XFILLER_35_437 VGND VGND VPWR VPWR sky130_fd_sc_hd__decap_3
XFILLER_21_1372 VGND VGND VPWR VPWR sky130_fd_sc_hd__decap_3
XFILLER_1_1455 VGND VGND VPWR VPWR sky130_fd_sc_hd__fill_1
XFILLER_46_91 VGND VGND VPWR VPWR sky130_fd_sc_hd__fill_2
XFILLER_1_1466 VGND VGND VPWR VPWR sky130_fd_sc_hd__decap_3
XTAP_TAPCELL_ROW_18_657 VGND VPWR sky130_fd_sc_hd__tapvpwrvgnd_1
XTAP_TAPCELL_ROW_18_668 VGND VPWR sky130_fd_sc_hd__tapvpwrvgnd_1
XTAP_TAPCELL_ROW_18_679 VGND VPWR sky130_fd_sc_hd__tapvpwrvgnd_1
XFILLER_56_1424 VGND VGND VPWR VPWR sky130_fd_sc_hd__decap_3
XFILLER_56_1435 VGND VGND VPWR VPWR sky130_fd_sc_hd__decap_3
XFILLER_44_993 VGND VGND VPWR VPWR sky130_fd_sc_hd__decap_3
XFILLER_50_429 VGND VGND VPWR VPWR sky130_fd_sc_hd__decap_3
XFILLER_17_1419 VGND VGND VPWR VPWR sky130_fd_sc_hd__decap_3
XFILLER_56_1468 VGND VGND VPWR VPWR sky130_fd_sc_hd__fill_1
XFILLER_31_643 VGND VGND VPWR VPWR sky130_fd_sc_hd__decap_3
XFILLER_31_676 VGND VGND VPWR VPWR sky130_fd_sc_hd__decap_3
X_4600_ _6302_/Q wire54/A _4597_/X _4599_/X VGND VGND VPWR VPWR _6302_/D sky130_fd_sc_hd__o22a_2
XFILLER_15_1132 VGND VGND VPWR VPWR sky130_fd_sc_hd__decap_3
X_5580_ _5581_/A _3712_/B _3915_/X _5583_/A2 _5580_/B2 VGND VGND VPWR VPWR _6656_/D
+ sky130_fd_sc_hd__a32o_2
XFILLER_7_30 VGND VGND VPWR VPWR sky130_fd_sc_hd__decap_3
XFILLER_30_197 VGND VGND VPWR VPWR sky130_fd_sc_hd__decap_3
X_4531_ _6293_/Q wire63/X _4528_/X _4530_/X VGND VGND VPWR VPWR _6293_/D sky130_fd_sc_hd__o22a_2
XFILLER_11_1018 VGND VGND VPWR VPWR sky130_fd_sc_hd__fill_2
X_4462_ _4817_/A1 _4459_/X _4460_/Y _4461_/X _4874_/C1 VGND VGND VPWR VPWR _4462_/X
+ sky130_fd_sc_hd__o221a_2
X_6201_ _7052_/CLK _6201_/D load_slew805/X VGND VGND VPWR VPWR _6201_/Q sky130_fd_sc_hd__dfrtp_2
X_3413_ hold890/X _3412_/X _3413_/S VGND VGND VPWR VPWR _6180_/D sky130_fd_sc_hd__mux2_1
X_4393_ _6275_/Q wire54/X _4390_/X _4392_/X VGND VGND VPWR VPWR _6275_/D sky130_fd_sc_hd__o22a_2
Xfanout807 fanout817/X VGND VGND VPWR VPWR fanout807/X sky130_fd_sc_hd__clkdlybuf4s25_1
X_6132_ _7055_/CLK _6132_/D wire796/X VGND VGND VPWR VPWR _6132_/Q sky130_fd_sc_hd__dfrtp_2
X_3344_ _6227_/Q _6403_/Q VGND VGND VPWR VPWR _3344_/X sky130_fd_sc_hd__xor2_2
Xfanout818 fanout847/X VGND VGND VPWR VPWR fanout818/X sky130_fd_sc_hd__clkdlybuf4s25_1
XFILLER_63_1428 VGND VGND VPWR VPWR sky130_fd_sc_hd__decap_3
XTAP_TAPCELL_ROW_5_319 VGND VPWR sky130_fd_sc_hd__tapvpwrvgnd_1
Xload_slew230 _6032_/S VGND VGND VPWR VPWR _6015_/S sky130_fd_sc_hd__buf_4
XFILLER_6_1300 VGND VGND VPWR VPWR sky130_fd_sc_hd__decap_3
X_6063_ _5703_/A _6062_/X _7066_/Q VGND VGND VPWR VPWR _7066_/D sky130_fd_sc_hd__mux2_1
X_3275_ _5958_/A0 _3274_/X _7087_/D VGND VGND VPWR VPWR _6111_/D sky130_fd_sc_hd__mux2_1
XFILLER_61_1130 VGND VGND VPWR VPWR sky130_fd_sc_hd__fill_1
Xhold1005 _6054_/X VGND VGND VPWR VPWR _7058_/D sky130_fd_sc_hd__dlygate4sd3_1
XFILLER_26_1250 VGND VGND VPWR VPWR sky130_fd_sc_hd__decap_3
XFILLER_26_1261 VGND VGND VPWR VPWR sky130_fd_sc_hd__decap_3
Xhold1016 _6135_/Q VGND VGND VPWR VPWR _5982_/A0 sky130_fd_sc_hd__dlygate4sd3_1
XFILLER_6_1344 VGND VGND VPWR VPWR sky130_fd_sc_hd__decap_3
Xhold1027 _6730_/Q VGND VGND VPWR VPWR _5677_/A0 sky130_fd_sc_hd__dlygate4sd3_1
Xhold1038 _7063_/Q VGND VGND VPWR VPWR _6059_/A1 sky130_fd_sc_hd__dlygate4sd3_1
X_5014_ _6456_/Q _6674_/Q VGND VGND VPWR VPWR _5015_/B sky130_fd_sc_hd__xor2_2
Xhold1049 _6710_/Q VGND VGND VPWR VPWR _5654_/A0 sky130_fd_sc_hd__dlygate4sd3_1
XFILLER_26_1294 VGND VGND VPWR VPWR sky130_fd_sc_hd__decap_3
XFILLER_61_1185 VGND VGND VPWR VPWR sky130_fd_sc_hd__fill_1
XFILLER_2_1208 VGND VGND VPWR VPWR sky130_fd_sc_hd__decap_3
XFILLER_6_1388 VGND VGND VPWR VPWR sky130_fd_sc_hd__decap_3
XFILLER_38_264 VGND VGND VPWR VPWR sky130_fd_sc_hd__decap_3
XFILLER_53_223 VGND VGND VPWR VPWR sky130_fd_sc_hd__fill_1
XFILLER_26_448 VGND VGND VPWR VPWR sky130_fd_sc_hd__decap_3
XFILLER_53_234 VGND VGND VPWR VPWR sky130_fd_sc_hd__decap_3
XFILLER_54_757 VGND VGND VPWR VPWR sky130_fd_sc_hd__fill_2
X_6965_ _7076_/CLK _6965_/D fanout672/X VGND VGND VPWR VPWR _6965_/Q sky130_fd_sc_hd__dfrtp_2
XFILLER_35_971 VGND VGND VPWR VPWR sky130_fd_sc_hd__fill_1
XFILLER_13_109 VGND VGND VPWR VPWR sky130_fd_sc_hd__decap_3
XFILLER_35_982 VGND VGND VPWR VPWR sky130_fd_sc_hd__fill_1
X_5916_ _5916_/A0 _5784_/C _5919_/S VGND VGND VPWR VPWR _6922_/D sky130_fd_sc_hd__mux2_1
XFILLER_59_1081 VGND VGND VPWR VPWR sky130_fd_sc_hd__fill_2
X_6896_ _7024_/CLK _6896_/D load_slew700/X VGND VGND VPWR VPWR _6896_/Q sky130_fd_sc_hd__dfrtp_2
XFILLER_50_941 VGND VGND VPWR VPWR sky130_fd_sc_hd__decap_3
X_5847_ _5847_/A0 _5797_/C _5849_/S VGND VGND VPWR VPWR _6863_/D sky130_fd_sc_hd__mux2_1
XFILLER_42_38 VGND VGND VPWR VPWR sky130_fd_sc_hd__fill_2
XFILLER_10_816 VGND VGND VPWR VPWR sky130_fd_sc_hd__decap_3
XFILLER_42_49 VGND VGND VPWR VPWR sky130_fd_sc_hd__decap_3
XFILLER_22_687 VGND VGND VPWR VPWR sky130_fd_sc_hd__decap_3
XFILLER_50_996 VGND VGND VPWR VPWR sky130_fd_sc_hd__decap_3
XFILLER_72_1270 VGND VGND VPWR VPWR sky130_fd_sc_hd__decap_3
XFILLER_37_1390 VGND VGND VPWR VPWR sky130_fd_sc_hd__decap_3
X_5778_ _5778_/A0 _5928_/A0 _5781_/S VGND VGND VPWR VPWR _6813_/D sky130_fd_sc_hd__mux2_1
XFILLER_33_1254 VGND VGND VPWR VPWR sky130_fd_sc_hd__decap_3
X_4729_ _6906_/Q _4774_/A2 wire36/X _4728_/X VGND VGND VPWR VPWR _4729_/X sky130_fd_sc_hd__a211o_2
XFILLER_33_1287 VGND VGND VPWR VPWR sky130_fd_sc_hd__fill_1
XFILLER_33_1298 VGND VGND VPWR VPWR sky130_fd_sc_hd__decap_3
XFILLER_68_1306 VGND VGND VPWR VPWR sky130_fd_sc_hd__decap_3
XFILLER_68_1317 VGND VGND VPWR VPWR sky130_fd_sc_hd__decap_3
Xhold861 _7087_/Q VGND VGND VPWR VPWR _7096_/D sky130_fd_sc_hd__dlygate4sd3_1
XFILLER_1_514 VGND VGND VPWR VPWR sky130_fd_sc_hd__decap_3
Xhold872 _6022_/X VGND VGND VPWR VPWR _7026_/D sky130_fd_sc_hd__dlygate4sd3_1
Xhold883 _5985_/X VGND VGND VPWR VPWR _6989_/D sky130_fd_sc_hd__dlygate4sd3_1
XFILLER_1_547 VGND VGND VPWR VPWR sky130_fd_sc_hd__fill_2
Xhold894 _6088_/Q VGND VGND VPWR VPWR hold894/X sky130_fd_sc_hd__dlygate4sd3_1
XFILLER_27_1036 VGND VGND VPWR VPWR sky130_fd_sc_hd__decap_3
XFILLER_7_1119 VGND VGND VPWR VPWR sky130_fd_sc_hd__fill_1
XFILLER_67_24 VGND VGND VPWR VPWR sky130_fd_sc_hd__decap_3
XFILLER_49_529 VGND VGND VPWR VPWR sky130_fd_sc_hd__decap_3
XFILLER_44_1350 VGND VGND VPWR VPWR sky130_fd_sc_hd__decap_3
XFILLER_67_57 VGND VGND VPWR VPWR sky130_fd_sc_hd__decap_3
XFILLER_29_220 VGND VGND VPWR VPWR sky130_fd_sc_hd__decap_3
XFILLER_44_1394 VGND VGND VPWR VPWR sky130_fd_sc_hd__decap_3
XFILLER_29_242 VGND VGND VPWR VPWR sky130_fd_sc_hd__fill_2
XFILLER_79_1413 VGND VGND VPWR VPWR sky130_fd_sc_hd__decap_3
Xhold1550 _6652_/Q VGND VGND VPWR VPWR _5574_/B2 sky130_fd_sc_hd__dlygate4sd3_1
Xhold1561 _6658_/Q VGND VGND VPWR VPWR _5585_/B2 sky130_fd_sc_hd__dlygate4sd3_1
XFILLER_57_573 VGND VGND VPWR VPWR sky130_fd_sc_hd__decap_3
Xhold1572 _6667_/Q VGND VGND VPWR VPWR _5595_/B2 sky130_fd_sc_hd__dlygate4sd3_1
XFILLER_40_1258 VGND VGND VPWR VPWR sky130_fd_sc_hd__fill_2
XFILLER_79_1446 VGND VGND VPWR VPWR sky130_fd_sc_hd__decap_3
XFILLER_72_510 VGND VGND VPWR VPWR sky130_fd_sc_hd__decap_3
XTAP_TAPCELL_ROW_28_922 VGND VPWR sky130_fd_sc_hd__tapvpwrvgnd_1
XFILLER_45_735 VGND VGND VPWR VPWR sky130_fd_sc_hd__decap_3
XFILLER_79_1457 VGND VGND VPWR VPWR sky130_fd_sc_hd__decap_3
XTAP_TAPCELL_ROW_28_933 VGND VPWR sky130_fd_sc_hd__tapvpwrvgnd_1
XFILLER_33_908 VGND VGND VPWR VPWR sky130_fd_sc_hd__decap_3
XFILLER_44_245 VGND VGND VPWR VPWR sky130_fd_sc_hd__decap_3
XFILLER_44_256 VGND VGND VPWR VPWR sky130_fd_sc_hd__decap_3
XFILLER_72_587 VGND VGND VPWR VPWR sky130_fd_sc_hd__fill_1
XFILLER_16_50 VGND VGND VPWR VPWR sky130_fd_sc_hd__decap_3
XTAP_TAPCELL_ROW_49_1480 VGND VPWR sky130_fd_sc_hd__tapvpwrvgnd_1
XFILLER_77_1192 VGND VGND VPWR VPWR sky130_fd_sc_hd__decap_3
XFILLER_25_492 VGND VGND VPWR VPWR sky130_fd_sc_hd__decap_3
XFILLER_13_643 VGND VGND VPWR VPWR sky130_fd_sc_hd__decap_3
XFILLER_34_1007 VGND VGND VPWR VPWR sky130_fd_sc_hd__decap_3
XTAP_TAPCELL_ROW_45_1366 VGND VPWR sky130_fd_sc_hd__tapvpwrvgnd_1
XFILLER_38_1187 VGND VGND VPWR VPWR sky130_fd_sc_hd__decap_3
XTAP_TAPCELL_ROW_45_1377 VGND VPWR sky130_fd_sc_hd__tapvpwrvgnd_1
XFILLER_73_1078 VGND VGND VPWR VPWR sky130_fd_sc_hd__fill_1
XFILLER_51_1310 VGND VGND VPWR VPWR sky130_fd_sc_hd__decap_3
XFILLER_16_1441 VGND VGND VPWR VPWR sky130_fd_sc_hd__decap_3
XFILLER_9_658 VGND VGND VPWR VPWR sky130_fd_sc_hd__decap_3
XFILLER_51_1343 VGND VGND VPWR VPWR sky130_fd_sc_hd__fill_1
XFILLER_51_1354 VGND VGND VPWR VPWR sky130_fd_sc_hd__decap_3
XFILLER_12_1338 VGND VGND VPWR VPWR sky130_fd_sc_hd__decap_3
XFILLER_51_1387 VGND VGND VPWR VPWR sky130_fd_sc_hd__decap_3
XTAP_TAPCELL_ROW_58_1705 VGND VPWR sky130_fd_sc_hd__tapvpwrvgnd_1
XFILLER_66_9 VGND VGND VPWR VPWR sky130_fd_sc_hd__decap_3
XTAP_TAPCELL_ROW_58_1716 VGND VPWR sky130_fd_sc_hd__tapvpwrvgnd_1
XFILLER_5_853 VGND VGND VPWR VPWR sky130_fd_sc_hd__fill_1
XFILLER_5_897 VGND VGND VPWR VPWR sky130_fd_sc_hd__decap_3
XFILLER_4_363 VGND VGND VPWR VPWR sky130_fd_sc_hd__fill_1
XFILLER_49_1272 VGND VGND VPWR VPWR sky130_fd_sc_hd__decap_3
XFILLER_80_1027 VGND VGND VPWR VPWR sky130_fd_sc_hd__fill_1
XFILLER_80_1049 VGND VGND VPWR VPWR sky130_fd_sc_hd__decap_3
XFILLER_23_1401 VGND VGND VPWR VPWR sky130_fd_sc_hd__decap_3
XFILLER_62_1450 VGND VGND VPWR VPWR sky130_fd_sc_hd__decap_3
XFILLER_67_337 VGND VGND VPWR VPWR sky130_fd_sc_hd__decap_3
X_3060_ _6356_/Q VGND VGND VPWR VPWR _3060_/Y sky130_fd_sc_hd__inv_2
XFILLER_23_1434 VGND VGND VPWR VPWR sky130_fd_sc_hd__decap_3
XFILLER_76_860 VGND VGND VPWR VPWR sky130_fd_sc_hd__decap_3
XFILLER_36_713 VGND VGND VPWR VPWR sky130_fd_sc_hd__decap_3
XFILLER_48_573 VGND VGND VPWR VPWR sky130_fd_sc_hd__fill_2
XFILLER_48_584 VGND VGND VPWR VPWR sky130_fd_sc_hd__decap_3
XFILLER_48_595 VGND VGND VPWR VPWR sky130_fd_sc_hd__decap_3
XFILLER_36_757 VGND VGND VPWR VPWR sky130_fd_sc_hd__decap_3
XFILLER_35_234 VGND VGND VPWR VPWR sky130_fd_sc_hd__decap_3
XFILLER_1_1263 VGND VGND VPWR VPWR sky130_fd_sc_hd__decap_3
X_6750_ _7088_/CLK _6750_/D fanout772/X VGND VGND VPWR VPWR _6750_/Q sky130_fd_sc_hd__dfrtp_2
XFILLER_16_470 VGND VGND VPWR VPWR sky130_fd_sc_hd__decap_3
XFILLER_56_1232 VGND VGND VPWR VPWR sky130_fd_sc_hd__decap_3
X_3962_ _6528_/Q _4388_/A _4061_/A1 VGND VGND VPWR VPWR _3962_/X sky130_fd_sc_hd__a21bo_2
XFILLER_17_1205 VGND VGND VPWR VPWR sky130_fd_sc_hd__decap_3
X_5701_ _5701_/A0 _5931_/A0 _5701_/S VGND VGND VPWR VPWR _6752_/D sky130_fd_sc_hd__mux2_1
XFILLER_32_963 VGND VGND VPWR VPWR sky130_fd_sc_hd__decap_3
XFILLER_50_259 VGND VGND VPWR VPWR sky130_fd_sc_hd__decap_3
X_6681_ _6929_/CLK _6681_/D load_slew707/X VGND VGND VPWR VPWR _6681_/Q sky130_fd_sc_hd__dfrtp_2
XFILLER_56_1276 VGND VGND VPWR VPWR sky130_fd_sc_hd__decap_3
X_3893_ _6244_/Q _4872_/A _3891_/X _3892_/X VGND VGND VPWR VPWR _4314_/B sky130_fd_sc_hd__o22a_2
X_5632_ _5908_/A0 _5632_/A1 wire93/X VGND VGND VPWR VPWR _6691_/D sky130_fd_sc_hd__mux2_1
XFILLER_30_1427 VGND VGND VPWR VPWR sky130_fd_sc_hd__fill_1
X_5563_ _6364_/Q _5566_/A2 _5563_/B1 _5566_/B2 VGND VGND VPWR VPWR _6646_/D sky130_fd_sc_hd__a22o_2
XFILLER_30_1438 VGND VGND VPWR VPWR sky130_fd_sc_hd__decap_3
X_4514_ _6267_/Q _4868_/A2 _3328_/X _4868_/B2 VGND VGND VPWR VPWR _4514_/X sky130_fd_sc_hd__a22o_2
X_5494_ _5488_/X _5493_/X _5492_/Y VGND VGND VPWR VPWR _6601_/D sky130_fd_sc_hd__a21oi_2
XFILLER_7_190 VGND VGND VPWR VPWR sky130_fd_sc_hd__decap_3
X_4445_ _5607_/A2 _5605_/A3 _4586_/D _4480_/S _6514_/Q VGND VGND VPWR VPWR _4445_/X
+ sky130_fd_sc_hd__a32o_2
XFILLER_28_1312 VGND VGND VPWR VPWR sky130_fd_sc_hd__decap_3
XFILLER_28_1323 VGND VGND VPWR VPWR sky130_fd_sc_hd__decap_3
XFILLER_67_1372 VGND VGND VPWR VPWR sky130_fd_sc_hd__decap_3
XFILLER_8_1406 VGND VGND VPWR VPWR sky130_fd_sc_hd__decap_3
Xfanout604 input8/X VGND VGND VPWR VPWR _5799_/C sky130_fd_sc_hd__clkdlybuf4s25_1
Xfanout615 input6/X VGND VGND VPWR VPWR _5795_/C sky130_fd_sc_hd__clkdlybuf4s25_1
X_4376_ _6273_/Q _4622_/S _4373_/X _4375_/X VGND VGND VPWR VPWR _6273_/D sky130_fd_sc_hd__o22a_2
Xfanout626 _5791_/C VGND VGND VPWR VPWR _5826_/A0 sky130_fd_sc_hd__clkdlybuf4s25_1
XFILLER_28_1356 VGND VGND VPWR VPWR sky130_fd_sc_hd__decap_3
XFILLER_63_1236 VGND VGND VPWR VPWR sky130_fd_sc_hd__decap_3
X_6115_ _7088_/CLK _6115_/D load_slew769/X VGND VGND VPWR VPWR _6115_/Q sky130_fd_sc_hd__dfrtp_2
X_3327_ _5984_/A0 _3326_/X _3455_/S VGND VGND VPWR VPWR _6137_/D sky130_fd_sc_hd__mux2_1
XFILLER_59_838 VGND VGND VPWR VPWR sky130_fd_sc_hd__fill_2
X_7095_ _7095_/CLK _7095_/D fanout698/X VGND VGND VPWR VPWR _7095_/Q sky130_fd_sc_hd__dfrtp_2
Xfanout659 fanout666/X VGND VGND VPWR VPWR fanout659/X sky130_fd_sc_hd__clkdlybuf4s25_1
XFILLER_63_1269 VGND VGND VPWR VPWR sky130_fd_sc_hd__decap_3
XFILLER_58_348 VGND VGND VPWR VPWR sky130_fd_sc_hd__decap_3
XFILLER_6_1141 VGND VGND VPWR VPWR sky130_fd_sc_hd__decap_3
X_6046_ hold941/X _7050_/Q _6046_/S VGND VGND VPWR VPWR _6046_/X sky130_fd_sc_hd__mux2_1
XFILLER_6_1152 VGND VGND VPWR VPWR sky130_fd_sc_hd__decap_3
X_3258_ _6264_/Q _6360_/Q VGND VGND VPWR VPWR _3258_/X sky130_fd_sc_hd__xor2_2
XFILLER_26_1091 VGND VGND VPWR VPWR sky130_fd_sc_hd__fill_1
XFILLER_2_1005 VGND VGND VPWR VPWR sky130_fd_sc_hd__decap_3
XFILLER_27_713 VGND VGND VPWR VPWR sky130_fd_sc_hd__decap_3
XFILLER_39_573 VGND VGND VPWR VPWR sky130_fd_sc_hd__decap_3
XFILLER_67_882 VGND VGND VPWR VPWR sky130_fd_sc_hd__decap_3
XFILLER_6_1185 VGND VGND VPWR VPWR sky130_fd_sc_hd__decap_3
X_3189_ _7007_/Q _3136_/A _3193_/A1 _3188_/X _3223_/C1 VGND VGND VPWR VPWR _3189_/X
+ sky130_fd_sc_hd__a221o_2
XFILLER_2_1049 VGND VGND VPWR VPWR sky130_fd_sc_hd__decap_3
XFILLER_14_418 VGND VGND VPWR VPWR sky130_fd_sc_hd__fill_2
X_6948_ _7012_/CLK _6948_/D load_slew810/X VGND VGND VPWR VPWR _6948_/Q sky130_fd_sc_hd__dfrtp_2
XFILLER_74_1332 VGND VGND VPWR VPWR sky130_fd_sc_hd__decap_3
XFILLER_39_1452 VGND VGND VPWR VPWR sky130_fd_sc_hd__decap_3
XFILLER_39_1463 VGND VGND VPWR VPWR sky130_fd_sc_hd__decap_3
XFILLER_74_1365 VGND VGND VPWR VPWR sky130_fd_sc_hd__decap_3
XFILLER_35_1316 VGND VGND VPWR VPWR sky130_fd_sc_hd__decap_3
XFILLER_74_1376 VGND VGND VPWR VPWR sky130_fd_sc_hd__decap_3
XFILLER_22_451 VGND VGND VPWR VPWR sky130_fd_sc_hd__decap_3
XFILLER_50_760 VGND VGND VPWR VPWR sky130_fd_sc_hd__decap_3
X_6879_ _7007_/CLK _6879_/D fanout820/X VGND VGND VPWR VPWR _6879_/Q sky130_fd_sc_hd__dfrtp_2
XFILLER_70_1229 VGND VGND VPWR VPWR sky130_fd_sc_hd__decap_3
XFILLER_23_996 VGND VGND VPWR VPWR sky130_fd_sc_hd__decap_3
XFILLER_50_782 VGND VGND VPWR VPWR sky130_fd_sc_hd__decap_3
XTAP_TAPCELL_ROW_40_1230 VGND VPWR sky130_fd_sc_hd__tapvpwrvgnd_1
XTAP_TAPCELL_ROW_40_1241 VGND VPWR sky130_fd_sc_hd__tapvpwrvgnd_1
XFILLER_6_617 VGND VGND VPWR VPWR sky130_fd_sc_hd__decap_3
XFILLER_33_1062 VGND VGND VPWR VPWR sky130_fd_sc_hd__fill_2
XTAP_TAPCELL_ROW_40_1252 VGND VPWR sky130_fd_sc_hd__tapvpwrvgnd_1
XFILLER_10_679 VGND VGND VPWR VPWR sky130_fd_sc_hd__decap_3
XFILLER_5_105 VGND VGND VPWR VPWR sky130_fd_sc_hd__decap_3
XFILLER_5_116 VGND VGND VPWR VPWR sky130_fd_sc_hd__decap_3
XFILLER_11_1360 VGND VGND VPWR VPWR sky130_fd_sc_hd__decap_3
XFILLER_68_1147 VGND VGND VPWR VPWR sky130_fd_sc_hd__fill_1
XFILLER_78_12 VGND VGND VPWR VPWR sky130_fd_sc_hd__decap_3
XTAP_TAPCELL_ROW_9_422 VGND VPWR sky130_fd_sc_hd__tapvpwrvgnd_1
XTAP_TAPCELL_ROW_9_433 VGND VPWR sky130_fd_sc_hd__tapvpwrvgnd_1
XFILLER_68_1169 VGND VGND VPWR VPWR sky130_fd_sc_hd__decap_3
XFILLER_11_1393 VGND VGND VPWR VPWR sky130_fd_sc_hd__decap_3
XFILLER_2_834 VGND VGND VPWR VPWR sky130_fd_sc_hd__decap_3
XTAP_TAPCELL_ROW_9_444 VGND VPWR sky130_fd_sc_hd__tapvpwrvgnd_1
XFILLER_1_311 VGND VGND VPWR VPWR sky130_fd_sc_hd__decap_3
XFILLER_46_1412 VGND VGND VPWR VPWR sky130_fd_sc_hd__decap_3
XFILLER_78_56 VGND VGND VPWR VPWR sky130_fd_sc_hd__decap_3
XFILLER_2_867 VGND VGND VPWR VPWR sky130_fd_sc_hd__fill_1
XFILLER_2_878 VGND VGND VPWR VPWR sky130_fd_sc_hd__decap_3
XFILLER_1_355 VGND VGND VPWR VPWR sky130_fd_sc_hd__decap_3
XTAP_TAPCELL_ROW_38_1181 VGND VPWR sky130_fd_sc_hd__tapvpwrvgnd_1
XFILLER_46_1456 VGND VGND VPWR VPWR sky130_fd_sc_hd__decap_3
XTAP_TAPCELL_ROW_38_1192 VGND VPWR sky130_fd_sc_hd__tapvpwrvgnd_1
XFILLER_1_388 VGND VGND VPWR VPWR sky130_fd_sc_hd__decap_3
XFILLER_42_1309 VGND VGND VPWR VPWR sky130_fd_sc_hd__decap_3
XFILLER_76_123 VGND VGND VPWR VPWR sky130_fd_sc_hd__decap_3
XFILLER_1_399 VGND VGND VPWR VPWR sky130_fd_sc_hd__decap_3
XFILLER_49_337 VGND VGND VPWR VPWR sky130_fd_sc_hd__decap_3
XTAP_TAPCELL_ROW_34_1078 VGND VPWR sky130_fd_sc_hd__tapvpwrvgnd_1
XFILLER_65_808 VGND VGND VPWR VPWR sky130_fd_sc_hd__decap_3
XTAP_TAPCELL_ROW_34_1089 VGND VPWR sky130_fd_sc_hd__tapvpwrvgnd_1
XFILLER_44_1191 VGND VGND VPWR VPWR sky130_fd_sc_hd__decap_3
XFILLER_79_1210 VGND VGND VPWR VPWR sky130_fd_sc_hd__decap_3
XFILLER_17_201 VGND VGND VPWR VPWR sky130_fd_sc_hd__fill_2
XFILLER_40_1055 VGND VGND VPWR VPWR sky130_fd_sc_hd__decap_3
XFILLER_73_841 VGND VGND VPWR VPWR sky130_fd_sc_hd__fill_1
Xhold1380 _6485_/Q VGND VGND VPWR VPWR _5373_/A1 sky130_fd_sc_hd__dlygate4sd3_1
XFILLER_79_1254 VGND VGND VPWR VPWR sky130_fd_sc_hd__decap_3
XFILLER_17_234 VGND VGND VPWR VPWR sky130_fd_sc_hd__decap_3
XFILLER_27_60 VGND VGND VPWR VPWR sky130_fd_sc_hd__decap_3
Xhold1391 _6850_/Q VGND VGND VPWR VPWR _5833_/A1 sky130_fd_sc_hd__dlygate4sd3_1
XFILLER_73_863 VGND VGND VPWR VPWR sky130_fd_sc_hd__decap_3
XTAP_TAPCELL_ROW_47_1417 VGND VPWR sky130_fd_sc_hd__tapvpwrvgnd_1
XFILLER_79_1287 VGND VGND VPWR VPWR sky130_fd_sc_hd__fill_1
XTAP_TAPCELL_ROW_47_1428 VGND VPWR sky130_fd_sc_hd__tapvpwrvgnd_1
XFILLER_79_1298 VGND VGND VPWR VPWR sky130_fd_sc_hd__decap_3
XFILLER_45_587 VGND VGND VPWR VPWR sky130_fd_sc_hd__decap_3
XFILLER_72_395 VGND VGND VPWR VPWR sky130_fd_sc_hd__fill_2
XFILLER_14_941 VGND VGND VPWR VPWR sky130_fd_sc_hd__decap_3
XFILLER_13_440 VGND VGND VPWR VPWR sky130_fd_sc_hd__fill_1
XFILLER_53_1416 VGND VGND VPWR VPWR sky130_fd_sc_hd__decap_3
XFILLER_13_462 VGND VGND VPWR VPWR sky130_fd_sc_hd__decap_3
XFILLER_9_411 VGND VGND VPWR VPWR sky130_fd_sc_hd__decap_3
XFILLER_41_771 VGND VGND VPWR VPWR sky130_fd_sc_hd__decap_3
XFILLER_53_1449 VGND VGND VPWR VPWR sky130_fd_sc_hd__decap_3
XFILLER_43_92 VGND VGND VPWR VPWR sky130_fd_sc_hd__decap_3
XFILLER_9_466 VGND VGND VPWR VPWR sky130_fd_sc_hd__decap_3
XFILLER_16_1282 VGND VGND VPWR VPWR sky130_fd_sc_hd__decap_3
XFILLER_64_6 VGND VGND VPWR VPWR sky130_fd_sc_hd__decap_3
XFILLER_4_171 VGND VGND VPWR VPWR sky130_fd_sc_hd__fill_1
X_4230_ _4303_/B _4230_/B VGND VGND VPWR VPWR _4315_/A sky130_fd_sc_hd__xnor2_2
XFILLER_4_193 VGND VGND VPWR VPWR sky130_fd_sc_hd__decap_3
XFILLER_4_53 VGND VGND VPWR VPWR sky130_fd_sc_hd__decap_3
X_4161_ _4327_/A _4161_/B VGND VGND VPWR VPWR _4162_/B sky130_fd_sc_hd__xnor2_2
XFILLER_4_97 VGND VGND VPWR VPWR sky130_fd_sc_hd__decap_3
XFILLER_60_1409 VGND VGND VPWR VPWR sky130_fd_sc_hd__decap_3
XFILLER_68_635 VGND VGND VPWR VPWR sky130_fd_sc_hd__fill_1
X_3112_ _7077_/Q _3114_/B VGND VGND VPWR VPWR _3217_/A sky130_fd_sc_hd__nand2_2
X_4092_ _3476_/X _4583_/B2 _4584_/A2 _6935_/Q _4092_/C1 VGND VGND VPWR VPWR _4092_/X
+ sky130_fd_sc_hd__a221o_2
XFILLER_23_1242 VGND VGND VPWR VPWR sky130_fd_sc_hd__decap_3
XFILLER_62_1291 VGND VGND VPWR VPWR sky130_fd_sc_hd__decap_3
XFILLER_3_1325 VGND VGND VPWR VPWR sky130_fd_sc_hd__decap_3
X_3043_ _4665_/B VGND VGND VPWR VPWR _3043_/Y sky130_fd_sc_hd__inv_2
XFILLER_23_1275 VGND VGND VPWR VPWR sky130_fd_sc_hd__decap_3
XFILLER_3_1369 VGND VGND VPWR VPWR sky130_fd_sc_hd__decap_3
XFILLER_36_565 VGND VGND VPWR VPWR sky130_fd_sc_hd__fill_2
XFILLER_58_1338 VGND VGND VPWR VPWR sky130_fd_sc_hd__decap_3
X_6802_ _7032_/CLK _6802_/D fanout689/X VGND VGND VPWR VPWR _6802_/Q sky130_fd_sc_hd__dfrtp_2
XFILLER_1_1060 VGND VGND VPWR VPWR sky130_fd_sc_hd__decap_3
XFILLER_1_1071 VGND VGND VPWR VPWR sky130_fd_sc_hd__decap_3
XFILLER_24_738 VGND VGND VPWR VPWR sky130_fd_sc_hd__fill_1
X_4994_ _6421_/Q _4994_/B VGND VGND VPWR VPWR _5237_/B sky130_fd_sc_hd__xnor2_2
XFILLER_51_546 VGND VGND VPWR VPWR sky130_fd_sc_hd__decap_3
X_6733_ _6765_/CLK _6733_/D wire641/X VGND VGND VPWR VPWR _6733_/Q sky130_fd_sc_hd__dfrtp_2
X_3945_ _6287_/Q _3948_/A2 _3948_/B1 _6263_/Q _3948_/C1 VGND VGND VPWR VPWR _3945_/X
+ sky130_fd_sc_hd__a221o_2
XFILLER_56_1073 VGND VGND VPWR VPWR sky130_fd_sc_hd__decap_3
X_6664_ _7034_/CLK _6664_/D fanout685/X VGND VGND VPWR VPWR _6664_/Q sky130_fd_sc_hd__dfrtp_2
XFILLER_17_1068 VGND VGND VPWR VPWR sky130_fd_sc_hd__decap_3
XFILLER_31_281 VGND VGND VPWR VPWR sky130_fd_sc_hd__decap_3
X_3876_ _6500_/Q _4319_/A2 _4582_/A _3875_/X VGND VGND VPWR VPWR _3876_/X sky130_fd_sc_hd__o211a_2
X_5615_ _5769_/A _6062_/B VGND VGND VPWR VPWR _5658_/B sky130_fd_sc_hd__or2_2
XFILLER_34_1371 VGND VGND VPWR VPWR sky130_fd_sc_hd__fill_1
X_6595_ _7064_/CLK _6595_/D load_slew723/X VGND VGND VPWR VPWR _6595_/Q sky130_fd_sc_hd__dfrtp_2
XFILLER_34_1382 VGND VGND VPWR VPWR sky130_fd_sc_hd__decap_3
XTAP_TAPCELL_ROW_30_972 VGND VPWR sky130_fd_sc_hd__tapvpwrvgnd_1
XFILLER_69_1401 VGND VGND VPWR VPWR sky130_fd_sc_hd__decap_3
XTAP_TAPCELL_ROW_30_983 VGND VPWR sky130_fd_sc_hd__tapvpwrvgnd_1
XFILLER_30_1235 VGND VGND VPWR VPWR sky130_fd_sc_hd__decap_3
X_5546_ _6347_/Q _5501_/B _5546_/B1 _5546_/B2 VGND VGND VPWR VPWR _6629_/D sky130_fd_sc_hd__a22o_2
XFILLER_69_1434 VGND VGND VPWR VPWR sky130_fd_sc_hd__decap_3
XFILLER_3_609 VGND VGND VPWR VPWR sky130_fd_sc_hd__decap_3
XFILLER_30_1279 VGND VGND VPWR VPWR sky130_fd_sc_hd__decap_3
X_5477_ _5477_/A1 _5477_/A2 _4881_/X VGND VGND VPWR VPWR _6589_/D sky130_fd_sc_hd__a21o_2
XFILLER_28_1120 VGND VGND VPWR VPWR sky130_fd_sc_hd__decap_3
X_4428_ _4428_/A _4783_/B _4783_/C VGND VGND VPWR VPWR _4480_/S sky130_fd_sc_hd__or3_2
XFILLER_8_1203 VGND VGND VPWR VPWR sky130_fd_sc_hd__fill_1
Xfanout401 _4772_/C1 VGND VGND VPWR VPWR _4597_/A sky130_fd_sc_hd__clkdlybuf4s25_1
XFILLER_67_1180 VGND VGND VPWR VPWR sky130_fd_sc_hd__decap_3
XFILLER_8_1214 VGND VGND VPWR VPWR sky130_fd_sc_hd__decap_3
XFILLER_59_602 VGND VGND VPWR VPWR sky130_fd_sc_hd__decap_3
Xfanout412 fanout413/X VGND VGND VPWR VPWR _4582_/A sky130_fd_sc_hd__clkdlybuf4s25_1
Xfanout423 _3098_/X VGND VGND VPWR VPWR _4318_/A sky130_fd_sc_hd__clkdlybuf4s25_1
XFILLER_59_613 VGND VGND VPWR VPWR sky130_fd_sc_hd__decap_3
XFILLER_28_1175 VGND VGND VPWR VPWR sky130_fd_sc_hd__fill_2
Xfanout445 _3073_/Y VGND VGND VPWR VPWR _3948_/A2 sky130_fd_sc_hd__clkdlybuf4s25_1
X_4359_ _4768_/B _4359_/B VGND VGND VPWR VPWR _4359_/Y sky130_fd_sc_hd__nand2_2
XFILLER_63_1055 VGND VGND VPWR VPWR sky130_fd_sc_hd__fill_1
XFILLER_8_1247 VGND VGND VPWR VPWR sky130_fd_sc_hd__decap_3
XFILLER_24_1017 VGND VGND VPWR VPWR sky130_fd_sc_hd__fill_2
XFILLER_48_48 VGND VGND VPWR VPWR sky130_fd_sc_hd__decap_3
Xfanout456 _3041_/Y VGND VGND VPWR VPWR _4586_/A sky130_fd_sc_hd__clkdlybuf4s25_1
Xfanout467 _4049_/A1 VGND VGND VPWR VPWR _4097_/A1 sky130_fd_sc_hd__clkdlybuf4s25_1
Xfanout478 fanout488/X VGND VGND VPWR VPWR _4793_/A sky130_fd_sc_hd__clkdlybuf4s25_1
X_7078_ _7092_/CLK _7078_/D load_slew677/X VGND VGND VPWR VPWR _7078_/Q sky130_fd_sc_hd__dfrtp_2
Xfanout489 _5581_/A VGND VGND VPWR VPWR _5606_/A1 sky130_fd_sc_hd__clkdlybuf4s25_1
XFILLER_41_1331 VGND VGND VPWR VPWR sky130_fd_sc_hd__decap_3
XFILLER_80_1391 VGND VGND VPWR VPWR sky130_fd_sc_hd__decap_3
XFILLER_46_318 VGND VGND VPWR VPWR sky130_fd_sc_hd__decap_3
XFILLER_46_329 VGND VGND VPWR VPWR sky130_fd_sc_hd__fill_1
X_6029_ hold869/X _7033_/Q _6053_/S VGND VGND VPWR VPWR _6029_/X sky130_fd_sc_hd__mux2_1
XFILLER_41_1375 VGND VGND VPWR VPWR sky130_fd_sc_hd__decap_3
XFILLER_15_705 VGND VGND VPWR VPWR sky130_fd_sc_hd__decap_3
XFILLER_76_1427 VGND VGND VPWR VPWR sky130_fd_sc_hd__fill_1
XFILLER_76_1438 VGND VGND VPWR VPWR sky130_fd_sc_hd__decap_3
XFILLER_42_502 VGND VGND VPWR VPWR sky130_fd_sc_hd__fill_1
XFILLER_54_362 VGND VGND VPWR VPWR sky130_fd_sc_hd__fill_2
XFILLER_39_1260 VGND VGND VPWR VPWR sky130_fd_sc_hd__decap_3
XFILLER_30_719 VGND VGND VPWR VPWR sky130_fd_sc_hd__decap_3
XFILLER_80_24 VGND VGND VPWR VPWR sky130_fd_sc_hd__decap_3
XFILLER_11_900 VGND VGND VPWR VPWR sky130_fd_sc_hd__fill_2
XTAP_TAPCELL_ROW_42_1303 VGND VPWR sky130_fd_sc_hd__tapvpwrvgnd_1
XFILLER_74_1173 VGND VGND VPWR VPWR sky130_fd_sc_hd__decap_3
XFILLER_80_35 VGND VGND VPWR VPWR sky130_fd_sc_hd__decap_3
XFILLER_23_782 VGND VGND VPWR VPWR sky130_fd_sc_hd__fill_2
XFILLER_80_57 VGND VGND VPWR VPWR sky130_fd_sc_hd__decap_3
XFILLER_70_1037 VGND VGND VPWR VPWR sky130_fd_sc_hd__decap_3
Xfanout74 _4105_/A2 VGND VGND VPWR VPWR _4081_/A2 sky130_fd_sc_hd__clkdlybuf4s25_1
XFILLER_10_421 VGND VGND VPWR VPWR sky130_fd_sc_hd__decap_3
XFILLER_7_904 VGND VGND VPWR VPWR sky130_fd_sc_hd__decap_3
XFILLER_13_51 VGND VGND VPWR VPWR sky130_fd_sc_hd__decap_3
XFILLER_13_1422 VGND VGND VPWR VPWR sky130_fd_sc_hd__decap_3
XFILLER_13_1455 VGND VGND VPWR VPWR sky130_fd_sc_hd__fill_1
XFILLER_13_1466 VGND VGND VPWR VPWR sky130_fd_sc_hd__decap_3
XFILLER_6_458 VGND VGND VPWR VPWR sky130_fd_sc_hd__decap_3
XTAP_TAPCELL_ROW_36_1129 VGND VPWR sky130_fd_sc_hd__tapvpwrvgnd_1
XFILLER_78_900 VGND VGND VPWR VPWR sky130_fd_sc_hd__decap_3
Xload_slew829 fanout828/X VGND VGND VPWR VPWR load_slew829/X sky130_fd_sc_hd__clkbuf_4
XFILLER_1_152 VGND VGND VPWR VPWR sky130_fd_sc_hd__decap_3
XFILLER_2_675 VGND VGND VPWR VPWR sky130_fd_sc_hd__decap_3
XFILLER_46_1253 VGND VGND VPWR VPWR sky130_fd_sc_hd__decap_3
XFILLER_46_1264 VGND VGND VPWR VPWR sky130_fd_sc_hd__decap_3
XFILLER_49_101 VGND VGND VPWR VPWR sky130_fd_sc_hd__fill_2
XFILLER_29_9 VGND VGND VPWR VPWR sky130_fd_sc_hd__fill_1
XFILLER_1_196 VGND VGND VPWR VPWR sky130_fd_sc_hd__decap_3
XFILLER_49_134 VGND VGND VPWR VPWR sky130_fd_sc_hd__decap_3
XFILLER_46_1297 VGND VGND VPWR VPWR sky130_fd_sc_hd__decap_3
XFILLER_38_819 VGND VGND VPWR VPWR sky130_fd_sc_hd__decap_3
XFILLER_42_1139 VGND VGND VPWR VPWR sky130_fd_sc_hd__decap_3
XFILLER_20_1415 VGND VGND VPWR VPWR sky130_fd_sc_hd__decap_3
XFILLER_79_1051 VGND VGND VPWR VPWR sky130_fd_sc_hd__fill_1
XFILLER_20_1459 VGND VGND VPWR VPWR sky130_fd_sc_hd__decap_3
XFILLER_45_351 VGND VGND VPWR VPWR sky130_fd_sc_hd__decap_3
XFILLER_79_1073 VGND VGND VPWR VPWR sky130_fd_sc_hd__decap_3
XFILLER_2_1391 VGND VGND VPWR VPWR sky130_fd_sc_hd__decap_3
XFILLER_18_1300 VGND VGND VPWR VPWR sky130_fd_sc_hd__decap_3
XFILLER_57_1360 VGND VGND VPWR VPWR sky130_fd_sc_hd__decap_3
XFILLER_60_354 VGND VGND VPWR VPWR sky130_fd_sc_hd__decap_3
XFILLER_18_1344 VGND VGND VPWR VPWR sky130_fd_sc_hd__decap_3
XFILLER_57_1393 VGND VGND VPWR VPWR sky130_fd_sc_hd__decap_3
XFILLER_13_270 VGND VGND VPWR VPWR sky130_fd_sc_hd__decap_3
X_3730_ _6343_/Q wire339/A _3728_/X _3729_/X VGND VGND VPWR VPWR _4303_/A sky130_fd_sc_hd__o22a_2
XFILLER_60_398 VGND VGND VPWR VPWR sky130_fd_sc_hd__decap_3
XFILLER_14_1208 VGND VGND VPWR VPWR sky130_fd_sc_hd__decap_3
XFILLER_53_1257 VGND VGND VPWR VPWR sky130_fd_sc_hd__decap_3
XFILLER_13_281 VGND VGND VPWR VPWR sky130_fd_sc_hd__decap_3
XFILLER_18_1388 VGND VGND VPWR VPWR sky130_fd_sc_hd__decap_3
X_3661_ _3671_/A _3661_/B _3661_/C VGND VGND VPWR VPWR _3661_/X sky130_fd_sc_hd__and3b_2
XFILLER_9_296 VGND VGND VPWR VPWR sky130_fd_sc_hd__fill_1
Xclkload11 _6858_/CLK VGND VGND VPWR VPWR clkload11/X sky130_fd_sc_hd__clkbuf_8
X_5400_ _5400_/A1 _5464_/A2 _4433_/X VGND VGND VPWR VPWR _6512_/D sky130_fd_sc_hd__a21o_2
Xclkload22 _6970_/CLK VGND VGND VPWR VPWR clkload22/X sky130_fd_sc_hd__clkbuf_8
XTAP_TAPCELL_ROW_11_482 VGND VPWR sky130_fd_sc_hd__tapvpwrvgnd_1
X_6380_ _6974_/CLK _6380_/D fanout765/X VGND VGND VPWR VPWR _6380_/Q sky130_fd_sc_hd__dfrtp_2
XFILLER_62_3 VGND VGND VPWR VPWR sky130_fd_sc_hd__decap_3
Xclkload33 _6905_/CLK VGND VGND VPWR VPWR clkload33/X sky130_fd_sc_hd__clkbuf_4
Xclkload44 _7052_/CLK VGND VGND VPWR VPWR clkload44/X sky130_fd_sc_hd__clkbuf_8
X_3592_ _6325_/Q _6333_/Q _6341_/Q _6245_/Q _3601_/B _3601_/A VGND VGND VPWR VPWR
+ _3593_/B sky130_fd_sc_hd__mux4_2
Xclkload55 _6807_/CLK VGND VGND VPWR VPWR clkload55/X sky130_fd_sc_hd__clkbuf_8
XTAP_TAPCELL_ROW_11_493 VGND VPWR sky130_fd_sc_hd__tapvpwrvgnd_1
X_5331_ _6458_/Q _5330_/X _5331_/S VGND VGND VPWR VPWR _6458_/D sky130_fd_sc_hd__mux2_1
XFILLER_6_981 VGND VGND VPWR VPWR sky130_fd_sc_hd__decap_3
X_5262_ _6767_/Q _5261_/A _5337_/S _5261_/Y VGND VGND VPWR VPWR _5262_/X sky130_fd_sc_hd__o211a_2
XFILLER_29_1440 VGND VGND VPWR VPWR sky130_fd_sc_hd__decap_3
XFILLER_64_1320 VGND VGND VPWR VPWR sky130_fd_sc_hd__decap_3
XFILLER_69_900 VGND VGND VPWR VPWR sky130_fd_sc_hd__decap_3
X_7001_ _7001_/CLK _7001_/D load_slew769/X VGND VGND VPWR VPWR _7001_/Q sky130_fd_sc_hd__dfrtp_2
X_4213_ _6482_/Q _4330_/A2 _4881_/A _4212_/Y VGND VGND VPWR VPWR _4213_/X sky130_fd_sc_hd__o211a_2
XFILLER_25_1304 VGND VGND VPWR VPWR sky130_fd_sc_hd__decap_3
XFILLER_64_1353 VGND VGND VPWR VPWR sky130_fd_sc_hd__decap_3
X_5193_ _5192_/Y _5114_/X _5287_/A2 _6405_/Q VGND VGND VPWR VPWR _6405_/D sky130_fd_sc_hd__a2bb2o_2
XFILLER_68_432 VGND VGND VPWR VPWR sky130_fd_sc_hd__decap_3
XFILLER_25_1337 VGND VGND VPWR VPWR sky130_fd_sc_hd__decap_3
XFILLER_25_1348 VGND VGND VPWR VPWR sky130_fd_sc_hd__decap_3
X_4144_ _3933_/A _4747_/B _4139_/X _5358_/C VGND VGND VPWR VPWR _4144_/X sky130_fd_sc_hd__o2bb2a_2
XFILLER_64_1397 VGND VGND VPWR VPWR sky130_fd_sc_hd__decap_3
XFILLER_18_29 VGND VGND VPWR VPWR sky130_fd_sc_hd__fill_2
XFILLER_28_318 VGND VGND VPWR VPWR sky130_fd_sc_hd__decap_3
XFILLER_55_104 VGND VGND VPWR VPWR sky130_fd_sc_hd__fill_2
X_4075_ _6242_/Q wire77/X _4073_/X _4074_/X VGND VGND VPWR VPWR _6242_/D sky130_fd_sc_hd__o22a_2
XFILLER_3_1133 VGND VGND VPWR VPWR sky130_fd_sc_hd__decap_3
XFILLER_23_1061 VGND VGND VPWR VPWR sky130_fd_sc_hd__decap_3
XFILLER_3_1166 VGND VGND VPWR VPWR sky130_fd_sc_hd__decap_3
XFILLER_3_1177 VGND VGND VPWR VPWR sky130_fd_sc_hd__decap_3
XFILLER_36_351 VGND VGND VPWR VPWR sky130_fd_sc_hd__fill_2
XFILLER_24_502 VGND VGND VPWR VPWR sky130_fd_sc_hd__decap_3
XFILLER_52_811 VGND VGND VPWR VPWR sky130_fd_sc_hd__fill_1
XFILLER_52_822 VGND VGND VPWR VPWR sky130_fd_sc_hd__decap_3
XFILLER_58_1135 VGND VGND VPWR VPWR sky130_fd_sc_hd__decap_3
XFILLER_64_682 VGND VGND VPWR VPWR sky130_fd_sc_hd__fill_2
XFILLER_34_39 VGND VGND VPWR VPWR sky130_fd_sc_hd__decap_3
XFILLER_51_332 VGND VGND VPWR VPWR sky130_fd_sc_hd__decap_3
XFILLER_36_1400 VGND VGND VPWR VPWR sky130_fd_sc_hd__decap_3
XFILLER_75_1460 VGND VGND VPWR VPWR sky130_fd_sc_hd__decap_3
XFILLER_24_568 VGND VGND VPWR VPWR sky130_fd_sc_hd__fill_1
XFILLER_71_1313 VGND VGND VPWR VPWR sky130_fd_sc_hd__decap_3
X_4977_ _6692_/Q _3058_/Y _5314_/S VGND VGND VPWR VPWR _4977_/X sky130_fd_sc_hd__mux2_1
Xclkbuf_4_9__f_clk clkbuf_3_4_0_clk/X VGND VGND VPWR VPWR clkload4/A sky130_fd_sc_hd__clkbuf_16
XFILLER_36_1444 VGND VGND VPWR VPWR sky130_fd_sc_hd__decap_3
XFILLER_51_387 VGND VGND VPWR VPWR sky130_fd_sc_hd__decap_3
X_6716_ _7019_/CLK _6716_/D fanout838/X VGND VGND VPWR VPWR _6716_/Q sky130_fd_sc_hd__dfrtp_2
X_3928_ _6229_/Q _3928_/A2 _3928_/B1 _6221_/Q _3928_/C1 VGND VGND VPWR VPWR _3928_/X
+ sky130_fd_sc_hd__a221o_2
XFILLER_71_1357 VGND VGND VPWR VPWR sky130_fd_sc_hd__decap_3
XFILLER_20_752 VGND VGND VPWR VPWR sky130_fd_sc_hd__decap_3
Xclkload5 clkload5/A VGND VGND VPWR VPWR clkload5/X sky130_fd_sc_hd__clkbuf_8
XFILLER_20_763 VGND VGND VPWR VPWR sky130_fd_sc_hd__decap_3
XTAP_TAPCELL_ROW_22_769 VGND VPWR sky130_fd_sc_hd__tapvpwrvgnd_1
X_6647_ _6958_/CLK _6647_/D load_slew760/X VGND VGND VPWR VPWR _6647_/Q sky130_fd_sc_hd__dfrtp_2
X_3859_ _6292_/Q _4010_/B _3902_/B1 _6268_/Q _3902_/C1 VGND VGND VPWR VPWR _3859_/X
+ sky130_fd_sc_hd__a221o_2
XFILLER_50_49 VGND VGND VPWR VPWR sky130_fd_sc_hd__decap_3
XFILLER_30_1032 VGND VGND VPWR VPWR sky130_fd_sc_hd__decap_3
X_6578_ _6863_/CLK _6578_/D fanout793/X VGND VGND VPWR VPWR _6578_/Q sky130_fd_sc_hd__dfrtp_2
XFILLER_4_918 VGND VGND VPWR VPWR sky130_fd_sc_hd__decap_3
XFILLER_69_1231 VGND VGND VPWR VPWR sky130_fd_sc_hd__fill_1
XTAP_TAPCELL_ROW_76_2166 VGND VPWR sky130_fd_sc_hd__tapvpwrvgnd_1
XTAP_TAPCELL_ROW_76_2177 VGND VPWR sky130_fd_sc_hd__tapvpwrvgnd_1
XFILLER_3_417 VGND VGND VPWR VPWR sky130_fd_sc_hd__decap_3
XFILLER_69_1242 VGND VGND VPWR VPWR sky130_fd_sc_hd__decap_3
X_5529_ _6613_/Q _6617_/Q VGND VGND VPWR VPWR _5529_/Y sky130_fd_sc_hd__nand2_2
XTAP_TAPCELL_ROW_76_2188 VGND VPWR sky130_fd_sc_hd__tapvpwrvgnd_1
XFILLER_69_1275 VGND VGND VPWR VPWR sky130_fd_sc_hd__decap_3
XFILLER_65_1117 VGND VGND VPWR VPWR sky130_fd_sc_hd__decap_3
XFILLER_79_719 VGND VGND VPWR VPWR sky130_fd_sc_hd__decap_3
XFILLER_59_69 VGND VGND VPWR VPWR sky130_fd_sc_hd__fill_2
XFILLER_43_1404 VGND VGND VPWR VPWR sky130_fd_sc_hd__decap_3
Xfanout220 fanout234/X VGND VGND VPWR VPWR _5997_/S sky130_fd_sc_hd__clkdlybuf4s25_1
Xfanout231 _6035_/S VGND VGND VPWR VPWR _6031_/S sky130_fd_sc_hd__clkdlybuf4s25_1
Xfanout242 _5486_/A2 VGND VGND VPWR VPWR _5480_/A2 sky130_fd_sc_hd__clkdlybuf4s25_1
XTAP_TAPCELL_ROW_31_1004 VGND VPWR sky130_fd_sc_hd__tapvpwrvgnd_1
XFILLER_43_1437 VGND VGND VPWR VPWR sky130_fd_sc_hd__decap_3
XFILLER_59_443 VGND VGND VPWR VPWR sky130_fd_sc_hd__decap_3
Xfanout253 _5359_/X VGND VGND VPWR VPWR _5484_/A2 sky130_fd_sc_hd__clkdlybuf4s25_1
XFILLER_8_1055 VGND VGND VPWR VPWR sky130_fd_sc_hd__decap_3
XTAP_TAPCELL_ROW_31_1015 VGND VPWR sky130_fd_sc_hd__tapvpwrvgnd_1
XFILLER_75_925 VGND VGND VPWR VPWR sky130_fd_sc_hd__decap_3
XFILLER_8_1077 VGND VGND VPWR VPWR sky130_fd_sc_hd__decap_3
XFILLER_19_307 VGND VGND VPWR VPWR sky130_fd_sc_hd__decap_3
XFILLER_75_24 VGND VGND VPWR VPWR sky130_fd_sc_hd__decap_3
XFILLER_74_402 VGND VGND VPWR VPWR sky130_fd_sc_hd__decap_3
Xfanout286 _4774_/A2 VGND VGND VPWR VPWR _4080_/B1 sky130_fd_sc_hd__clkdlybuf4s25_1
XFILLER_19_318 VGND VGND VPWR VPWR sky130_fd_sc_hd__decap_3
XFILLER_75_57 VGND VGND VPWR VPWR sky130_fd_sc_hd__decap_3
XFILLER_46_137 VGND VGND VPWR VPWR sky130_fd_sc_hd__decap_3
XFILLER_28_852 VGND VGND VPWR VPWR sky130_fd_sc_hd__decap_3
XFILLER_41_1183 VGND VGND VPWR VPWR sky130_fd_sc_hd__decap_3
XFILLER_15_502 VGND VGND VPWR VPWR sky130_fd_sc_hd__fill_2
XFILLER_43_811 VGND VGND VPWR VPWR sky130_fd_sc_hd__fill_1
XFILLER_15_513 VGND VGND VPWR VPWR sky130_fd_sc_hd__decap_3
XFILLER_76_1235 VGND VGND VPWR VPWR sky130_fd_sc_hd__decap_3
XFILLER_43_833 VGND VGND VPWR VPWR sky130_fd_sc_hd__decap_3
XFILLER_43_844 VGND VGND VPWR VPWR sky130_fd_sc_hd__decap_3
XFILLER_54_181 VGND VGND VPWR VPWR sky130_fd_sc_hd__decap_3
XFILLER_15_546 VGND VGND VPWR VPWR sky130_fd_sc_hd__fill_1
Xclkbuf_leaf_81_clk clkbuf_leaf_3_clk/A VGND VGND VPWR VPWR _6865_/CLK sky130_fd_sc_hd__clkbuf_8
XFILLER_15_557 VGND VGND VPWR VPWR sky130_fd_sc_hd__decap_3
XFILLER_43_866 VGND VGND VPWR VPWR sky130_fd_sc_hd__decap_3
XFILLER_76_1279 VGND VGND VPWR VPWR sky130_fd_sc_hd__decap_3
XFILLER_15_579 VGND VGND VPWR VPWR sky130_fd_sc_hd__decap_3
XFILLER_42_354 VGND VGND VPWR VPWR sky130_fd_sc_hd__decap_3
XFILLER_42_365 VGND VGND VPWR VPWR sky130_fd_sc_hd__fill_1
XTAP_TAPCELL_ROW_65_1881 VGND VPWR sky130_fd_sc_hd__tapvpwrvgnd_1
XFILLER_42_387 VGND VGND VPWR VPWR sky130_fd_sc_hd__decap_3
XTAP_TAPCELL_ROW_65_1892 VGND VPWR sky130_fd_sc_hd__tapvpwrvgnd_1
XFILLER_24_61 VGND VGND VPWR VPWR sky130_fd_sc_hd__decap_3
XTAP_TAPCELL_ROW_61_1778 VGND VPWR sky130_fd_sc_hd__tapvpwrvgnd_1
XFILLER_11_763 VGND VGND VPWR VPWR sky130_fd_sc_hd__decap_3
XTAP_TAPCELL_ROW_61_1789 VGND VPWR sky130_fd_sc_hd__tapvpwrvgnd_1
Xwire632 input3/X VGND VGND VPWR VPWR _5789_/C sky130_fd_sc_hd__buf_4
XFILLER_7_723 VGND VGND VPWR VPWR sky130_fd_sc_hd__decap_3
XFILLER_6_200 VGND VGND VPWR VPWR sky130_fd_sc_hd__fill_2
XFILLER_10_262 VGND VGND VPWR VPWR sky130_fd_sc_hd__decap_3
XFILLER_13_1230 VGND VGND VPWR VPWR sky130_fd_sc_hd__fill_2
XFILLER_10_284 VGND VGND VPWR VPWR sky130_fd_sc_hd__decap_3
XFILLER_6_244 VGND VGND VPWR VPWR sky130_fd_sc_hd__decap_3
XFILLER_13_1263 VGND VGND VPWR VPWR sky130_fd_sc_hd__decap_3
Xwire687 wire687/A VGND VGND VPWR VPWR wire687/X sky130_fd_sc_hd__clkbuf_4
XFILLER_6_299 VGND VGND VPWR VPWR sky130_fd_sc_hd__decap_3
XFILLER_48_1315 VGND VGND VPWR VPWR sky130_fd_sc_hd__fill_1
XFILLER_48_1326 VGND VGND VPWR VPWR sky130_fd_sc_hd__decap_3
XFILLER_3_951 VGND VGND VPWR VPWR sky130_fd_sc_hd__fill_1
XFILLER_3_962 VGND VGND VPWR VPWR sky130_fd_sc_hd__decap_3
XFILLER_48_1359 VGND VGND VPWR VPWR sky130_fd_sc_hd__decap_3
Xload_slew637 fanout636/X VGND VGND VPWR VPWR load_slew637/X sky130_fd_sc_hd__clkbuf_4
Xload_slew648 fanout647/X VGND VGND VPWR VPWR load_slew648/X sky130_fd_sc_hd__buf_2
XFILLER_46_1083 VGND VGND VPWR VPWR sky130_fd_sc_hd__fill_1
XFILLER_66_925 VGND VGND VPWR VPWR sky130_fd_sc_hd__decap_3
XFILLER_1_21 VGND VGND VPWR VPWR sky130_fd_sc_hd__decap_3
XFILLER_65_413 VGND VGND VPWR VPWR sky130_fd_sc_hd__decap_3
XFILLER_65_424 VGND VGND VPWR VPWR sky130_fd_sc_hd__decap_3
XFILLER_19_830 VGND VGND VPWR VPWR sky130_fd_sc_hd__fill_1
XFILLER_1_54 VGND VGND VPWR VPWR sky130_fd_sc_hd__fill_2
XFILLER_4_1453 VGND VGND VPWR VPWR sky130_fd_sc_hd__decap_3
XFILLER_37_148 VGND VGND VPWR VPWR sky130_fd_sc_hd__decap_3
XFILLER_1_87 VGND VGND VPWR VPWR sky130_fd_sc_hd__decap_3
XFILLER_19_863 VGND VGND VPWR VPWR sky130_fd_sc_hd__decap_3
XFILLER_20_1234 VGND VGND VPWR VPWR sky130_fd_sc_hd__decap_3
XFILLER_0_1317 VGND VGND VPWR VPWR sky130_fd_sc_hd__decap_3
XFILLER_59_1422 VGND VGND VPWR VPWR sky130_fd_sc_hd__decap_3
XFILLER_20_1267 VGND VGND VPWR VPWR sky130_fd_sc_hd__decap_3
X_4900_ _7081_/Q _5354_/S _3483_/B VGND VGND VPWR VPWR _4900_/X sky130_fd_sc_hd__o21a_2
XFILLER_59_1455 VGND VGND VPWR VPWR sky130_fd_sc_hd__fill_1
X_5880_ _5784_/C _5880_/A1 _5887_/S VGND VGND VPWR VPWR _6890_/D sky130_fd_sc_hd__mux2_1
XFILLER_59_1466 VGND VGND VPWR VPWR sky130_fd_sc_hd__decap_3
Xclkbuf_leaf_72_clk clkbuf_4_8__f_clk/X VGND VGND VPWR VPWR _6918_/CLK sky130_fd_sc_hd__clkbuf_8
XFILLER_55_1319 VGND VGND VPWR VPWR sky130_fd_sc_hd__decap_3
X_4831_ _4831_/A1 _4828_/X _4829_/Y _4830_/X _4831_/C1 VGND VGND VPWR VPWR _4831_/X
+ sky130_fd_sc_hd__o221a_2
XFILLER_21_505 VGND VGND VPWR VPWR sky130_fd_sc_hd__fill_1
XFILLER_18_1130 VGND VGND VPWR VPWR sky130_fd_sc_hd__fill_1
XFILLER_53_1021 VGND VGND VPWR VPWR sky130_fd_sc_hd__fill_1
X_4762_ _6573_/Q _4762_/B VGND VGND VPWR VPWR _4762_/Y sky130_fd_sc_hd__nand2_2
XFILLER_53_1054 VGND VGND VPWR VPWR sky130_fd_sc_hd__fill_2
XFILLER_53_1065 VGND VGND VPWR VPWR sky130_fd_sc_hd__decap_3
X_6501_ _6910_/CLK _6501_/D load_slew784/X VGND VGND VPWR VPWR _6501_/Q sky130_fd_sc_hd__dfrtp_2
X_3713_ _4428_/A _4547_/B VGND VGND VPWR VPWR _3713_/X sky130_fd_sc_hd__and2_2
X_4693_ _6315_/Q wire49/X _4690_/X _4692_/X VGND VGND VPWR VPWR _6315_/D sky130_fd_sc_hd__o22a_2
XFILLER_14_1049 VGND VGND VPWR VPWR sky130_fd_sc_hd__decap_3
X_6432_ _7032_/CLK _6432_/D fanout691/X VGND VGND VPWR VPWR _6432_/Q sky130_fd_sc_hd__dfrtp_2
X_3644_ _3581_/Y _3644_/B _3644_/C VGND VGND VPWR VPWR _3673_/B sky130_fd_sc_hd__and3b_2
XFILLER_31_1363 VGND VGND VPWR VPWR sky130_fd_sc_hd__decap_3
X_6363_ _6765_/CLK _6363_/D wire655/X VGND VGND VPWR VPWR _6363_/Q sky130_fd_sc_hd__dfrtp_2
XFILLER_31_1396 VGND VGND VPWR VPWR sky130_fd_sc_hd__decap_3
X_3575_ _3576_/B _3576_/C VGND VGND VPWR VPWR _3640_/B sky130_fd_sc_hd__nand2_2
XFILLER_66_1415 VGND VGND VPWR VPWR sky130_fd_sc_hd__decap_3
X_5314_ _6788_/Q _4973_/B _5314_/S VGND VGND VPWR VPWR _5314_/X sky130_fd_sc_hd__mux2_1
X_6294_ _7024_/CLK _6294_/D fanout699/A VGND VGND VPWR VPWR _6294_/Q sky130_fd_sc_hd__dfrtp_2
XTAP_TAPCELL_ROW_71_2041 VGND VPWR sky130_fd_sc_hd__tapvpwrvgnd_1
XFILLER_66_1459 VGND VGND VPWR VPWR sky130_fd_sc_hd__decap_3
XTAP_TAPCELL_ROW_71_2052 VGND VPWR sky130_fd_sc_hd__tapvpwrvgnd_1
X_5245_ _6423_/Q wire112/A _5244_/X VGND VGND VPWR VPWR _6423_/D sky130_fd_sc_hd__a21o_2
XFILLER_9_1331 VGND VGND VPWR VPWR sky130_fd_sc_hd__decap_3
XFILLER_64_1161 VGND VGND VPWR VPWR sky130_fd_sc_hd__decap_3
XFILLER_29_1281 VGND VGND VPWR VPWR sky130_fd_sc_hd__decap_3
XFILLER_29_1292 VGND VGND VPWR VPWR sky130_fd_sc_hd__decap_3
XFILLER_9_1375 VGND VGND VPWR VPWR sky130_fd_sc_hd__decap_3
X_5176_ _6735_/Q _5334_/S VGND VGND VPWR VPWR _5176_/X sky130_fd_sc_hd__or2_2
XFILLER_68_251 VGND VGND VPWR VPWR sky130_fd_sc_hd__fill_1
XFILLER_57_925 VGND VGND VPWR VPWR sky130_fd_sc_hd__decap_3
XFILLER_69_785 VGND VGND VPWR VPWR sky130_fd_sc_hd__fill_1
XFILLER_5_1228 VGND VGND VPWR VPWR sky130_fd_sc_hd__decap_3
XFILLER_5_1239 VGND VGND VPWR VPWR sky130_fd_sc_hd__decap_3
X_4127_ _6249_/Q _4622_/S _4124_/X _4126_/X VGND VGND VPWR VPWR _6249_/D sky130_fd_sc_hd__o22a_2
XFILLER_29_649 VGND VGND VPWR VPWR sky130_fd_sc_hd__decap_3
XFILLER_28_137 VGND VGND VPWR VPWR sky130_fd_sc_hd__decap_3
XFILLER_72_906 VGND VGND VPWR VPWR sky130_fd_sc_hd__decap_3
XTAP_TAPCELL_ROW_3_269 VGND VPWR sky130_fd_sc_hd__tapvpwrvgnd_1
XFILLER_72_928 VGND VGND VPWR VPWR sky130_fd_sc_hd__decap_3
XFILLER_25_800 VGND VGND VPWR VPWR sky130_fd_sc_hd__decap_3
X_4058_ _4738_/A _3957_/X _6592_/Q _5515_/A1 VGND VGND VPWR VPWR _4058_/X sky130_fd_sc_hd__a2bb2o_2
XFILLER_43_107 VGND VGND VPWR VPWR sky130_fd_sc_hd__decap_3
XFILLER_37_671 VGND VGND VPWR VPWR sky130_fd_sc_hd__fill_1
XFILLER_71_449 VGND VGND VPWR VPWR sky130_fd_sc_hd__decap_3
XFILLER_25_844 VGND VGND VPWR VPWR sky130_fd_sc_hd__fill_2
Xclkbuf_leaf_63_clk clkbuf_leaf_67_clk/A VGND VGND VPWR VPWR _7012_/CLK sky130_fd_sc_hd__clkbuf_8
XFILLER_36_192 VGND VGND VPWR VPWR sky130_fd_sc_hd__decap_3
XFILLER_73_1419 VGND VGND VPWR VPWR sky130_fd_sc_hd__decap_3
XFILLER_24_354 VGND VGND VPWR VPWR sky130_fd_sc_hd__fill_1
XFILLER_40_825 VGND VGND VPWR VPWR sky130_fd_sc_hd__decap_3
XFILLER_52_696 VGND VGND VPWR VPWR sky130_fd_sc_hd__decap_3
XFILLER_71_1132 VGND VGND VPWR VPWR sky130_fd_sc_hd__decap_3
XFILLER_12_549 VGND VGND VPWR VPWR sky130_fd_sc_hd__decap_3
XFILLER_36_1252 VGND VGND VPWR VPWR sky130_fd_sc_hd__decap_3
XFILLER_40_869 VGND VGND VPWR VPWR sky130_fd_sc_hd__decap_3
XTAP_TAPCELL_ROW_78_2217 VGND VPWR sky130_fd_sc_hd__tapvpwrvgnd_1
XFILLER_71_1165 VGND VGND VPWR VPWR sky130_fd_sc_hd__decap_3
XFILLER_36_1285 VGND VGND VPWR VPWR sky130_fd_sc_hd__decap_3
XTAP_TAPCELL_ROW_78_2228 VGND VPWR sky130_fd_sc_hd__tapvpwrvgnd_1
XTAP_TAPCELL_ROW_78_2239 VGND VPWR sky130_fd_sc_hd__tapvpwrvgnd_1
XFILLER_20_560 VGND VGND VPWR VPWR sky130_fd_sc_hd__decap_3
XFILLER_71_1198 VGND VGND VPWR VPWR sky130_fd_sc_hd__decap_3
XFILLER_10_1403 VGND VGND VPWR VPWR sky130_fd_sc_hd__decap_3
XFILLER_4_704 VGND VGND VPWR VPWR sky130_fd_sc_hd__decap_3
XFILLER_10_1447 VGND VGND VPWR VPWR sky130_fd_sc_hd__decap_3
XFILLER_3_236 VGND VGND VPWR VPWR sky130_fd_sc_hd__decap_3
XFILLER_10_52 VGND VGND VPWR VPWR sky130_fd_sc_hd__decap_3
XFILLER_79_505 VGND VGND VPWR VPWR sky130_fd_sc_hd__decap_3
XFILLER_10_85 VGND VGND VPWR VPWR sky130_fd_sc_hd__decap_3
XFILLER_79_538 VGND VGND VPWR VPWR sky130_fd_sc_hd__decap_3
XFILLER_0_921 VGND VGND VPWR VPWR sky130_fd_sc_hd__decap_3
XFILLER_0_943 VGND VGND VPWR VPWR sky130_fd_sc_hd__decap_3
XFILLER_47_1381 VGND VGND VPWR VPWR sky130_fd_sc_hd__decap_3
XFILLER_0_965 VGND VGND VPWR VPWR sky130_fd_sc_hd__decap_3
XFILLER_48_914 VGND VGND VPWR VPWR sky130_fd_sc_hd__fill_2
XTAP_TAPCELL_ROW_54_1593 VGND VPWR sky130_fd_sc_hd__tapvpwrvgnd_1
XFILLER_0_987 VGND VGND VPWR VPWR sky130_fd_sc_hd__decap_3
XFILLER_43_1245 VGND VGND VPWR VPWR sky130_fd_sc_hd__decap_3
XFILLER_47_413 VGND VGND VPWR VPWR sky130_fd_sc_hd__fill_1
XFILLER_74_210 VGND VGND VPWR VPWR sky130_fd_sc_hd__decap_3
XFILLER_43_1278 VGND VGND VPWR VPWR sky130_fd_sc_hd__decap_3
XFILLER_48_947 VGND VGND VPWR VPWR sky130_fd_sc_hd__decap_3
XFILLER_59_284 VGND VGND VPWR VPWR sky130_fd_sc_hd__decap_3
XFILLER_75_744 VGND VGND VPWR VPWR sky130_fd_sc_hd__decap_3
XFILLER_47_435 VGND VGND VPWR VPWR sky130_fd_sc_hd__decap_3
XFILLER_43_1289 VGND VGND VPWR VPWR sky130_fd_sc_hd__decap_3
XFILLER_75_755 VGND VGND VPWR VPWR sky130_fd_sc_hd__decap_3
XFILLER_75_788 VGND VGND VPWR VPWR sky130_fd_sc_hd__decap_3
XFILLER_28_660 VGND VGND VPWR VPWR sky130_fd_sc_hd__decap_3
XTAP_TAPCELL_ROW_67_1932 VGND VPWR sky130_fd_sc_hd__tapvpwrvgnd_1
XFILLER_76_1021 VGND VGND VPWR VPWR sky130_fd_sc_hd__decap_3
XFILLER_62_438 VGND VGND VPWR VPWR sky130_fd_sc_hd__decap_3
XTAP_TAPCELL_ROW_67_1943 VGND VPWR sky130_fd_sc_hd__tapvpwrvgnd_1
XFILLER_16_844 VGND VGND VPWR VPWR sky130_fd_sc_hd__decap_3
XTAP_TAPCELL_ROW_67_1954 VGND VPWR sky130_fd_sc_hd__tapvpwrvgnd_1
Xclkbuf_leaf_54_clk clkbuf_leaf_54_clk/A VGND VGND VPWR VPWR _7007_/CLK sky130_fd_sc_hd__clkbuf_8
XFILLER_15_354 VGND VGND VPWR VPWR sky130_fd_sc_hd__decap_3
XFILLER_31_803 VGND VGND VPWR VPWR sky130_fd_sc_hd__decap_3
XFILLER_35_60 VGND VGND VPWR VPWR sky130_fd_sc_hd__fill_1
XFILLER_76_1076 VGND VGND VPWR VPWR sky130_fd_sc_hd__decap_3
XTAP_TAPCELL_ROW_63_1829 VGND VPWR sky130_fd_sc_hd__tapvpwrvgnd_1
XFILLER_35_82 VGND VGND VPWR VPWR sky130_fd_sc_hd__decap_3
XTAP_TAPCELL_ROW_26_872 VGND VPWR sky130_fd_sc_hd__tapvpwrvgnd_1
XFILLER_43_685 VGND VGND VPWR VPWR sky130_fd_sc_hd__decap_3
XTAP_TAPCELL_ROW_26_883 VGND VPWR sky130_fd_sc_hd__tapvpwrvgnd_1
XFILLER_30_324 VGND VGND VPWR VPWR sky130_fd_sc_hd__decap_3
XFILLER_54_1341 VGND VGND VPWR VPWR sky130_fd_sc_hd__decap_3
XTAP_TAPCELL_ROW_13_533 VGND VPWR sky130_fd_sc_hd__tapvpwrvgnd_1
XFILLER_30_346 VGND VGND VPWR VPWR sky130_fd_sc_hd__decap_3
XTAP_TAPCELL_ROW_13_544 VGND VPWR sky130_fd_sc_hd__tapvpwrvgnd_1
XFILLER_15_1325 VGND VGND VPWR VPWR sky130_fd_sc_hd__decap_3
XFILLER_30_368 VGND VGND VPWR VPWR sky130_fd_sc_hd__decap_3
XFILLER_50_1205 VGND VGND VPWR VPWR sky130_fd_sc_hd__decap_3
XFILLER_54_1385 VGND VGND VPWR VPWR sky130_fd_sc_hd__decap_3
XFILLER_30_379 VGND VGND VPWR VPWR sky130_fd_sc_hd__decap_3
XFILLER_50_1249 VGND VGND VPWR VPWR sky130_fd_sc_hd__decap_3
XFILLER_15_1369 VGND VGND VPWR VPWR sky130_fd_sc_hd__decap_3
XFILLER_7_553 VGND VGND VPWR VPWR sky130_fd_sc_hd__decap_3
XFILLER_7_564 VGND VGND VPWR VPWR sky130_fd_sc_hd__decap_3
XFILLER_48_1123 VGND VGND VPWR VPWR sky130_fd_sc_hd__decap_3
X_3360_ _6299_/Q _6411_/Q VGND VGND VPWR VPWR _3360_/X sky130_fd_sc_hd__xor2_2
X_3291_ _5966_/A0 _3290_/X _3355_/S VGND VGND VPWR VPWR _6119_/D sky130_fd_sc_hd__mux2_1
XFILLER_26_1421 VGND VGND VPWR VPWR sky130_fd_sc_hd__decap_3
XFILLER_61_1301 VGND VGND VPWR VPWR sky130_fd_sc_hd__decap_3
XFILLER_2_291 VGND VGND VPWR VPWR sky130_fd_sc_hd__decap_3
XFILLER_26_1432 VGND VGND VPWR VPWR sky130_fd_sc_hd__decap_3
X_5030_ _6394_/Q _5252_/B VGND VGND VPWR VPWR _5030_/X sky130_fd_sc_hd__or2_2
XFILLER_25_3 VGND VGND VPWR VPWR sky130_fd_sc_hd__decap_3
XFILLER_61_1334 VGND VGND VPWR VPWR sky130_fd_sc_hd__decap_3
Xhold1209 _6860_/Q VGND VGND VPWR VPWR _5844_/A0 sky130_fd_sc_hd__dlygate4sd3_1
XFILLER_26_1465 VGND VGND VPWR VPWR sky130_fd_sc_hd__decap_3
XFILLER_61_1345 VGND VGND VPWR VPWR sky130_fd_sc_hd__decap_3
XFILLER_22_1329 VGND VGND VPWR VPWR sky130_fd_sc_hd__decap_3
XFILLER_61_1378 VGND VGND VPWR VPWR sky130_fd_sc_hd__decap_3
XFILLER_65_210 VGND VGND VPWR VPWR sky130_fd_sc_hd__decap_3
XFILLER_4_1250 VGND VGND VPWR VPWR sky130_fd_sc_hd__decap_3
XTAP_TAPCELL_ROW_0_206 VGND VPWR sky130_fd_sc_hd__tapvpwrvgnd_1
XFILLER_38_468 VGND VGND VPWR VPWR sky130_fd_sc_hd__decap_3
XFILLER_54_917 VGND VGND VPWR VPWR sky130_fd_sc_hd__decap_3
XFILLER_54_928 VGND VGND VPWR VPWR sky130_fd_sc_hd__fill_1
XFILLER_4_1261 VGND VGND VPWR VPWR sky130_fd_sc_hd__decap_3
X_6981_ clkload8/A _6981_/D load_slew637/X VGND VGND VPWR VPWR _6981_/Q sky130_fd_sc_hd__dfrtp_2
XFILLER_53_405 VGND VGND VPWR VPWR sky130_fd_sc_hd__decap_3
XFILLER_66_799 VGND VGND VPWR VPWR sky130_fd_sc_hd__decap_3
XFILLER_0_1114 VGND VGND VPWR VPWR sky130_fd_sc_hd__decap_3
XFILLER_4_1294 VGND VGND VPWR VPWR sky130_fd_sc_hd__decap_3
XFILLER_25_129 VGND VGND VPWR VPWR sky130_fd_sc_hd__fill_1
XFILLER_47_991 VGND VGND VPWR VPWR sky130_fd_sc_hd__decap_3
X_5932_ _5932_/A0 _5932_/A1 _5932_/S VGND VGND VPWR VPWR _6937_/D sky130_fd_sc_hd__mux2_1
XFILLER_0_1136 VGND VGND VPWR VPWR sky130_fd_sc_hd__decap_3
XFILLER_65_298 VGND VGND VPWR VPWR sky130_fd_sc_hd__decap_3
Xclkbuf_leaf_45_clk clkbuf_leaf_47_clk/A VGND VGND VPWR VPWR _6772_/CLK sky130_fd_sc_hd__clkbuf_8
XFILLER_20_1086 VGND VGND VPWR VPWR sky130_fd_sc_hd__decap_3
XFILLER_0_1158 VGND VGND VPWR VPWR sky130_fd_sc_hd__decap_3
XFILLER_59_1263 VGND VGND VPWR VPWR sky130_fd_sc_hd__decap_3
X_5863_ _5863_/A0 _5901_/A0 _5867_/S VGND VGND VPWR VPWR _6877_/D sky130_fd_sc_hd__mux2_1
XFILLER_61_460 VGND VGND VPWR VPWR sky130_fd_sc_hd__decap_3
XFILLER_55_1138 VGND VGND VPWR VPWR sky130_fd_sc_hd__decap_3
X_4814_ _4312_/B _6580_/Q _4835_/S VGND VGND VPWR VPWR _4814_/X sky130_fd_sc_hd__mux2_1
XFILLER_72_1441 VGND VGND VPWR VPWR sky130_fd_sc_hd__decap_3
XFILLER_22_869 VGND VGND VPWR VPWR sky130_fd_sc_hd__decap_3
X_5794_ _5794_/A1 _5783_/X _5841_/C _5793_/X VGND VGND VPWR VPWR _6821_/D sky130_fd_sc_hd__a22o_2
XFILLER_33_1425 VGND VGND VPWR VPWR sky130_fd_sc_hd__decap_3
X_4745_ _6322_/Q _4745_/A2 _4742_/X _4744_/X VGND VGND VPWR VPWR _6322_/D sky130_fd_sc_hd__o22a_2
X_4676_ _4793_/A _4673_/X _4674_/Y _4675_/X _4604_/A VGND VGND VPWR VPWR _4676_/X
+ sky130_fd_sc_hd__o221a_2
XTAP_TAPCELL_ROW_73_2103 VGND VPWR sky130_fd_sc_hd__tapvpwrvgnd_1
X_6415_ _7041_/CLK _6415_/D fanout729/X VGND VGND VPWR VPWR _6415_/Q sky130_fd_sc_hd__dfrtp_2
X_3627_ _3624_/X _3626_/X _4532_/B VGND VGND VPWR VPWR _3627_/X sky130_fd_sc_hd__mux2_1
XFILLER_66_1201 VGND VGND VPWR VPWR sky130_fd_sc_hd__decap_3
XFILLER_66_1223 VGND VGND VPWR VPWR sky130_fd_sc_hd__decap_3
X_6346_ _7019_/CLK _6346_/D fanout836/X VGND VGND VPWR VPWR _6346_/Q sky130_fd_sc_hd__dfrtp_2
XFILLER_1_718 VGND VGND VPWR VPWR sky130_fd_sc_hd__decap_3
X_3558_ _6297_/Q _6305_/Q _6313_/Q _6233_/Q _3550_/B _3566_/A VGND VGND VPWR VPWR
+ _3558_/X sky130_fd_sc_hd__mux4_2
XFILLER_0_206 VGND VGND VPWR VPWR sky130_fd_sc_hd__decap_3
XFILLER_1_729 VGND VGND VPWR VPWR sky130_fd_sc_hd__decap_3
XFILLER_66_1256 VGND VGND VPWR VPWR sky130_fd_sc_hd__decap_3
XFILLER_66_1267 VGND VGND VPWR VPWR sky130_fd_sc_hd__decap_3
XFILLER_0_228 VGND VGND VPWR VPWR sky130_fd_sc_hd__decap_3
X_6277_ _6847_/CLK _6277_/D load_slew778/X VGND VGND VPWR VPWR _6277_/Q sky130_fd_sc_hd__dfrtp_2
X_3489_ _3489_/A _3490_/B _3490_/C VGND VGND VPWR VPWR _3489_/Y sky130_fd_sc_hd__nor3_2
XFILLER_76_508 VGND VGND VPWR VPWR sky130_fd_sc_hd__decap_3
X_5228_ _5314_/S _5228_/B VGND VGND VPWR VPWR _5228_/Y sky130_fd_sc_hd__nand2_2
XFILLER_9_1172 VGND VGND VPWR VPWR sky130_fd_sc_hd__decap_3
XFILLER_29_402 VGND VGND VPWR VPWR sky130_fd_sc_hd__decap_3
XFILLER_9_1183 VGND VGND VPWR VPWR sky130_fd_sc_hd__decap_3
XFILLER_56_15 VGND VGND VPWR VPWR sky130_fd_sc_hd__decap_3
XFILLER_40_1418 VGND VGND VPWR VPWR sky130_fd_sc_hd__decap_3
X_5159_ _6388_/Q wire112/X _4992_/S _5158_/X VGND VGND VPWR VPWR _6388_/D sky130_fd_sc_hd__a22o_2
XFILLER_40_1429 VGND VGND VPWR VPWR sky130_fd_sc_hd__decap_3
XFILLER_45_917 VGND VGND VPWR VPWR sky130_fd_sc_hd__decap_3
XFILLER_44_405 VGND VGND VPWR VPWR sky130_fd_sc_hd__decap_3
XFILLER_72_725 VGND VGND VPWR VPWR sky130_fd_sc_hd__decap_3
XFILLER_44_427 VGND VGND VPWR VPWR sky130_fd_sc_hd__decap_3
XFILLER_16_129 VGND VGND VPWR VPWR sky130_fd_sc_hd__decap_3
XFILLER_56_298 VGND VGND VPWR VPWR sky130_fd_sc_hd__fill_2
XFILLER_72_769 VGND VGND VPWR VPWR sky130_fd_sc_hd__fill_2
XFILLER_38_1303 VGND VGND VPWR VPWR sky130_fd_sc_hd__decap_3
Xclkbuf_leaf_36_clk clkbuf_leaf_56_clk/A VGND VGND VPWR VPWR _6974_/CLK sky130_fd_sc_hd__clkbuf_8
XFILLER_53_950 VGND VGND VPWR VPWR sky130_fd_sc_hd__fill_2
XFILLER_77_1363 VGND VGND VPWR VPWR sky130_fd_sc_hd__decap_3
XFILLER_25_652 VGND VGND VPWR VPWR sky130_fd_sc_hd__decap_3
XFILLER_73_1216 VGND VGND VPWR VPWR sky130_fd_sc_hd__decap_3
XFILLER_72_47 VGND VGND VPWR VPWR sky130_fd_sc_hd__decap_3
XFILLER_71_279 VGND VGND VPWR VPWR sky130_fd_sc_hd__fill_1
XFILLER_77_1396 VGND VGND VPWR VPWR sky130_fd_sc_hd__decap_3
XFILLER_24_151 VGND VGND VPWR VPWR sky130_fd_sc_hd__decap_3
XFILLER_38_1347 VGND VGND VPWR VPWR sky130_fd_sc_hd__decap_3
XFILLER_8_306 VGND VGND VPWR VPWR sky130_fd_sc_hd__fill_2
XFILLER_12_368 VGND VGND VPWR VPWR sky130_fd_sc_hd__decap_3
XFILLER_40_688 VGND VGND VPWR VPWR sky130_fd_sc_hd__decap_3
XFILLER_36_1093 VGND VGND VPWR VPWR sky130_fd_sc_hd__decap_3
XANTENNA_80 fanout848/X VGND VGND VPWR VPWR sky130_fd_sc_hd__diode_2
XFILLER_10_1200 VGND VGND VPWR VPWR sky130_fd_sc_hd__decap_3
XFILLER_10_1211 VGND VGND VPWR VPWR sky130_fd_sc_hd__decap_3
XFILLER_14_1391 VGND VGND VPWR VPWR sky130_fd_sc_hd__decap_3
XFILLER_4_512 VGND VGND VPWR VPWR sky130_fd_sc_hd__decap_3
XFILLER_67_1009 VGND VGND VPWR VPWR sky130_fd_sc_hd__fill_1
XFILLER_49_1410 VGND VGND VPWR VPWR sky130_fd_sc_hd__decap_3
XFILLER_10_1244 VGND VGND VPWR VPWR sky130_fd_sc_hd__decap_3
XFILLER_4_545 VGND VGND VPWR VPWR sky130_fd_sc_hd__decap_3
XFILLER_49_1443 VGND VGND VPWR VPWR sky130_fd_sc_hd__decap_3
XFILLER_10_1288 VGND VGND VPWR VPWR sky130_fd_sc_hd__decap_3
XFILLER_4_578 VGND VGND VPWR VPWR sky130_fd_sc_hd__decap_3
XTAP_TAPCELL_ROW_56_1644 VGND VPWR sky130_fd_sc_hd__tapvpwrvgnd_1
XFILLER_4_589 VGND VGND VPWR VPWR sky130_fd_sc_hd__decap_3
XTAP_TAPCELL_ROW_56_1655 VGND VPWR sky130_fd_sc_hd__tapvpwrvgnd_1
XFILLER_45_1307 VGND VGND VPWR VPWR sky130_fd_sc_hd__decap_3
XTAP_TAPCELL_ROW_56_1666 VGND VPWR sky130_fd_sc_hd__tapvpwrvgnd_1
XFILLER_79_368 VGND VGND VPWR VPWR sky130_fd_sc_hd__decap_3
XTAP_TAPCELL_ROW_7_372 VGND VPWR sky130_fd_sc_hd__tapvpwrvgnd_1
XTAP_TAPCELL_ROW_7_383 VGND VPWR sky130_fd_sc_hd__tapvpwrvgnd_1
XTAP_TAPCELL_ROW_7_394 VGND VPWR sky130_fd_sc_hd__tapvpwrvgnd_1
XFILLER_48_733 VGND VGND VPWR VPWR sky130_fd_sc_hd__decap_3
XFILLER_11_9 VGND VGND VPWR VPWR sky130_fd_sc_hd__decap_3
XFILLER_48_755 VGND VGND VPWR VPWR sky130_fd_sc_hd__fill_1
XFILLER_78_1105 VGND VGND VPWR VPWR sky130_fd_sc_hd__decap_3
XFILLER_47_254 VGND VGND VPWR VPWR sky130_fd_sc_hd__decap_3
XFILLER_1_1401 VGND VGND VPWR VPWR sky130_fd_sc_hd__decap_3
XFILLER_36_928 VGND VGND VPWR VPWR sky130_fd_sc_hd__decap_3
XFILLER_21_1340 VGND VGND VPWR VPWR sky130_fd_sc_hd__decap_3
XFILLER_36_939 VGND VGND VPWR VPWR sky130_fd_sc_hd__decap_3
XFILLER_78_1138 VGND VGND VPWR VPWR sky130_fd_sc_hd__decap_3
XFILLER_21_1351 VGND VGND VPWR VPWR sky130_fd_sc_hd__decap_3
XFILLER_78_1149 VGND VGND VPWR VPWR sky130_fd_sc_hd__decap_3
XFILLER_1_1434 VGND VGND VPWR VPWR sky130_fd_sc_hd__decap_3
XFILLER_63_747 VGND VGND VPWR VPWR sky130_fd_sc_hd__fill_1
XFILLER_35_449 VGND VGND VPWR VPWR sky130_fd_sc_hd__decap_3
Xclkbuf_leaf_27_clk clkload3/A VGND VGND VPWR VPWR _6617_/CLK sky130_fd_sc_hd__clkbuf_8
XFILLER_21_1384 VGND VGND VPWR VPWR sky130_fd_sc_hd__decap_3
XTAP_TAPCELL_ROW_18_658 VGND VPWR sky130_fd_sc_hd__tapvpwrvgnd_1
XFILLER_56_1403 VGND VGND VPWR VPWR sky130_fd_sc_hd__decap_3
Xmax_cap82 _5919_/S VGND VGND VPWR VPWR _5923_/S sky130_fd_sc_hd__clkbuf_8
XTAP_TAPCELL_ROW_18_669 VGND VPWR sky130_fd_sc_hd__tapvpwrvgnd_1
XFILLER_50_419 VGND VGND VPWR VPWR sky130_fd_sc_hd__fill_1
XFILLER_43_460 VGND VGND VPWR VPWR sky130_fd_sc_hd__decap_3
XFILLER_56_1447 VGND VGND VPWR VPWR sky130_fd_sc_hd__decap_3
XFILLER_30_132 VGND VGND VPWR VPWR sky130_fd_sc_hd__decap_3
XFILLER_15_1100 VGND VGND VPWR VPWR sky130_fd_sc_hd__decap_3
XFILLER_54_1160 VGND VGND VPWR VPWR sky130_fd_sc_hd__decap_3
XFILLER_50_1002 VGND VGND VPWR VPWR sky130_fd_sc_hd__decap_3
X_4530_ _6863_/Q _4883_/A2 _4883_/B1 _4529_/X VGND VGND VPWR VPWR _4530_/X sky130_fd_sc_hd__a211o_2
XFILLER_8_851 VGND VGND VPWR VPWR sky130_fd_sc_hd__decap_3
XFILLER_15_1177 VGND VGND VPWR VPWR sky130_fd_sc_hd__fill_2
X_4461_ _6516_/Q _4518_/A _4817_/A1 VGND VGND VPWR VPWR _4461_/X sky130_fd_sc_hd__a21bo_2
X_6200_ _7051_/CLK _6200_/D load_slew815/X VGND VGND VPWR VPWR _6200_/Q sky130_fd_sc_hd__dfrtp_2
X_3412_ _6237_/Q _6437_/Q VGND VGND VPWR VPWR _3412_/X sky130_fd_sc_hd__xor2_2
X_4392_ _6845_/Q _4751_/A2 wire36/X _4391_/X VGND VGND VPWR VPWR _4392_/X sky130_fd_sc_hd__a211o_2
X_6131_ _6982_/CLK _6131_/D load_slew742/X VGND VGND VPWR VPWR _6131_/Q sky130_fd_sc_hd__dfrtp_2
XFILLER_63_1407 VGND VGND VPWR VPWR sky130_fd_sc_hd__decap_3
X_3343_ hold919/X _3342_/X _3421_/S VGND VGND VPWR VPWR _6145_/D sky130_fd_sc_hd__mux2_1
X_6062_ _6073_/D _6062_/B VGND VGND VPWR VPWR _6062_/X sky130_fd_sc_hd__and2_2
XFILLER_58_519 VGND VGND VPWR VPWR sky130_fd_sc_hd__decap_3
XFILLER_6_1312 VGND VGND VPWR VPWR sky130_fd_sc_hd__decap_3
X_3274_ _6216_/Q _6368_/Q VGND VGND VPWR VPWR _3274_/X sky130_fd_sc_hd__xor2_2
Xhold1006 _6170_/Q VGND VGND VPWR VPWR _6017_/A0 sky130_fd_sc_hd__dlygate4sd3_1
Xload_slew264 _4564_/B VGND VGND VPWR VPWR _4588_/B sky130_fd_sc_hd__clkbuf_4
XFILLER_6_1323 VGND VGND VPWR VPWR sky130_fd_sc_hd__decap_3
Xhold1017 _6134_/Q VGND VGND VPWR VPWR _5981_/A0 sky130_fd_sc_hd__dlygate4sd3_1
Xload_slew275 fanout274/X VGND VGND VPWR VPWR _4422_/A sky130_fd_sc_hd__clkbuf_4
X_5013_ _6359_/Q _5012_/X _5013_/S VGND VGND VPWR VPWR _6359_/D sky130_fd_sc_hd__mux2_1
XFILLER_26_1273 VGND VGND VPWR VPWR sky130_fd_sc_hd__decap_3
Xhold1028 _6104_/Q VGND VGND VPWR VPWR _5951_/A0 sky130_fd_sc_hd__dlygate4sd3_1
XFILLER_6_1356 VGND VGND VPWR VPWR sky130_fd_sc_hd__decap_3
Xload_slew297 _4805_/A2 VGND VGND VPWR VPWR _4862_/A2 sky130_fd_sc_hd__buf_2
XFILLER_38_221 VGND VGND VPWR VPWR sky130_fd_sc_hd__decap_3
Xhold1039 _6638_/Q VGND VGND VPWR VPWR _5555_/B1 sky130_fd_sc_hd__dlygate4sd3_1
XFILLER_61_1175 VGND VGND VPWR VPWR sky130_fd_sc_hd__fill_1
XFILLER_39_777 VGND VGND VPWR VPWR sky130_fd_sc_hd__decap_3
XFILLER_39_788 VGND VGND VPWR VPWR sky130_fd_sc_hd__fill_2
XFILLER_26_405 VGND VGND VPWR VPWR sky130_fd_sc_hd__decap_3
XFILLER_27_939 VGND VGND VPWR VPWR sky130_fd_sc_hd__decap_3
XFILLER_26_29 VGND VGND VPWR VPWR sky130_fd_sc_hd__decap_3
XFILLER_38_298 VGND VGND VPWR VPWR sky130_fd_sc_hd__decap_3
XFILLER_54_747 VGND VGND VPWR VPWR sky130_fd_sc_hd__fill_1
XPHY_EDGE_ROW_5_Right_5 VGND VGND VPWR VPWR sky130_fd_sc_hd__decap_3
XFILLER_4_1091 VGND VGND VPWR VPWR sky130_fd_sc_hd__fill_1
XFILLER_53_246 VGND VGND VPWR VPWR sky130_fd_sc_hd__decap_3
X_6964_ _7036_/CLK _6964_/D load_slew840/X VGND VGND VPWR VPWR _6964_/Q sky130_fd_sc_hd__dfrtp_2
Xclkbuf_leaf_18_clk clkbuf_4_4__f_clk/X VGND VGND VPWR VPWR _7037_/CLK sky130_fd_sc_hd__clkbuf_8
XFILLER_53_268 VGND VGND VPWR VPWR sky130_fd_sc_hd__decap_3
X_5915_ _5906_/B _5915_/B _5915_/C _5915_/D VGND VGND VPWR VPWR _5919_/S sky130_fd_sc_hd__and4b_2
XFILLER_34_460 VGND VGND VPWR VPWR sky130_fd_sc_hd__decap_3
X_6895_ _7054_/CLK _6895_/D fanout755/X VGND VGND VPWR VPWR _6895_/Q sky130_fd_sc_hd__dfrtp_2
XFILLER_22_611 VGND VGND VPWR VPWR sky130_fd_sc_hd__decap_3
XFILLER_50_920 VGND VGND VPWR VPWR sky130_fd_sc_hd__decap_3
X_5846_ _5846_/A0 _5911_/A0 _5849_/S VGND VGND VPWR VPWR _6862_/D sky130_fd_sc_hd__mux2_1
XFILLER_50_953 VGND VGND VPWR VPWR sky130_fd_sc_hd__decap_3
XFILLER_72_1282 VGND VGND VPWR VPWR sky130_fd_sc_hd__decap_3
XFILLER_33_1233 VGND VGND VPWR VPWR sky130_fd_sc_hd__decap_3
X_5777_ _5777_/A0 _5900_/A0 _5782_/S VGND VGND VPWR VPWR _6812_/D sky130_fd_sc_hd__mux2_1
XFILLER_33_1266 VGND VGND VPWR VPWR sky130_fd_sc_hd__decap_3
X_4728_ _6248_/Q _4750_/A2 _3418_/X _4750_/B2 VGND VGND VPWR VPWR _4728_/X sky130_fd_sc_hd__a22o_2
X_4659_ _4659_/A _4836_/B VGND VGND VPWR VPWR _4659_/Y sky130_fd_sc_hd__nor2_2
XFILLER_68_1329 VGND VGND VPWR VPWR sky130_fd_sc_hd__decap_3
Xhold862 _6118_/Q VGND VGND VPWR VPWR hold862/X sky130_fd_sc_hd__dlygate4sd3_1
XFILLER_1_526 VGND VGND VPWR VPWR sky130_fd_sc_hd__decap_3
Xhold873 _6644_/Q VGND VGND VPWR VPWR hold873/X sky130_fd_sc_hd__dlygate4sd3_1
X_6329_ _7011_/CLK _6329_/D fanout811/X VGND VGND VPWR VPWR _6329_/Q sky130_fd_sc_hd__dfrtp_2
Xhold884 _6112_/Q VGND VGND VPWR VPWR hold884/X sky130_fd_sc_hd__dlygate4sd3_1
Xhold895 _5935_/X VGND VGND VPWR VPWR _6939_/D sky130_fd_sc_hd__dlygate4sd3_1
XFILLER_1_559 VGND VGND VPWR VPWR sky130_fd_sc_hd__fill_1
XFILLER_67_36 VGND VGND VPWR VPWR sky130_fd_sc_hd__decap_3
XTAP_TAPCELL_ROW_51_1530 VGND VPWR sky130_fd_sc_hd__tapvpwrvgnd_1
XFILLER_44_1362 VGND VGND VPWR VPWR sky130_fd_sc_hd__decap_3
XFILLER_67_69 VGND VGND VPWR VPWR sky130_fd_sc_hd__decap_3
XFILLER_44_1373 VGND VGND VPWR VPWR sky130_fd_sc_hd__decap_3
Xhold1540 _6672_/Q VGND VGND VPWR VPWR _5600_/B2 sky130_fd_sc_hd__dlygate4sd3_1
XFILLER_40_1237 VGND VGND VPWR VPWR sky130_fd_sc_hd__decap_3
Xhold1551 _6659_/Q VGND VGND VPWR VPWR _5586_/B2 sky130_fd_sc_hd__dlygate4sd3_1
XPHY_EDGE_ROW_48_Left_129 VGND VGND VPWR VPWR sky130_fd_sc_hd__decap_3
Xhold1562 _6655_/Q VGND VGND VPWR VPWR _5579_/A1 sky130_fd_sc_hd__dlygate4sd3_1
XFILLER_79_1425 VGND VGND VPWR VPWR sky130_fd_sc_hd__decap_3
XFILLER_18_928 VGND VGND VPWR VPWR sky130_fd_sc_hd__fill_1
XFILLER_29_265 VGND VGND VPWR VPWR sky130_fd_sc_hd__decap_3
Xhold1573 _6823_/Q VGND VGND VPWR VPWR _5798_/A1 sky130_fd_sc_hd__dlygate4sd3_1
XFILLER_45_725 VGND VGND VPWR VPWR sky130_fd_sc_hd__decap_3
XTAP_TAPCELL_ROW_28_923 VGND VPWR sky130_fd_sc_hd__tapvpwrvgnd_1
XFILLER_72_522 VGND VGND VPWR VPWR sky130_fd_sc_hd__decap_3
XTAP_TAPCELL_ROW_28_934 VGND VPWR sky130_fd_sc_hd__tapvpwrvgnd_1
XFILLER_72_533 VGND VGND VPWR VPWR sky130_fd_sc_hd__decap_3
XFILLER_17_449 VGND VGND VPWR VPWR sky130_fd_sc_hd__decap_3
XFILLER_45_769 VGND VGND VPWR VPWR sky130_fd_sc_hd__decap_3
XFILLER_77_1160 VGND VGND VPWR VPWR sky130_fd_sc_hd__decap_3
XFILLER_32_408 VGND VGND VPWR VPWR sky130_fd_sc_hd__decap_3
XFILLER_60_717 VGND VGND VPWR VPWR sky130_fd_sc_hd__decap_3
XFILLER_13_600 VGND VGND VPWR VPWR sky130_fd_sc_hd__decap_3
XTAP_TAPCELL_ROW_49_1470 VGND VPWR sky130_fd_sc_hd__tapvpwrvgnd_1
XFILLER_16_62 VGND VGND VPWR VPWR sky130_fd_sc_hd__decap_3
XTAP_TAPCELL_ROW_49_1481 VGND VPWR sky130_fd_sc_hd__tapvpwrvgnd_1
XFILLER_53_780 VGND VGND VPWR VPWR sky130_fd_sc_hd__decap_3
XFILLER_41_953 VGND VGND VPWR VPWR sky130_fd_sc_hd__decap_3
XFILLER_13_655 VGND VGND VPWR VPWR sky130_fd_sc_hd__decap_3
XFILLER_52_290 VGND VGND VPWR VPWR sky130_fd_sc_hd__decap_3
XTAP_TAPCELL_ROW_45_1367 VGND VPWR sky130_fd_sc_hd__tapvpwrvgnd_1
XFILLER_9_615 VGND VGND VPWR VPWR sky130_fd_sc_hd__fill_1
XTAP_TAPCELL_ROW_45_1378 VGND VPWR sky130_fd_sc_hd__tapvpwrvgnd_1
XFILLER_41_997 VGND VGND VPWR VPWR sky130_fd_sc_hd__decap_3
XFILLER_51_1322 VGND VGND VPWR VPWR sky130_fd_sc_hd__decap_3
XFILLER_8_125 VGND VGND VPWR VPWR sky130_fd_sc_hd__decap_3
XFILLER_16_1453 VGND VGND VPWR VPWR sky130_fd_sc_hd__decap_3
XPHY_EDGE_ROW_57_Left_138 VGND VGND VPWR VPWR sky130_fd_sc_hd__decap_3
XFILLER_12_1306 VGND VGND VPWR VPWR sky130_fd_sc_hd__decap_3
XFILLER_12_1317 VGND VGND VPWR VPWR sky130_fd_sc_hd__decap_3
XFILLER_51_1366 VGND VGND VPWR VPWR sky130_fd_sc_hd__decap_3
XFILLER_32_94 VGND VGND VPWR VPWR sky130_fd_sc_hd__fill_1
XFILLER_51_1399 VGND VGND VPWR VPWR sky130_fd_sc_hd__fill_1
XTAP_TAPCELL_ROW_58_1706 VGND VPWR sky130_fd_sc_hd__tapvpwrvgnd_1
XTAP_TAPCELL_ROW_58_1717 VGND VPWR sky130_fd_sc_hd__tapvpwrvgnd_1
XFILLER_59_9 VGND VGND VPWR VPWR sky130_fd_sc_hd__fill_2
XFILLER_4_342 VGND VGND VPWR VPWR sky130_fd_sc_hd__decap_3
XFILLER_5_887 VGND VGND VPWR VPWR sky130_fd_sc_hd__decap_3
XFILLER_10_1074 VGND VGND VPWR VPWR sky130_fd_sc_hd__decap_3
XFILLER_49_1251 VGND VGND VPWR VPWR sky130_fd_sc_hd__decap_3
XFILLER_10_1096 VGND VGND VPWR VPWR sky130_fd_sc_hd__decap_3
XFILLER_4_397 VGND VGND VPWR VPWR sky130_fd_sc_hd__decap_3
XFILLER_49_1284 VGND VGND VPWR VPWR sky130_fd_sc_hd__decap_3
XFILLER_80_1006 VGND VGND VPWR VPWR sky130_fd_sc_hd__fill_2
XFILLER_49_1295 VGND VGND VPWR VPWR sky130_fd_sc_hd__decap_3
XFILLER_68_839 VGND VGND VPWR VPWR sky130_fd_sc_hd__fill_1
XFILLER_0_570 VGND VGND VPWR VPWR sky130_fd_sc_hd__decap_3
XFILLER_23_1413 VGND VGND VPWR VPWR sky130_fd_sc_hd__decap_3
XFILLER_62_1462 VGND VGND VPWR VPWR sky130_fd_sc_hd__decap_3
XPHY_EDGE_ROW_66_Left_147 VGND VGND VPWR VPWR sky130_fd_sc_hd__decap_3
XFILLER_0_592 VGND VGND VPWR VPWR sky130_fd_sc_hd__decap_3
XFILLER_48_530 VGND VGND VPWR VPWR sky130_fd_sc_hd__fill_2
XFILLER_23_1446 VGND VGND VPWR VPWR sky130_fd_sc_hd__decap_3
XFILLER_76_872 VGND VGND VPWR VPWR sky130_fd_sc_hd__decap_3
XFILLER_23_1457 VGND VGND VPWR VPWR sky130_fd_sc_hd__decap_3
XFILLER_63_511 VGND VGND VPWR VPWR sky130_fd_sc_hd__decap_3
XFILLER_75_393 VGND VGND VPWR VPWR sky130_fd_sc_hd__decap_3
XFILLER_1_1231 VGND VGND VPWR VPWR sky130_fd_sc_hd__fill_1
XFILLER_1_1242 VGND VGND VPWR VPWR sky130_fd_sc_hd__decap_3
XFILLER_17_950 VGND VGND VPWR VPWR sky130_fd_sc_hd__fill_2
XFILLER_35_246 VGND VGND VPWR VPWR sky130_fd_sc_hd__decap_3
XFILLER_23_408 VGND VGND VPWR VPWR sky130_fd_sc_hd__decap_3
XFILLER_1_1275 VGND VGND VPWR VPWR sky130_fd_sc_hd__decap_3
XFILLER_35_279 VGND VGND VPWR VPWR sky130_fd_sc_hd__fill_1
XFILLER_17_983 VGND VGND VPWR VPWR sky130_fd_sc_hd__decap_3
X_3961_ _4059_/B _4388_/A VGND VGND VPWR VPWR _3961_/Y sky130_fd_sc_hd__nor2_2
XFILLER_32_931 VGND VGND VPWR VPWR sky130_fd_sc_hd__decap_3
XFILLER_50_227 VGND VGND VPWR VPWR sky130_fd_sc_hd__decap_3
X_5700_ _5700_/A0 _5903_/A0 _5702_/S VGND VGND VPWR VPWR _6751_/D sky130_fd_sc_hd__mux2_1
XFILLER_56_1244 VGND VGND VPWR VPWR sky130_fd_sc_hd__decap_3
X_6680_ _7056_/CLK _6680_/D fanout703/X VGND VGND VPWR VPWR _6680_/Q sky130_fd_sc_hd__dfrtp_2
XFILLER_17_1217 VGND VGND VPWR VPWR sky130_fd_sc_hd__decap_3
XFILLER_43_290 VGND VGND VPWR VPWR sky130_fd_sc_hd__decap_3
X_3892_ _6228_/Q _4010_/B _3902_/B1 _6220_/Q _3902_/C1 VGND VGND VPWR VPWR _3892_/X
+ sky130_fd_sc_hd__a221o_2
XFILLER_52_1108 VGND VGND VPWR VPWR sky130_fd_sc_hd__decap_3
XFILLER_17_1239 VGND VGND VPWR VPWR sky130_fd_sc_hd__decap_3
XFILLER_32_975 VGND VGND VPWR VPWR sky130_fd_sc_hd__decap_3
XFILLER_56_1288 VGND VGND VPWR VPWR sky130_fd_sc_hd__decap_3
XPHY_EDGE_ROW_75_Left_156 VGND VGND VPWR VPWR sky130_fd_sc_hd__decap_3
X_5631_ _5907_/A0 _5631_/A1 wire93/A VGND VGND VPWR VPWR _6690_/D sky130_fd_sc_hd__mux2_1
XFILLER_30_1406 VGND VGND VPWR VPWR sky130_fd_sc_hd__decap_3
X_5562_ _6363_/Q _5501_/B _5562_/B1 _5562_/B2 VGND VGND VPWR VPWR _6645_/D sky130_fd_sc_hd__a22o_2
XFILLER_8_670 VGND VGND VPWR VPWR sky130_fd_sc_hd__decap_3
X_4513_ _4888_/C1 _4510_/X _4511_/Y _4512_/X _4831_/C1 VGND VGND VPWR VPWR _4513_/X
+ sky130_fd_sc_hd__o221a_2
X_5493_ _6601_/Q _6600_/Q _7082_/Q VGND VGND VPWR VPWR _5493_/X sky130_fd_sc_hd__a21bo_2
X_4444_ _4444_/A _4768_/B VGND VGND VPWR VPWR _4444_/Y sky130_fd_sc_hd__nor2_2
Xclkbuf_leaf_7_clk clkload0/A VGND VGND VPWR VPWR _6954_/CLK sky130_fd_sc_hd__clkbuf_8
XFILLER_67_1340 VGND VGND VPWR VPWR sky130_fd_sc_hd__decap_3
XFILLER_67_1351 VGND VGND VPWR VPWR sky130_fd_sc_hd__decap_3
X_4375_ _6843_/Q _4744_/A2 _4766_/B1 _4374_/X VGND VGND VPWR VPWR _4375_/X sky130_fd_sc_hd__a211o_2
XFILLER_63_1215 VGND VGND VPWR VPWR sky130_fd_sc_hd__decap_3
Xfanout605 _5931_/A0 VGND VGND VPWR VPWR _5904_/A0 sky130_fd_sc_hd__clkdlybuf4s25_1
XFILLER_28_1335 VGND VGND VPWR VPWR sky130_fd_sc_hd__decap_3
XFILLER_67_1384 VGND VGND VPWR VPWR sky130_fd_sc_hd__decap_3
Xfanout616 input6/X VGND VGND VPWR VPWR _5902_/A0 sky130_fd_sc_hd__clkdlybuf4s25_1
XFILLER_8_1418 VGND VGND VPWR VPWR sky130_fd_sc_hd__decap_3
XFILLER_8_1429 VGND VGND VPWR VPWR sky130_fd_sc_hd__decap_3
X_6114_ _7076_/CLK _6114_/D load_slew681/X VGND VGND VPWR VPWR _6114_/Q sky130_fd_sc_hd__dfrtp_2
X_3326_ _6290_/Q _6394_/Q VGND VGND VPWR VPWR _3326_/X sky130_fd_sc_hd__xor2_2
Xfanout638 fanout667/X VGND VGND VPWR VPWR wire639/A sky130_fd_sc_hd__clkdlybuf4s25_1
XFILLER_28_1368 VGND VGND VPWR VPWR sky130_fd_sc_hd__decap_3
XFILLER_63_1248 VGND VGND VPWR VPWR sky130_fd_sc_hd__decap_3
X_7094_ _7096_/CLK _7094_/D load_slew677/X VGND VGND VPWR VPWR _7094_/Q sky130_fd_sc_hd__dfrtp_2
Xfanout649 wire652/A VGND VGND VPWR VPWR fanout649/X sky130_fd_sc_hd__clkdlybuf4s25_1
XFILLER_28_1379 VGND VGND VPWR VPWR sky130_fd_sc_hd__decap_3
XFILLER_6_1120 VGND VGND VPWR VPWR sky130_fd_sc_hd__decap_3
X_6045_ hold892/X hold903/X _6053_/S VGND VGND VPWR VPWR _7049_/D sky130_fd_sc_hd__mux2_1
XFILLER_26_1070 VGND VGND VPWR VPWR sky130_fd_sc_hd__decap_3
X_3257_ hold913/X _3256_/X _3379_/S VGND VGND VPWR VPWR _6102_/D sky130_fd_sc_hd__mux2_1
XFILLER_67_850 VGND VGND VPWR VPWR sky130_fd_sc_hd__decap_3
XFILLER_6_1164 VGND VGND VPWR VPWR sky130_fd_sc_hd__decap_3
XFILLER_2_1017 VGND VGND VPWR VPWR sky130_fd_sc_hd__decap_3
X_3188_ _7015_/Q _7023_/Q _3191_/S VGND VGND VPWR VPWR _3188_/X sky130_fd_sc_hd__mux2_1
XFILLER_27_725 VGND VGND VPWR VPWR sky130_fd_sc_hd__decap_3
XFILLER_39_585 VGND VGND VPWR VPWR sky130_fd_sc_hd__decap_3
XFILLER_67_894 VGND VGND VPWR VPWR sky130_fd_sc_hd__fill_2
XFILLER_6_1197 VGND VGND VPWR VPWR sky130_fd_sc_hd__decap_3
XFILLER_66_382 VGND VGND VPWR VPWR sky130_fd_sc_hd__decap_3
XFILLER_54_533 VGND VGND VPWR VPWR sky130_fd_sc_hd__decap_3
XFILLER_74_1300 VGND VGND VPWR VPWR sky130_fd_sc_hd__decap_3
XFILLER_42_728 VGND VGND VPWR VPWR sky130_fd_sc_hd__decap_3
XFILLER_39_1431 VGND VGND VPWR VPWR sky130_fd_sc_hd__decap_3
XFILLER_41_205 VGND VGND VPWR VPWR sky130_fd_sc_hd__fill_1
X_6947_ _6987_/CLK _6947_/D load_slew834/X VGND VGND VPWR VPWR _6947_/Q sky130_fd_sc_hd__dfrtp_2
XFILLER_74_1344 VGND VGND VPWR VPWR sky130_fd_sc_hd__decap_3
XFILLER_35_791 VGND VGND VPWR VPWR sky130_fd_sc_hd__decap_3
XFILLER_41_249 VGND VGND VPWR VPWR sky130_fd_sc_hd__decap_3
XFILLER_23_964 VGND VGND VPWR VPWR sky130_fd_sc_hd__decap_3
XFILLER_70_1208 VGND VGND VPWR VPWR sky130_fd_sc_hd__decap_3
XFILLER_35_1328 VGND VGND VPWR VPWR sky130_fd_sc_hd__decap_3
X_6878_ _6974_/CLK _6878_/D fanout779/A VGND VGND VPWR VPWR _6878_/Q sky130_fd_sc_hd__dfrtp_2
XFILLER_74_1388 VGND VGND VPWR VPWR sky130_fd_sc_hd__decap_3
XFILLER_50_794 VGND VGND VPWR VPWR sky130_fd_sc_hd__decap_3
X_5829_ _5930_/A0 _5829_/A1 _5831_/S VGND VGND VPWR VPWR _6847_/D sky130_fd_sc_hd__mux2_1
XFILLER_72_1090 VGND VGND VPWR VPWR sky130_fd_sc_hd__fill_2
XTAP_TAPCELL_ROW_40_1231 VGND VPWR sky130_fd_sc_hd__tapvpwrvgnd_1
XTAP_TAPCELL_ROW_40_1242 VGND VPWR sky130_fd_sc_hd__tapvpwrvgnd_1
XFILLER_6_629 VGND VGND VPWR VPWR sky130_fd_sc_hd__fill_2
XTAP_TAPCELL_ROW_40_1253 VGND VPWR sky130_fd_sc_hd__tapvpwrvgnd_1
XFILLER_5_139 VGND VGND VPWR VPWR sky130_fd_sc_hd__decap_3
XFILLER_11_1372 VGND VGND VPWR VPWR sky130_fd_sc_hd__decap_3
XTAP_TAPCELL_ROW_9_423 VGND VPWR sky130_fd_sc_hd__tapvpwrvgnd_1
XFILLER_2_813 VGND VGND VPWR VPWR sky130_fd_sc_hd__decap_3
XFILLER_78_24 VGND VGND VPWR VPWR sky130_fd_sc_hd__decap_3
XTAP_TAPCELL_ROW_9_434 VGND VPWR sky130_fd_sc_hd__tapvpwrvgnd_1
XFILLER_78_35 VGND VGND VPWR VPWR sky130_fd_sc_hd__decap_3
XTAP_TAPCELL_ROW_9_445 VGND VPWR sky130_fd_sc_hd__tapvpwrvgnd_1
XFILLER_2_846 VGND VGND VPWR VPWR sky130_fd_sc_hd__decap_3
XFILLER_1_323 VGND VGND VPWR VPWR sky130_fd_sc_hd__fill_1
XFILLER_46_1424 VGND VGND VPWR VPWR sky130_fd_sc_hd__decap_3
XFILLER_46_1435 VGND VGND VPWR VPWR sky130_fd_sc_hd__decap_3
XFILLER_78_68 VGND VGND VPWR VPWR sky130_fd_sc_hd__decap_3
XTAP_TAPCELL_ROW_38_1182 VGND VPWR sky130_fd_sc_hd__tapvpwrvgnd_1
XTAP_TAPCELL_ROW_38_1193 VGND VPWR sky130_fd_sc_hd__tapvpwrvgnd_1
XFILLER_1_367 VGND VGND VPWR VPWR sky130_fd_sc_hd__decap_3
XFILLER_46_1468 VGND VGND VPWR VPWR sky130_fd_sc_hd__fill_1
XFILLER_77_647 VGND VGND VPWR VPWR sky130_fd_sc_hd__fill_1
XTAP_TAPCELL_ROW_34_1079 VGND VPWR sky130_fd_sc_hd__tapvpwrvgnd_1
XFILLER_77_669 VGND VGND VPWR VPWR sky130_fd_sc_hd__decap_3
XFILLER_40_1023 VGND VGND VPWR VPWR sky130_fd_sc_hd__decap_3
XFILLER_79_1222 VGND VGND VPWR VPWR sky130_fd_sc_hd__decap_3
XFILLER_45_511 VGND VGND VPWR VPWR sky130_fd_sc_hd__decap_3
XFILLER_58_894 VGND VGND VPWR VPWR sky130_fd_sc_hd__decap_3
XFILLER_79_1233 VGND VGND VPWR VPWR sky130_fd_sc_hd__decap_3
XFILLER_18_736 VGND VGND VPWR VPWR sky130_fd_sc_hd__decap_3
Xhold1370 _6848_/Q VGND VGND VPWR VPWR _5830_/A1 sky130_fd_sc_hd__dlygate4sd3_1
Xhold1381 _6495_/Q VGND VGND VPWR VPWR _5383_/A1 sky130_fd_sc_hd__dlygate4sd3_1
XFILLER_57_393 VGND VGND VPWR VPWR sky130_fd_sc_hd__decap_3
Xhold1392 _6909_/Q VGND VGND VPWR VPWR _5901_/A1 sky130_fd_sc_hd__dlygate4sd3_1
XFILLER_79_1266 VGND VGND VPWR VPWR sky130_fd_sc_hd__decap_3
XFILLER_75_1108 VGND VGND VPWR VPWR sky130_fd_sc_hd__decap_3
XTAP_TAPCELL_ROW_47_1418 VGND VPWR sky130_fd_sc_hd__tapvpwrvgnd_1
XFILLER_72_363 VGND VGND VPWR VPWR sky130_fd_sc_hd__fill_1
XTAP_TAPCELL_ROW_47_1429 VGND VPWR sky130_fd_sc_hd__tapvpwrvgnd_1
XFILLER_26_780 VGND VGND VPWR VPWR sky130_fd_sc_hd__decap_3
XFILLER_60_536 VGND VGND VPWR VPWR sky130_fd_sc_hd__fill_1
XFILLER_53_1428 VGND VGND VPWR VPWR sky130_fd_sc_hd__decap_3
XFILLER_43_60 VGND VGND VPWR VPWR sky130_fd_sc_hd__decap_3
XFILLER_13_474 VGND VGND VPWR VPWR sky130_fd_sc_hd__decap_3
XFILLER_41_783 VGND VGND VPWR VPWR sky130_fd_sc_hd__fill_1
XFILLER_9_423 VGND VGND VPWR VPWR sky130_fd_sc_hd__decap_3
XFILLER_16_1250 VGND VGND VPWR VPWR sky130_fd_sc_hd__decap_3
XFILLER_16_1261 VGND VGND VPWR VPWR sky130_fd_sc_hd__decap_3
XFILLER_9_478 VGND VGND VPWR VPWR sky130_fd_sc_hd__fill_1
XFILLER_16_1294 VGND VGND VPWR VPWR sky130_fd_sc_hd__decap_3
XFILLER_51_1196 VGND VGND VPWR VPWR sky130_fd_sc_hd__decap_3
XFILLER_5_651 VGND VGND VPWR VPWR sky130_fd_sc_hd__decap_3
XFILLER_57_6 VGND VGND VPWR VPWR sky130_fd_sc_hd__decap_3
XFILLER_5_673 VGND VGND VPWR VPWR sky130_fd_sc_hd__decap_3
XFILLER_4_21 VGND VGND VPWR VPWR sky130_fd_sc_hd__decap_3
XFILLER_4_32 VGND VGND VPWR VPWR sky130_fd_sc_hd__decap_3
XFILLER_4_65 VGND VGND VPWR VPWR sky130_fd_sc_hd__decap_3
X_4160_ _4316_/B _4314_/B VGND VGND VPWR VPWR _4161_/B sky130_fd_sc_hd__xor2_2
X_3111_ _7077_/Q _3114_/B VGND VGND VPWR VPWR _3202_/A sky130_fd_sc_hd__and2_2
XFILLER_7_1440 VGND VGND VPWR VPWR sky130_fd_sc_hd__decap_3
X_4091_ _4091_/A1 _4088_/X _4089_/Y _4090_/X _4734_/C1 VGND VGND VPWR VPWR _4091_/X
+ sky130_fd_sc_hd__o221a_2
XFILLER_27_1390 VGND VGND VPWR VPWR sky130_fd_sc_hd__decap_3
XFILLER_62_1270 VGND VGND VPWR VPWR sky130_fd_sc_hd__decap_3
XFILLER_3_1304 VGND VGND VPWR VPWR sky130_fd_sc_hd__decap_3
X_3042_ _4487_/A VGND VGND VPWR VPWR _3042_/Y sky130_fd_sc_hd__inv_2
XFILLER_23_1254 VGND VGND VPWR VPWR sky130_fd_sc_hd__decap_3
XFILLER_55_319 VGND VGND VPWR VPWR sky130_fd_sc_hd__decap_3
XFILLER_36_500 VGND VGND VPWR VPWR sky130_fd_sc_hd__decap_3
XFILLER_3_1337 VGND VGND VPWR VPWR sky130_fd_sc_hd__decap_3
XFILLER_48_371 VGND VGND VPWR VPWR sky130_fd_sc_hd__fill_1
XFILLER_64_820 VGND VGND VPWR VPWR sky130_fd_sc_hd__fill_1
XFILLER_3_1348 VGND VGND VPWR VPWR sky130_fd_sc_hd__decap_3
XFILLER_23_1287 VGND VGND VPWR VPWR sky130_fd_sc_hd__fill_1
XFILLER_48_393 VGND VGND VPWR VPWR sky130_fd_sc_hd__fill_1
XFILLER_64_842 VGND VGND VPWR VPWR sky130_fd_sc_hd__decap_3
XFILLER_23_1298 VGND VGND VPWR VPWR sky130_fd_sc_hd__decap_3
XFILLER_75_190 VGND VGND VPWR VPWR sky130_fd_sc_hd__decap_3
XFILLER_58_1306 VGND VGND VPWR VPWR sky130_fd_sc_hd__decap_3
XFILLER_58_1317 VGND VGND VPWR VPWR sky130_fd_sc_hd__decap_3
XFILLER_51_503 VGND VGND VPWR VPWR sky130_fd_sc_hd__fill_1
X_6801_ _6897_/CLK _6801_/D wire712/X VGND VGND VPWR VPWR _6801_/Q sky130_fd_sc_hd__dfrtp_2
XFILLER_24_728 VGND VGND VPWR VPWR sky130_fd_sc_hd__fill_1
X_4993_ _6453_/Q _6671_/Q VGND VGND VPWR VPWR _4994_/B sky130_fd_sc_hd__xor2_2
XFILLER_51_525 VGND VGND VPWR VPWR sky130_fd_sc_hd__decap_3
XFILLER_63_385 VGND VGND VPWR VPWR sky130_fd_sc_hd__decap_3
XFILLER_1_1083 VGND VGND VPWR VPWR sky130_fd_sc_hd__decap_3
XFILLER_63_396 VGND VGND VPWR VPWR sky130_fd_sc_hd__fill_1
XFILLER_23_238 VGND VGND VPWR VPWR sky130_fd_sc_hd__fill_1
XFILLER_56_1030 VGND VGND VPWR VPWR sky130_fd_sc_hd__decap_3
X_6732_ _7020_/CLK _6732_/D load_slew808/X VGND VGND VPWR VPWR _6732_/Q sky130_fd_sc_hd__dfrtp_2
X_3944_ _5517_/B2 _6311_/Q VGND VGND VPWR VPWR _3944_/X sky130_fd_sc_hd__and2b_2
XTAP_TAPCELL_ROW_80_2290 VGND VPWR sky130_fd_sc_hd__tapvpwrvgnd_1
X_6663_ _7007_/CLK _6663_/D load_slew822/X VGND VGND VPWR VPWR _6663_/Q sky130_fd_sc_hd__dfrtp_2
X_3875_ _4318_/A _4083_/B _3857_/X _3486_/B VGND VGND VPWR VPWR _3875_/X sky130_fd_sc_hd__o2bb2a_2
X_5614_ _5769_/A _6062_/B VGND VGND VPWR VPWR _5703_/A sky130_fd_sc_hd__nor2_2
XFILLER_20_967 VGND VGND VPWR VPWR sky130_fd_sc_hd__decap_3
XFILLER_34_1350 VGND VGND VPWR VPWR sky130_fd_sc_hd__decap_3
X_6594_ _6807_/CLK _6594_/D load_slew784/X VGND VGND VPWR VPWR _6594_/Q sky130_fd_sc_hd__dfrtp_2
XTAP_TAPCELL_ROW_30_973 VGND VPWR sky130_fd_sc_hd__tapvpwrvgnd_1
XTAP_TAPCELL_ROW_30_984 VGND VPWR sky130_fd_sc_hd__tapvpwrvgnd_1
XFILLER_34_1394 VGND VGND VPWR VPWR sky130_fd_sc_hd__decap_3
X_5545_ _6346_/Q _5564_/A2 hold910/X _5564_/B2 VGND VGND VPWR VPWR _6628_/D sky130_fd_sc_hd__a22o_2
XFILLER_69_1413 VGND VGND VPWR VPWR sky130_fd_sc_hd__decap_3
XFILLER_30_1247 VGND VGND VPWR VPWR sky130_fd_sc_hd__decap_3
XFILLER_69_1446 VGND VGND VPWR VPWR sky130_fd_sc_hd__decap_3
XFILLER_69_1457 VGND VGND VPWR VPWR sky130_fd_sc_hd__decap_3
X_5476_ _5476_/A1 _5476_/A2 _4874_/X VGND VGND VPWR VPWR _6588_/D sky130_fd_sc_hd__a21o_2
XFILLER_2_109 VGND VGND VPWR VPWR sky130_fd_sc_hd__decap_3
X_4427_ _6279_/Q _4426_/X _4427_/S VGND VGND VPWR VPWR _6279_/D sky130_fd_sc_hd__mux2_1
XFILLER_28_1132 VGND VGND VPWR VPWR sky130_fd_sc_hd__decap_3
XFILLER_63_1012 VGND VGND VPWR VPWR sky130_fd_sc_hd__decap_3
Xfanout402 _4772_/C1 VGND VGND VPWR VPWR _4013_/A sky130_fd_sc_hd__clkdlybuf4s25_1
Xfanout413 _3486_/X VGND VGND VPWR VPWR fanout413/X sky130_fd_sc_hd__clkdlybuf4s25_1
XFILLER_67_1192 VGND VGND VPWR VPWR sky130_fd_sc_hd__decap_3
XFILLER_8_1226 VGND VGND VPWR VPWR sky130_fd_sc_hd__decap_3
Xfanout424 _3948_/B1 VGND VGND VPWR VPWR _3921_/B1 sky130_fd_sc_hd__clkdlybuf4s25_1
X_4358_ _4358_/A VGND VGND VPWR VPWR _4359_/B sky130_fd_sc_hd__inv_2
Xfanout435 wire443/A VGND VGND VPWR VPWR wire437/A sky130_fd_sc_hd__clkdlybuf4s25_1
Xfanout446 _4010_/B VGND VGND VPWR VPWR _3928_/A2 sky130_fd_sc_hd__clkdlybuf4s25_1
Xfanout457 _4654_/A1 VGND VGND VPWR VPWR _4831_/A1 sky130_fd_sc_hd__clkdlybuf4s25_1
XFILLER_59_647 VGND VGND VPWR VPWR sky130_fd_sc_hd__decap_3
XFILLER_8_1259 VGND VGND VPWR VPWR sky130_fd_sc_hd__fill_1
X_3309_ _5975_/A0 _3308_/X _3453_/S VGND VGND VPWR VPWR _6128_/D sky130_fd_sc_hd__mux2_1
Xfanout468 _5358_/C VGND VGND VPWR VPWR _4049_/A1 sky130_fd_sc_hd__clkdlybuf4s25_1
XFILLER_41_1310 VGND VGND VPWR VPWR sky130_fd_sc_hd__decap_3
X_7077_ _7077_/CLK _7077_/D load_slew679/X VGND VGND VPWR VPWR _7077_/Q sky130_fd_sc_hd__dfrtp_2
XFILLER_63_1089 VGND VGND VPWR VPWR sky130_fd_sc_hd__fill_1
X_4289_ _3796_/A _3796_/B _4562_/C _4842_/B _4394_/A VGND VGND VPWR VPWR _4289_/X
+ sky130_fd_sc_hd__o2111a_2
Xfanout479 fanout488/X VGND VGND VPWR VPWR _4619_/A1 sky130_fd_sc_hd__clkdlybuf4s25_1
X_6028_ hold911/X _7032_/Q _6052_/S VGND VGND VPWR VPWR _6028_/X sky130_fd_sc_hd__mux2_1
XFILLER_41_1343 VGND VGND VPWR VPWR sky130_fd_sc_hd__fill_1
XFILLER_27_500 VGND VGND VPWR VPWR sky130_fd_sc_hd__decap_3
XFILLER_41_1354 VGND VGND VPWR VPWR sky130_fd_sc_hd__decap_3
XFILLER_73_116 VGND VGND VPWR VPWR sky130_fd_sc_hd__decap_3
XFILLER_27_511 VGND VGND VPWR VPWR sky130_fd_sc_hd__fill_1
XFILLER_39_371 VGND VGND VPWR VPWR sky130_fd_sc_hd__decap_3
XFILLER_64_15 VGND VGND VPWR VPWR sky130_fd_sc_hd__decap_3
XFILLER_39_393 VGND VGND VPWR VPWR sky130_fd_sc_hd__fill_1
XFILLER_41_1387 VGND VGND VPWR VPWR sky130_fd_sc_hd__decap_3
XFILLER_76_1406 VGND VGND VPWR VPWR sky130_fd_sc_hd__decap_3
XFILLER_27_544 VGND VGND VPWR VPWR sky130_fd_sc_hd__decap_3
XFILLER_55_864 VGND VGND VPWR VPWR sky130_fd_sc_hd__fill_2
XFILLER_15_717 VGND VGND VPWR VPWR sky130_fd_sc_hd__decap_3
XFILLER_42_514 VGND VGND VPWR VPWR sky130_fd_sc_hd__decap_3
XFILLER_55_897 VGND VGND VPWR VPWR sky130_fd_sc_hd__decap_3
XFILLER_70_856 VGND VGND VPWR VPWR sky130_fd_sc_hd__decap_3
XFILLER_74_1141 VGND VGND VPWR VPWR sky130_fd_sc_hd__decap_3
XFILLER_74_1152 VGND VGND VPWR VPWR sky130_fd_sc_hd__decap_3
Xfanout20 _3830_/Y VGND VGND VPWR VPWR _4300_/B sky130_fd_sc_hd__clkdlybuf4s25_1
XFILLER_39_1272 VGND VGND VPWR VPWR sky130_fd_sc_hd__decap_3
XFILLER_70_889 VGND VGND VPWR VPWR sky130_fd_sc_hd__fill_1
XTAP_TAPCELL_ROW_42_1304 VGND VPWR sky130_fd_sc_hd__tapvpwrvgnd_1
Xfanout42 fanout47/X VGND VGND VPWR VPWR _4592_/B1 sky130_fd_sc_hd__clkdlybuf4s25_1
Xfanout53 _4775_/A2 VGND VGND VPWR VPWR wire54/A sky130_fd_sc_hd__clkdlybuf4s25_1
XFILLER_74_1185 VGND VGND VPWR VPWR sky130_fd_sc_hd__decap_3
XFILLER_11_923 VGND VGND VPWR VPWR sky130_fd_sc_hd__decap_3
XFILLER_80_47 VGND VGND VPWR VPWR sky130_fd_sc_hd__decap_3
XFILLER_23_794 VGND VGND VPWR VPWR sky130_fd_sc_hd__decap_3
Xfanout64 _4759_/A2 VGND VGND VPWR VPWR _4593_/A2 sky130_fd_sc_hd__clkdlybuf4s25_1
Xfanout75 _3489_/Y VGND VGND VPWR VPWR _4105_/A2 sky130_fd_sc_hd__clkdlybuf4s25_1
XFILLER_22_282 VGND VGND VPWR VPWR sky130_fd_sc_hd__decap_3
XFILLER_13_1401 VGND VGND VPWR VPWR sky130_fd_sc_hd__decap_3
XFILLER_13_30 VGND VGND VPWR VPWR sky130_fd_sc_hd__decap_3
XFILLER_52_1450 VGND VGND VPWR VPWR sky130_fd_sc_hd__decap_3
XFILLER_6_404 VGND VGND VPWR VPWR sky130_fd_sc_hd__decap_3
XFILLER_13_1434 VGND VGND VPWR VPWR sky130_fd_sc_hd__decap_3
XFILLER_10_466 VGND VGND VPWR VPWR sky130_fd_sc_hd__decap_3
XFILLER_7_949 VGND VGND VPWR VPWR sky130_fd_sc_hd__decap_3
XFILLER_10_477 VGND VGND VPWR VPWR sky130_fd_sc_hd__decap_3
XFILLER_2_610 VGND VGND VPWR VPWR sky130_fd_sc_hd__decap_3
XFILLER_11_1180 VGND VGND VPWR VPWR sky130_fd_sc_hd__decap_3
XFILLER_1_131 VGND VGND VPWR VPWR sky130_fd_sc_hd__decap_3
XFILLER_2_654 VGND VGND VPWR VPWR sky130_fd_sc_hd__decap_3
Xload_slew808 fanout807/X VGND VGND VPWR VPWR load_slew808/X sky130_fd_sc_hd__buf_4
XFILLER_78_912 VGND VGND VPWR VPWR sky130_fd_sc_hd__decap_3
XFILLER_46_1232 VGND VGND VPWR VPWR sky130_fd_sc_hd__decap_3
Xload_slew819 fanout818/X VGND VGND VPWR VPWR load_slew819/X sky130_fd_sc_hd__buf_2
XFILLER_78_934 VGND VGND VPWR VPWR sky130_fd_sc_hd__fill_1
XFILLER_77_411 VGND VGND VPWR VPWR sky130_fd_sc_hd__decap_3
XFILLER_1_164 VGND VGND VPWR VPWR sky130_fd_sc_hd__decap_3
XFILLER_2_687 VGND VGND VPWR VPWR sky130_fd_sc_hd__decap_3
XFILLER_1_175 VGND VGND VPWR VPWR sky130_fd_sc_hd__decap_3
XFILLER_46_1276 VGND VGND VPWR VPWR sky130_fd_sc_hd__decap_3
XFILLER_77_455 VGND VGND VPWR VPWR sky130_fd_sc_hd__fill_1
XFILLER_37_308 VGND VGND VPWR VPWR sky130_fd_sc_hd__decap_3
XFILLER_20_1427 VGND VGND VPWR VPWR sky130_fd_sc_hd__fill_1
XFILLER_46_831 VGND VGND VPWR VPWR sky130_fd_sc_hd__decap_3
XFILLER_18_533 VGND VGND VPWR VPWR sky130_fd_sc_hd__fill_2
XFILLER_20_1438 VGND VGND VPWR VPWR sky130_fd_sc_hd__decap_3
XFILLER_18_555 VGND VGND VPWR VPWR sky130_fd_sc_hd__decap_3
XFILLER_46_864 VGND VGND VPWR VPWR sky130_fd_sc_hd__decap_3
XFILLER_46_875 VGND VGND VPWR VPWR sky130_fd_sc_hd__decap_3
XFILLER_45_363 VGND VGND VPWR VPWR sky130_fd_sc_hd__fill_1
XFILLER_79_1085 VGND VGND VPWR VPWR sky130_fd_sc_hd__decap_3
XFILLER_33_514 VGND VGND VPWR VPWR sky130_fd_sc_hd__decap_3
XFILLER_33_547 VGND VGND VPWR VPWR sky130_fd_sc_hd__decap_3
XFILLER_54_70 VGND VGND VPWR VPWR sky130_fd_sc_hd__decap_3
XFILLER_18_1312 VGND VGND VPWR VPWR sky130_fd_sc_hd__decap_3
XFILLER_18_1323 VGND VGND VPWR VPWR sky130_fd_sc_hd__decap_3
XFILLER_57_1372 VGND VGND VPWR VPWR sky130_fd_sc_hd__decap_3
XFILLER_61_889 VGND VGND VPWR VPWR sky130_fd_sc_hd__decap_3
XFILLER_18_1356 VGND VGND VPWR VPWR sky130_fd_sc_hd__decap_3
XFILLER_53_1236 VGND VGND VPWR VPWR sky130_fd_sc_hd__decap_3
XFILLER_9_231 VGND VGND VPWR VPWR sky130_fd_sc_hd__decap_3
XFILLER_53_1269 VGND VGND VPWR VPWR sky130_fd_sc_hd__decap_3
X_3660_ _3660_/A _3660_/B VGND VGND VPWR VPWR _3669_/A sky130_fd_sc_hd__and2_2
XFILLER_16_1091 VGND VGND VPWR VPWR sky130_fd_sc_hd__fill_1
Xclkload12 _7050_/CLK VGND VGND VPWR VPWR clkload12/X sky130_fd_sc_hd__clkbuf_4
Xclkload23 _7034_/CLK VGND VGND VPWR VPWR clkload23/X sky130_fd_sc_hd__clkbuf_4
X_3591_ _3673_/A _3649_/B VGND VGND VPWR VPWR _3591_/Y sky130_fd_sc_hd__nor2_2
XTAP_TAPCELL_ROW_11_483 VGND VPWR sky130_fd_sc_hd__tapvpwrvgnd_1
Xclkload34 _6863_/CLK VGND VGND VPWR VPWR clkload34/X sky130_fd_sc_hd__clkbuf_8
XTAP_TAPCELL_ROW_11_494 VGND VPWR sky130_fd_sc_hd__tapvpwrvgnd_1
Xclkload45 _7020_/CLK VGND VGND VPWR VPWR clkload45/X sky130_fd_sc_hd__clkbuf_4
X_5330_ _6796_/Q _5029_/B _5330_/S VGND VGND VPWR VPWR _5330_/X sky130_fd_sc_hd__mux2_1
Xclkload56 _7039_/CLK VGND VGND VPWR VPWR clkload56/X sky130_fd_sc_hd__clkbuf_4
XFILLER_6_971 VGND VGND VPWR VPWR sky130_fd_sc_hd__decap_3
XFILLER_55_3 VGND VGND VPWR VPWR sky130_fd_sc_hd__decap_3
XFILLER_5_470 VGND VGND VPWR VPWR sky130_fd_sc_hd__decap_3
X_5261_ _5261_/A _5261_/B VGND VGND VPWR VPWR _5261_/Y sky130_fd_sc_hd__nand2_2
XFILLER_47_1029 VGND VGND VPWR VPWR sky130_fd_sc_hd__decap_3
X_7000_ _7000_/CLK _7000_/D fanout697/X VGND VGND VPWR VPWR _7000_/Q sky130_fd_sc_hd__dfrtp_2
X_4212_ _4283_/A _4624_/B VGND VGND VPWR VPWR _4212_/Y sky130_fd_sc_hd__nand2_2
XFILLER_29_1452 VGND VGND VPWR VPWR sky130_fd_sc_hd__decap_3
XFILLER_64_1332 VGND VGND VPWR VPWR sky130_fd_sc_hd__decap_3
XFILLER_29_1463 VGND VGND VPWR VPWR sky130_fd_sc_hd__decap_3
X_5192_ _6743_/Q _5276_/A VGND VGND VPWR VPWR _5192_/Y sky130_fd_sc_hd__nor2_2
XFILLER_25_1316 VGND VGND VPWR VPWR sky130_fd_sc_hd__decap_3
XFILLER_64_1365 VGND VGND VPWR VPWR sky130_fd_sc_hd__decap_3
XFILLER_64_1376 VGND VGND VPWR VPWR sky130_fd_sc_hd__decap_3
XFILLER_69_956 VGND VGND VPWR VPWR sky130_fd_sc_hd__decap_3
X_4143_ _4143_/A _4143_/B VGND VGND VPWR VPWR _4747_/B sky130_fd_sc_hd__xnor2_2
XFILLER_60_1229 VGND VGND VPWR VPWR sky130_fd_sc_hd__decap_3
XFILLER_69_989 VGND VGND VPWR VPWR sky130_fd_sc_hd__decap_3
XFILLER_68_477 VGND VGND VPWR VPWR sky130_fd_sc_hd__decap_3
XFILLER_3_1101 VGND VGND VPWR VPWR sky130_fd_sc_hd__decap_3
X_4074_ _3470_/X _4583_/B2 _4584_/A2 _6932_/Q _4092_/C1 VGND VGND VPWR VPWR _4074_/X
+ sky130_fd_sc_hd__a221o_2
XFILLER_7_1281 VGND VGND VPWR VPWR sky130_fd_sc_hd__decap_3
XFILLER_55_116 VGND VGND VPWR VPWR sky130_fd_sc_hd__decap_3
XFILLER_37_820 VGND VGND VPWR VPWR sky130_fd_sc_hd__decap_3
XFILLER_7_1292 VGND VGND VPWR VPWR sky130_fd_sc_hd__decap_3
XFILLER_3_1145 VGND VGND VPWR VPWR sky130_fd_sc_hd__decap_3
XFILLER_48_190 VGND VGND VPWR VPWR sky130_fd_sc_hd__decap_3
XFILLER_3_1189 VGND VGND VPWR VPWR sky130_fd_sc_hd__decap_3
XFILLER_37_897 VGND VGND VPWR VPWR sky130_fd_sc_hd__decap_3
XFILLER_36_385 VGND VGND VPWR VPWR sky130_fd_sc_hd__decap_3
XFILLER_58_1147 VGND VGND VPWR VPWR sky130_fd_sc_hd__fill_1
XFILLER_51_322 VGND VGND VPWR VPWR sky130_fd_sc_hd__fill_1
XFILLER_52_867 VGND VGND VPWR VPWR sky130_fd_sc_hd__fill_1
XFILLER_63_193 VGND VGND VPWR VPWR sky130_fd_sc_hd__decap_3
XFILLER_52_878 VGND VGND VPWR VPWR sky130_fd_sc_hd__decap_3
XFILLER_36_1412 VGND VGND VPWR VPWR sky130_fd_sc_hd__decap_3
X_4976_ _4974_/X _4975_/Y _5254_/A2 VGND VGND VPWR VPWR _4978_/S sky130_fd_sc_hd__a21oi_2
XFILLER_51_366 VGND VGND VPWR VPWR sky130_fd_sc_hd__decap_3
XFILLER_71_1325 VGND VGND VPWR VPWR sky130_fd_sc_hd__decap_3
X_6715_ _7004_/CLK _6715_/D load_slew845/X VGND VGND VPWR VPWR _6715_/Q sky130_fd_sc_hd__dfrtp_2
XFILLER_36_1456 VGND VGND VPWR VPWR sky130_fd_sc_hd__decap_3
X_3927_ _3927_/A_N _6237_/Q VGND VGND VPWR VPWR _3927_/X sky130_fd_sc_hd__and2b_2
XFILLER_20_731 VGND VGND VPWR VPWR sky130_fd_sc_hd__decap_3
XFILLER_32_1309 VGND VGND VPWR VPWR sky130_fd_sc_hd__decap_3
XFILLER_71_1369 VGND VGND VPWR VPWR sky130_fd_sc_hd__decap_3
Xclkload6 clkload6/A VGND VGND VPWR VPWR clkload6/X sky130_fd_sc_hd__clkbuf_8
X_6646_ _6958_/CLK _6646_/D fanout752/X VGND VGND VPWR VPWR _6646_/Q sky130_fd_sc_hd__dfrtp_2
X_3858_ _4010_/A _6316_/Q VGND VGND VPWR VPWR _3858_/X sky130_fd_sc_hd__and2b_2
X_3789_ _3789_/A _3789_/B _3789_/C VGND VGND VPWR VPWR _3888_/A sky130_fd_sc_hd__or3_2
X_6577_ _6958_/CLK _6577_/D fanout759/A VGND VGND VPWR VPWR _6577_/Q sky130_fd_sc_hd__dfrtp_2
XFILLER_69_1210 VGND VGND VPWR VPWR sky130_fd_sc_hd__decap_3
XTAP_TAPCELL_ROW_76_2167 VGND VPWR sky130_fd_sc_hd__tapvpwrvgnd_1
XTAP_TAPCELL_ROW_76_2178 VGND VPWR sky130_fd_sc_hd__tapvpwrvgnd_1
X_5528_ _6613_/Q _5488_/X _5527_/X VGND VGND VPWR VPWR _6613_/D sky130_fd_sc_hd__o21a_2
XFILLER_69_1254 VGND VGND VPWR VPWR sky130_fd_sc_hd__decap_3
XTAP_TAPCELL_ROW_76_2189 VGND VPWR sky130_fd_sc_hd__tapvpwrvgnd_1
XFILLER_3_429 VGND VGND VPWR VPWR sky130_fd_sc_hd__decap_3
XFILLER_69_1287 VGND VGND VPWR VPWR sky130_fd_sc_hd__fill_1
X_5459_ _5459_/A1 _5486_/A2 _4749_/X VGND VGND VPWR VPWR _6571_/D sky130_fd_sc_hd__a21o_2
XFILLER_65_1129 VGND VGND VPWR VPWR sky130_fd_sc_hd__decap_3
XFILLER_69_1298 VGND VGND VPWR VPWR sky130_fd_sc_hd__decap_3
XFILLER_8_1012 VGND VGND VPWR VPWR sky130_fd_sc_hd__decap_3
XFILLER_43_1416 VGND VGND VPWR VPWR sky130_fd_sc_hd__decap_3
Xfanout232 _6059_/S VGND VGND VPWR VPWR _5971_/S sky130_fd_sc_hd__clkdlybuf4s25_1
Xfanout243 _5487_/A2 VGND VGND VPWR VPWR _5486_/A2 sky130_fd_sc_hd__clkdlybuf4s25_1
XTAP_TAPCELL_ROW_31_1005 VGND VPWR sky130_fd_sc_hd__tapvpwrvgnd_1
Xfanout254 _4717_/A VGND VGND VPWR VPWR _4610_/A sky130_fd_sc_hd__clkdlybuf4s25_1
XTAP_TAPCELL_ROW_31_1016 VGND VPWR sky130_fd_sc_hd__tapvpwrvgnd_1
XFILLER_43_1449 VGND VGND VPWR VPWR sky130_fd_sc_hd__decap_3
Xfanout265 _4580_/B VGND VGND VPWR VPWR _4645_/A sky130_fd_sc_hd__clkdlybuf4s25_1
XFILLER_59_455 VGND VGND VPWR VPWR sky130_fd_sc_hd__decap_3
Xfanout276 _4518_/A VGND VGND VPWR VPWR _4438_/A sky130_fd_sc_hd__clkdlybuf4s25_1
Xfanout287 _4751_/A2 VGND VGND VPWR VPWR _4774_/A2 sky130_fd_sc_hd__clkdlybuf4s25_1
XFILLER_75_36 VGND VGND VPWR VPWR sky130_fd_sc_hd__decap_3
XFILLER_74_414 VGND VGND VPWR VPWR sky130_fd_sc_hd__decap_3
Xfanout298 _4855_/A2 VGND VGND VPWR VPWR fanout298/X sky130_fd_sc_hd__clkdlybuf4s25_1
XFILLER_75_47 VGND VGND VPWR VPWR sky130_fd_sc_hd__decap_3
XFILLER_76_1203 VGND VGND VPWR VPWR sky130_fd_sc_hd__fill_1
XFILLER_28_875 VGND VGND VPWR VPWR sky130_fd_sc_hd__decap_3
XFILLER_76_1214 VGND VGND VPWR VPWR sky130_fd_sc_hd__decap_3
XFILLER_61_119 VGND VGND VPWR VPWR sky130_fd_sc_hd__decap_3
XFILLER_15_525 VGND VGND VPWR VPWR sky130_fd_sc_hd__decap_3
XFILLER_76_1247 VGND VGND VPWR VPWR sky130_fd_sc_hd__decap_3
XFILLER_27_396 VGND VGND VPWR VPWR sky130_fd_sc_hd__decap_3
XFILLER_42_333 VGND VGND VPWR VPWR sky130_fd_sc_hd__fill_2
XFILLER_54_193 VGND VGND VPWR VPWR sky130_fd_sc_hd__decap_3
XTAP_TAPCELL_ROW_65_1882 VGND VPWR sky130_fd_sc_hd__tapvpwrvgnd_1
XFILLER_70_686 VGND VGND VPWR VPWR sky130_fd_sc_hd__fill_2
XFILLER_39_1091 VGND VGND VPWR VPWR sky130_fd_sc_hd__decap_3
XTAP_TAPCELL_ROW_65_1893 VGND VPWR sky130_fd_sc_hd__tapvpwrvgnd_1
XFILLER_23_580 VGND VGND VPWR VPWR sky130_fd_sc_hd__decap_3
XFILLER_50_1409 VGND VGND VPWR VPWR sky130_fd_sc_hd__decap_3
XTAP_TAPCELL_ROW_61_1779 VGND VPWR sky130_fd_sc_hd__tapvpwrvgnd_1
Xwire655 wire655/A VGND VGND VPWR VPWR wire655/X sky130_fd_sc_hd__clkbuf_4
XFILLER_13_1242 VGND VGND VPWR VPWR sky130_fd_sc_hd__decap_3
XFILLER_52_1291 VGND VGND VPWR VPWR sky130_fd_sc_hd__decap_3
XFILLER_7_779 VGND VGND VPWR VPWR sky130_fd_sc_hd__decap_3
XFILLER_6_256 VGND VGND VPWR VPWR sky130_fd_sc_hd__decap_3
XFILLER_40_50 VGND VGND VPWR VPWR sky130_fd_sc_hd__decap_3
XFILLER_13_1275 VGND VGND VPWR VPWR sky130_fd_sc_hd__decap_3
XFILLER_6_278 VGND VGND VPWR VPWR sky130_fd_sc_hd__decap_3
XFILLER_40_83 VGND VGND VPWR VPWR sky130_fd_sc_hd__fill_1
XFILLER_3_930 VGND VGND VPWR VPWR sky130_fd_sc_hd__fill_2
XFILLER_40_94 VGND VGND VPWR VPWR sky130_fd_sc_hd__fill_2
XFILLER_48_1338 VGND VGND VPWR VPWR sky130_fd_sc_hd__decap_3
XFILLER_41_9 VGND VGND VPWR VPWR sky130_fd_sc_hd__decap_3
XFILLER_3_974 VGND VGND VPWR VPWR sky130_fd_sc_hd__decap_3
XFILLER_2_451 VGND VGND VPWR VPWR sky130_fd_sc_hd__decap_3
XFILLER_3_996 VGND VGND VPWR VPWR sky130_fd_sc_hd__decap_3
XFILLER_78_742 VGND VGND VPWR VPWR sky130_fd_sc_hd__decap_3
XFILLER_66_904 VGND VGND VPWR VPWR sky130_fd_sc_hd__decap_3
XFILLER_49_92 VGND VGND VPWR VPWR sky130_fd_sc_hd__decap_3
XFILLER_4_1421 VGND VGND VPWR VPWR sky130_fd_sc_hd__decap_3
XFILLER_1_33 VGND VGND VPWR VPWR sky130_fd_sc_hd__decap_3
XFILLER_4_1432 VGND VGND VPWR VPWR sky130_fd_sc_hd__decap_3
XFILLER_65_436 VGND VGND VPWR VPWR sky130_fd_sc_hd__decap_3
XFILLER_66_959 VGND VGND VPWR VPWR sky130_fd_sc_hd__decap_3
XFILLER_24_1371 VGND VGND VPWR VPWR sky130_fd_sc_hd__fill_1
XFILLER_24_1382 VGND VGND VPWR VPWR sky130_fd_sc_hd__decap_3
XFILLER_1_66 VGND VGND VPWR VPWR sky130_fd_sc_hd__decap_3
XFILLER_18_330 VGND VGND VPWR VPWR sky130_fd_sc_hd__decap_3
XFILLER_4_1465 VGND VGND VPWR VPWR sky130_fd_sc_hd__decap_3
XFILLER_59_1401 VGND VGND VPWR VPWR sky130_fd_sc_hd__decap_3
XFILLER_0_1307 VGND VGND VPWR VPWR sky130_fd_sc_hd__decap_3
XFILLER_20_1246 VGND VGND VPWR VPWR sky130_fd_sc_hd__decap_3
XFILLER_74_970 VGND VGND VPWR VPWR sky130_fd_sc_hd__decap_3
XFILLER_1_99 VGND VGND VPWR VPWR sky130_fd_sc_hd__decap_3
XFILLER_0_1329 VGND VGND VPWR VPWR sky130_fd_sc_hd__decap_3
XFILLER_18_363 VGND VGND VPWR VPWR sky130_fd_sc_hd__fill_1
XFILLER_46_672 VGND VGND VPWR VPWR sky130_fd_sc_hd__decap_3
XFILLER_59_1434 VGND VGND VPWR VPWR sky130_fd_sc_hd__decap_3
XFILLER_20_1279 VGND VGND VPWR VPWR sky130_fd_sc_hd__decap_3
XFILLER_33_322 VGND VGND VPWR VPWR sky130_fd_sc_hd__decap_3
X_4830_ _6582_/Q _4829_/A _4831_/A1 VGND VGND VPWR VPWR _4830_/X sky130_fd_sc_hd__a21bo_2
XFILLER_34_878 VGND VGND VPWR VPWR sky130_fd_sc_hd__decap_3
XFILLER_60_141 VGND VGND VPWR VPWR sky130_fd_sc_hd__decap_3
XFILLER_60_152 VGND VGND VPWR VPWR sky130_fd_sc_hd__decap_3
XFILLER_18_1120 VGND VGND VPWR VPWR sky130_fd_sc_hd__fill_1
XFILLER_57_1180 VGND VGND VPWR VPWR sky130_fd_sc_hd__decap_3
X_4761_ _6573_/Q _4723_/X _4763_/C1 VGND VGND VPWR VPWR _4761_/X sky130_fd_sc_hd__a21o_2
XFILLER_60_185 VGND VGND VPWR VPWR sky130_fd_sc_hd__decap_3
X_3712_ _4420_/C _3712_/B VGND VGND VPWR VPWR _4547_/B sky130_fd_sc_hd__nand2_2
X_6500_ _7088_/CLK _6500_/D fanout772/X VGND VGND VPWR VPWR _6500_/Q sky130_fd_sc_hd__dfrtp_2
X_4692_ _6893_/Q _4869_/A2 _4869_/B1 _4691_/X VGND VGND VPWR VPWR _4692_/X sky130_fd_sc_hd__a211o_2
XFILLER_31_1331 VGND VGND VPWR VPWR sky130_fd_sc_hd__decap_3
X_3643_ _3634_/X _3635_/Y _3791_/A VGND VGND VPWR VPWR _3646_/A sky130_fd_sc_hd__a21o_2
X_6431_ _6897_/CLK _6431_/D wire712/X VGND VGND VPWR VPWR _6431_/Q sky130_fd_sc_hd__dfrtp_2
XFILLER_70_1391 VGND VGND VPWR VPWR sky130_fd_sc_hd__decap_3
XFILLER_31_1375 VGND VGND VPWR VPWR sky130_fd_sc_hd__decap_3
X_6362_ _7020_/CLK _6362_/D load_slew808/X VGND VGND VPWR VPWR _6362_/Q sky130_fd_sc_hd__dfrtp_2
X_3574_ _4487_/A _3569_/Y _3573_/Y VGND VGND VPWR VPWR _3576_/C sky130_fd_sc_hd__a21o_2
X_5313_ _6449_/Q _5312_/X _5321_/S VGND VGND VPWR VPWR _6449_/D sky130_fd_sc_hd__mux2_1
XFILLER_66_1427 VGND VGND VPWR VPWR sky130_fd_sc_hd__fill_1
X_6293_ _6863_/CLK _6293_/D load_slew757/X VGND VGND VPWR VPWR _6293_/Q sky130_fd_sc_hd__dfrtp_2
XFILLER_66_1438 VGND VGND VPWR VPWR sky130_fd_sc_hd__decap_3
XTAP_TAPCELL_ROW_71_2042 VGND VPWR sky130_fd_sc_hd__tapvpwrvgnd_1
XTAP_TAPCELL_ROW_71_2053 VGND VPWR sky130_fd_sc_hd__tapvpwrvgnd_1
XFILLER_9_1310 VGND VGND VPWR VPWR sky130_fd_sc_hd__decap_3
X_5244_ _6761_/Q _5334_/S _5335_/S _5243_/Y VGND VGND VPWR VPWR _5244_/X sky130_fd_sc_hd__o211a_2
XFILLER_29_1260 VGND VGND VPWR VPWR sky130_fd_sc_hd__decap_3
XFILLER_69_720 VGND VGND VPWR VPWR sky130_fd_sc_hd__decap_3
XFILLER_9_1343 VGND VGND VPWR VPWR sky130_fd_sc_hd__fill_1
XFILLER_9_1354 VGND VGND VPWR VPWR sky130_fd_sc_hd__decap_3
XFILLER_64_1173 VGND VGND VPWR VPWR sky130_fd_sc_hd__decap_3
X_5175_ _6396_/Q wire112/X _5048_/S _5174_/X VGND VGND VPWR VPWR _6396_/D sky130_fd_sc_hd__a22o_2
XFILLER_5_1207 VGND VGND VPWR VPWR sky130_fd_sc_hd__decap_3
XFILLER_9_1387 VGND VGND VPWR VPWR sky130_fd_sc_hd__decap_3
XFILLER_29_617 VGND VGND VPWR VPWR sky130_fd_sc_hd__decap_3
XFILLER_60_1037 VGND VGND VPWR VPWR sky130_fd_sc_hd__decap_3
XFILLER_28_105 VGND VGND VPWR VPWR sky130_fd_sc_hd__fill_1
X_4126_ _6811_/Q _4855_/A2 _4766_/B1 _4125_/X VGND VGND VPWR VPWR _4126_/X sky130_fd_sc_hd__a211o_2
XFILLER_28_149 VGND VGND VPWR VPWR sky130_fd_sc_hd__fill_1
X_4057_ _6239_/Q _4105_/A2 _4055_/X _4056_/X VGND VGND VPWR VPWR _6239_/D sky130_fd_sc_hd__o22a_2
XFILLER_65_970 VGND VGND VPWR VPWR sky130_fd_sc_hd__decap_3
XFILLER_71_428 VGND VGND VPWR VPWR sky130_fd_sc_hd__decap_3
XFILLER_24_322 VGND VGND VPWR VPWR sky130_fd_sc_hd__decap_3
XFILLER_12_506 VGND VGND VPWR VPWR sky130_fd_sc_hd__decap_3
XFILLER_24_377 VGND VGND VPWR VPWR sky130_fd_sc_hd__decap_3
XFILLER_36_1231 VGND VGND VPWR VPWR sky130_fd_sc_hd__decap_3
X_4959_ _6416_/Q _4959_/B VGND VGND VPWR VPWR _5222_/B sky130_fd_sc_hd__xnor2_2
XFILLER_71_1144 VGND VGND VPWR VPWR sky130_fd_sc_hd__decap_3
XFILLER_36_1264 VGND VGND VPWR VPWR sky130_fd_sc_hd__decap_3
XTAP_TAPCELL_ROW_78_2218 VGND VPWR sky130_fd_sc_hd__tapvpwrvgnd_1
XTAP_TAPCELL_ROW_78_2229 VGND VPWR sky130_fd_sc_hd__tapvpwrvgnd_1
XFILLER_71_1177 VGND VGND VPWR VPWR sky130_fd_sc_hd__decap_3
XFILLER_36_1297 VGND VGND VPWR VPWR sky130_fd_sc_hd__decap_3
XFILLER_20_594 VGND VGND VPWR VPWR sky130_fd_sc_hd__decap_3
X_6629_ _6970_/CLK _6629_/D fanout673/X VGND VGND VPWR VPWR _6629_/Q sky130_fd_sc_hd__dfrtp_2
XFILLER_10_1415 VGND VGND VPWR VPWR sky130_fd_sc_hd__decap_3
XFILLER_69_1051 VGND VGND VPWR VPWR sky130_fd_sc_hd__decap_3
XFILLER_10_1459 VGND VGND VPWR VPWR sky130_fd_sc_hd__decap_3
XFILLER_3_248 VGND VGND VPWR VPWR sky130_fd_sc_hd__decap_3
XFILLER_79_517 VGND VGND VPWR VPWR sky130_fd_sc_hd__decap_3
XFILLER_0_900 VGND VGND VPWR VPWR sky130_fd_sc_hd__decap_3
XFILLER_10_97 VGND VGND VPWR VPWR sky130_fd_sc_hd__decap_3
XFILLER_47_1360 VGND VGND VPWR VPWR sky130_fd_sc_hd__decap_3
XFILLER_47_1393 VGND VGND VPWR VPWR sky130_fd_sc_hd__decap_3
XFILLER_0_977 VGND VGND VPWR VPWR sky130_fd_sc_hd__decap_3
XTAP_TAPCELL_ROW_54_1594 VGND VPWR sky130_fd_sc_hd__tapvpwrvgnd_1
XFILLER_0_999 VGND VGND VPWR VPWR sky130_fd_sc_hd__decap_3
XFILLER_43_1257 VGND VGND VPWR VPWR sky130_fd_sc_hd__decap_3
XFILLER_78_1309 VGND VGND VPWR VPWR sky130_fd_sc_hd__decap_3
XTAP_TAPCELL_ROW_67_1933 VGND VPWR sky130_fd_sc_hd__tapvpwrvgnd_1
XTAP_TAPCELL_ROW_67_1944 VGND VPWR sky130_fd_sc_hd__tapvpwrvgnd_1
XFILLER_43_620 VGND VGND VPWR VPWR sky130_fd_sc_hd__fill_1
XFILLER_76_1033 VGND VGND VPWR VPWR sky130_fd_sc_hd__decap_3
XTAP_TAPCELL_ROW_67_1955 VGND VPWR sky130_fd_sc_hd__tapvpwrvgnd_1
XFILLER_43_653 VGND VGND VPWR VPWR sky130_fd_sc_hd__decap_3
XFILLER_37_1017 VGND VGND VPWR VPWR sky130_fd_sc_hd__decap_3
XFILLER_42_141 VGND VGND VPWR VPWR sky130_fd_sc_hd__fill_2
XFILLER_15_366 VGND VGND VPWR VPWR sky130_fd_sc_hd__decap_3
XFILLER_76_1088 VGND VGND VPWR VPWR sky130_fd_sc_hd__decap_3
XTAP_TAPCELL_ROW_26_873 VGND VPWR sky130_fd_sc_hd__tapvpwrvgnd_1
XFILLER_76_1099 VGND VGND VPWR VPWR sky130_fd_sc_hd__decap_3
XFILLER_19_1440 VGND VGND VPWR VPWR sky130_fd_sc_hd__decap_3
XFILLER_35_94 VGND VGND VPWR VPWR sky130_fd_sc_hd__fill_1
XFILLER_54_1320 VGND VGND VPWR VPWR sky130_fd_sc_hd__decap_3
XFILLER_15_388 VGND VGND VPWR VPWR sky130_fd_sc_hd__decap_3
XTAP_TAPCELL_ROW_26_884 VGND VPWR sky130_fd_sc_hd__tapvpwrvgnd_1
XFILLER_15_399 VGND VGND VPWR VPWR sky130_fd_sc_hd__decap_3
XTAP_TAPCELL_ROW_13_534 VGND VPWR sky130_fd_sc_hd__tapvpwrvgnd_1
XFILLER_15_1304 VGND VGND VPWR VPWR sky130_fd_sc_hd__decap_3
XFILLER_54_1353 VGND VGND VPWR VPWR sky130_fd_sc_hd__decap_3
XTAP_TAPCELL_ROW_13_545 VGND VPWR sky130_fd_sc_hd__tapvpwrvgnd_1
XFILLER_15_1337 VGND VGND VPWR VPWR sky130_fd_sc_hd__decap_3
XFILLER_15_1348 VGND VGND VPWR VPWR sky130_fd_sc_hd__decap_3
XFILLER_54_1397 VGND VGND VPWR VPWR sky130_fd_sc_hd__decap_3
XFILLER_11_583 VGND VGND VPWR VPWR sky130_fd_sc_hd__decap_3
XFILLER_13_1061 VGND VGND VPWR VPWR sky130_fd_sc_hd__decap_3
XFILLER_7_576 VGND VGND VPWR VPWR sky130_fd_sc_hd__fill_1
XFILLER_7_587 VGND VGND VPWR VPWR sky130_fd_sc_hd__decap_3
XFILLER_26_1400 VGND VGND VPWR VPWR sky130_fd_sc_hd__decap_3
X_3290_ _6272_/Q _6376_/Q VGND VGND VPWR VPWR _3290_/X sky130_fd_sc_hd__xor2_2
XFILLER_65_1460 VGND VGND VPWR VPWR sky130_fd_sc_hd__decap_3
XFILLER_2_270 VGND VGND VPWR VPWR sky130_fd_sc_hd__decap_3
XFILLER_61_1313 VGND VGND VPWR VPWR sky130_fd_sc_hd__decap_3
XFILLER_26_1444 VGND VGND VPWR VPWR sky130_fd_sc_hd__decap_3
XFILLER_61_1357 VGND VGND VPWR VPWR sky130_fd_sc_hd__decap_3
XFILLER_39_948 VGND VGND VPWR VPWR sky130_fd_sc_hd__decap_3
XFILLER_66_734 VGND VGND VPWR VPWR sky130_fd_sc_hd__fill_2
XFILLER_18_3 VGND VGND VPWR VPWR sky130_fd_sc_hd__decap_3
XFILLER_66_745 VGND VGND VPWR VPWR sky130_fd_sc_hd__fill_2
XFILLER_65_244 VGND VGND VPWR VPWR sky130_fd_sc_hd__decap_3
XTAP_TAPCELL_ROW_0_207 VGND VPWR sky130_fd_sc_hd__tapvpwrvgnd_1
XFILLER_20_1021 VGND VGND VPWR VPWR sky130_fd_sc_hd__decap_3
XFILLER_24_1190 VGND VGND VPWR VPWR sky130_fd_sc_hd__fill_1
X_6980_ _6988_/CLK _6980_/D load_slew813/X VGND VGND VPWR VPWR _6980_/Q sky130_fd_sc_hd__dfrtp_2
XFILLER_4_1273 VGND VGND VPWR VPWR sky130_fd_sc_hd__decap_3
XFILLER_19_661 VGND VGND VPWR VPWR sky130_fd_sc_hd__fill_2
XFILLER_80_225 VGND VGND VPWR VPWR sky130_fd_sc_hd__decap_3
X_5931_ _5931_/A0 _5931_/A1 _5932_/S VGND VGND VPWR VPWR _6936_/D sky130_fd_sc_hd__mux2_1
XFILLER_59_1231 VGND VGND VPWR VPWR sky130_fd_sc_hd__fill_1
XFILLER_46_480 VGND VGND VPWR VPWR sky130_fd_sc_hd__fill_1
XFILLER_59_1242 VGND VGND VPWR VPWR sky130_fd_sc_hd__decap_3
XFILLER_62_940 VGND VGND VPWR VPWR sky130_fd_sc_hd__fill_2
XFILLER_55_1106 VGND VGND VPWR VPWR sky130_fd_sc_hd__fill_1
XFILLER_59_1275 VGND VGND VPWR VPWR sky130_fd_sc_hd__decap_3
X_5862_ _5862_/A0 _5900_/A0 _5867_/S VGND VGND VPWR VPWR _6876_/D sky130_fd_sc_hd__mux2_1
XFILLER_34_675 VGND VGND VPWR VPWR sky130_fd_sc_hd__decap_3
XFILLER_61_483 VGND VGND VPWR VPWR sky130_fd_sc_hd__decap_3
X_4813_ _6331_/Q _4812_/X wire49/X VGND VGND VPWR VPWR _6331_/D sky130_fd_sc_hd__mux2_1
X_5793_ _5915_/D _5868_/B _5793_/C VGND VGND VPWR VPWR _5793_/X sky130_fd_sc_hd__and3b_2
XFILLER_72_1453 VGND VGND VPWR VPWR sky130_fd_sc_hd__decap_3
XFILLER_33_1404 VGND VGND VPWR VPWR sky130_fd_sc_hd__decap_3
XFILLER_33_1437 VGND VGND VPWR VPWR sky130_fd_sc_hd__decap_3
X_4744_ _6908_/Q _4744_/A2 _4744_/B1 _4743_/X VGND VGND VPWR VPWR _4744_/X sky130_fd_sc_hd__a211o_2
X_4675_ _6553_/Q _4703_/A _4793_/A VGND VGND VPWR VPWR _4675_/X sky130_fd_sc_hd__a21bo_2
X_3626_ _6224_/Q _3631_/A2 _5603_/A1 _6280_/Q _3625_/X VGND VGND VPWR VPWR _3626_/X
+ sky130_fd_sc_hd__a221o_2
X_6414_ _6752_/CLK _6414_/D load_slew669/X VGND VGND VPWR VPWR _6414_/Q sky130_fd_sc_hd__dfrtp_2
XTAP_TAPCELL_ROW_73_2104 VGND VPWR sky130_fd_sc_hd__tapvpwrvgnd_1
XFILLER_31_1172 VGND VGND VPWR VPWR sky130_fd_sc_hd__decap_3
X_3557_ _4723_/B _3557_/B VGND VGND VPWR VPWR _3557_/X sky130_fd_sc_hd__or2_2
X_6345_ _7004_/CLK _6345_/D fanout839/X VGND VGND VPWR VPWR _6345_/Q sky130_fd_sc_hd__dfrtp_2
XFILLER_66_1235 VGND VGND VPWR VPWR sky130_fd_sc_hd__decap_3
XFILLER_0_218 VGND VGND VPWR VPWR sky130_fd_sc_hd__decap_3
X_6276_ _7009_/CLK _6276_/D load_slew767/X VGND VGND VPWR VPWR _6276_/Q sky130_fd_sc_hd__dfrtp_2
X_3488_ _5519_/A2 _3488_/B _4796_/A VGND VGND VPWR VPWR _3490_/C sky130_fd_sc_hd__and3b_2
XFILLER_66_1279 VGND VGND VPWR VPWR sky130_fd_sc_hd__decap_3
X_5227_ _6417_/Q _5263_/A2 _5226_/X VGND VGND VPWR VPWR _6417_/D sky130_fd_sc_hd__a21o_2
XFILLER_9_1151 VGND VGND VPWR VPWR sky130_fd_sc_hd__decap_3
XFILLER_69_561 VGND VGND VPWR VPWR sky130_fd_sc_hd__decap_3
XFILLER_29_414 VGND VGND VPWR VPWR sky130_fd_sc_hd__fill_1
XFILLER_9_1195 VGND VGND VPWR VPWR sky130_fd_sc_hd__decap_3
X_5158_ _6726_/Q _5318_/S VGND VGND VPWR VPWR _5158_/X sky130_fd_sc_hd__or2_2
XFILLER_5_1037 VGND VGND VPWR VPWR sky130_fd_sc_hd__decap_3
XFILLER_29_447 VGND VGND VPWR VPWR sky130_fd_sc_hd__fill_1
XFILLER_29_458 VGND VGND VPWR VPWR sky130_fd_sc_hd__decap_3
X_4109_ _6472_/Q _4108_/B _4108_/Y _3098_/A VGND VGND VPWR VPWR _4109_/X sky130_fd_sc_hd__a211o_2
XFILLER_57_767 VGND VGND VPWR VPWR sky130_fd_sc_hd__decap_3
X_5089_ _6402_/Q _5276_/B VGND VGND VPWR VPWR _5091_/B sky130_fd_sc_hd__xor2_2
XFILLER_44_417 VGND VGND VPWR VPWR sky130_fd_sc_hd__decap_3
XFILLER_77_1331 VGND VGND VPWR VPWR sky130_fd_sc_hd__decap_3
XFILLER_25_620 VGND VGND VPWR VPWR sky130_fd_sc_hd__decap_3
XFILLER_72_15 VGND VGND VPWR VPWR sky130_fd_sc_hd__decap_3
XFILLER_38_1315 VGND VGND VPWR VPWR sky130_fd_sc_hd__fill_1
XFILLER_53_962 VGND VGND VPWR VPWR sky130_fd_sc_hd__decap_3
XFILLER_77_1375 VGND VGND VPWR VPWR sky130_fd_sc_hd__decap_3
XFILLER_38_1326 VGND VGND VPWR VPWR sky130_fd_sc_hd__decap_3
XFILLER_13_815 VGND VGND VPWR VPWR sky130_fd_sc_hd__decap_3
XFILLER_73_1228 VGND VGND VPWR VPWR sky130_fd_sc_hd__decap_3
XFILLER_72_59 VGND VGND VPWR VPWR sky130_fd_sc_hd__decap_3
XFILLER_53_995 VGND VGND VPWR VPWR sky130_fd_sc_hd__fill_1
XFILLER_80_781 VGND VGND VPWR VPWR sky130_fd_sc_hd__decap_3
XFILLER_73_1239 VGND VGND VPWR VPWR sky130_fd_sc_hd__decap_3
XTAP_TAPCELL_ROW_23_810 VGND VPWR sky130_fd_sc_hd__tapvpwrvgnd_1
XFILLER_24_163 VGND VGND VPWR VPWR sky130_fd_sc_hd__decap_3
XFILLER_38_1359 VGND VGND VPWR VPWR sky130_fd_sc_hd__decap_3
XANTENNA_70 _5107_/A VGND VGND VPWR VPWR sky130_fd_sc_hd__diode_2
XANTENNA_81 fanout848/X VGND VGND VPWR VPWR sky130_fd_sc_hd__diode_2
XFILLER_10_1223 VGND VGND VPWR VPWR sky130_fd_sc_hd__decap_3
XFILLER_4_524 VGND VGND VPWR VPWR sky130_fd_sc_hd__decap_3
XFILLER_21_63 VGND VGND VPWR VPWR sky130_fd_sc_hd__decap_3
XFILLER_10_1256 VGND VGND VPWR VPWR sky130_fd_sc_hd__decap_3
XFILLER_49_1422 VGND VGND VPWR VPWR sky130_fd_sc_hd__decap_3
XFILLER_4_557 VGND VGND VPWR VPWR sky130_fd_sc_hd__decap_3
XFILLER_10_1267 VGND VGND VPWR VPWR sky130_fd_sc_hd__decap_3
XFILLER_49_1455 VGND VGND VPWR VPWR sky130_fd_sc_hd__fill_1
XFILLER_49_1466 VGND VGND VPWR VPWR sky130_fd_sc_hd__decap_3
XTAP_TAPCELL_ROW_56_1645 VGND VPWR sky130_fd_sc_hd__tapvpwrvgnd_1
XTAP_TAPCELL_ROW_56_1656 VGND VPWR sky130_fd_sc_hd__tapvpwrvgnd_1
XTAP_TAPCELL_ROW_56_1667 VGND VPWR sky130_fd_sc_hd__tapvpwrvgnd_1
XFILLER_79_325 VGND VGND VPWR VPWR sky130_fd_sc_hd__decap_3
XFILLER_45_1319 VGND VGND VPWR VPWR sky130_fd_sc_hd__decap_3
XFILLER_0_741 VGND VGND VPWR VPWR sky130_fd_sc_hd__decap_3
XTAP_TAPCELL_ROW_7_373 VGND VPWR sky130_fd_sc_hd__tapvpwrvgnd_1
XFILLER_0_763 VGND VGND VPWR VPWR sky130_fd_sc_hd__decap_3
XFILLER_48_701 VGND VGND VPWR VPWR sky130_fd_sc_hd__decap_3
XTAP_TAPCELL_ROW_7_384 VGND VPWR sky130_fd_sc_hd__tapvpwrvgnd_1
XTAP_TAPCELL_ROW_7_395 VGND VPWR sky130_fd_sc_hd__tapvpwrvgnd_1
XFILLER_0_785 VGND VGND VPWR VPWR sky130_fd_sc_hd__decap_3
XFILLER_43_1043 VGND VGND VPWR VPWR sky130_fd_sc_hd__decap_3
XFILLER_75_520 VGND VGND VPWR VPWR sky130_fd_sc_hd__decap_3
XFILLER_47_222 VGND VGND VPWR VPWR sky130_fd_sc_hd__fill_2
XFILLER_43_1076 VGND VGND VPWR VPWR sky130_fd_sc_hd__decap_3
XFILLER_36_907 VGND VGND VPWR VPWR sky130_fd_sc_hd__decap_3
XFILLER_75_553 VGND VGND VPWR VPWR sky130_fd_sc_hd__decap_3
XFILLER_75_564 VGND VGND VPWR VPWR sky130_fd_sc_hd__fill_2
XFILLER_78_1117 VGND VGND VPWR VPWR sky130_fd_sc_hd__decap_3
XFILLER_1_1413 VGND VGND VPWR VPWR sky130_fd_sc_hd__decap_3
XFILLER_75_597 VGND VGND VPWR VPWR sky130_fd_sc_hd__fill_2
XFILLER_21_1363 VGND VGND VPWR VPWR sky130_fd_sc_hd__decap_3
XFILLER_1_1446 VGND VGND VPWR VPWR sky130_fd_sc_hd__decap_3
XFILLER_1_1457 VGND VGND VPWR VPWR sky130_fd_sc_hd__decap_3
XFILLER_21_1396 VGND VGND VPWR VPWR sky130_fd_sc_hd__decap_3
XTAP_TAPCELL_ROW_18_659 VGND VPWR sky130_fd_sc_hd__tapvpwrvgnd_1
XFILLER_16_653 VGND VGND VPWR VPWR sky130_fd_sc_hd__fill_1
Xmax_cap83 _5913_/S VGND VGND VPWR VPWR _5914_/S sky130_fd_sc_hd__buf_6
XFILLER_56_1415 VGND VGND VPWR VPWR sky130_fd_sc_hd__decap_3
XFILLER_44_973 VGND VGND VPWR VPWR sky130_fd_sc_hd__decap_3
Xmax_cap94 _4444_/Y VGND VGND VPWR VPWR _4586_/D sky130_fd_sc_hd__buf_2
XFILLER_16_675 VGND VGND VPWR VPWR sky130_fd_sc_hd__decap_3
XFILLER_44_984 VGND VGND VPWR VPWR sky130_fd_sc_hd__decap_3
XFILLER_43_472 VGND VGND VPWR VPWR sky130_fd_sc_hd__fill_2
XFILLER_30_100 VGND VGND VPWR VPWR sky130_fd_sc_hd__decap_3
XFILLER_56_1459 VGND VGND VPWR VPWR sky130_fd_sc_hd__decap_3
XFILLER_15_185 VGND VGND VPWR VPWR sky130_fd_sc_hd__decap_3
XFILLER_30_144 VGND VGND VPWR VPWR sky130_fd_sc_hd__decap_3
XFILLER_19_1281 VGND VGND VPWR VPWR sky130_fd_sc_hd__decap_3
XFILLER_62_81 VGND VGND VPWR VPWR sky130_fd_sc_hd__decap_3
XFILLER_19_1292 VGND VGND VPWR VPWR sky130_fd_sc_hd__decap_3
XFILLER_7_21 VGND VGND VPWR VPWR sky130_fd_sc_hd__decap_3
XFILLER_11_1009 VGND VGND VPWR VPWR sky130_fd_sc_hd__decap_3
XFILLER_7_65 VGND VGND VPWR VPWR sky130_fd_sc_hd__decap_3
X_4460_ _4518_/A _4815_/B VGND VGND VPWR VPWR _4460_/Y sky130_fd_sc_hd__nor2_2
Xwire271 wire271/A VGND VGND VPWR VPWR _4541_/A sky130_fd_sc_hd__clkbuf_4
XFILLER_7_87 VGND VGND VPWR VPWR sky130_fd_sc_hd__decap_3
X_3411_ _6026_/A0 _3410_/X _3477_/S VGND VGND VPWR VPWR _6179_/D sky130_fd_sc_hd__mux2_1
X_4391_ _6299_/Q _4750_/A2 _3296_/X _4750_/B2 VGND VGND VPWR VPWR _4391_/X sky130_fd_sc_hd__a22o_2
X_6130_ clkload8/A _6130_/D load_slew637/X VGND VGND VPWR VPWR _6130_/Q sky130_fd_sc_hd__dfrtp_2
X_3342_ _6226_/Q _6402_/Q VGND VGND VPWR VPWR _3342_/X sky130_fd_sc_hd__xor2_2
Xfanout809 fanout817/X VGND VGND VPWR VPWR fanout809/X sky130_fd_sc_hd__clkdlybuf4s25_1
XFILLER_63_1419 VGND VGND VPWR VPWR sky130_fd_sc_hd__decap_3
Xload_slew210 _6001_/S VGND VGND VPWR VPWR _5998_/S sky130_fd_sc_hd__buf_4
Xload_slew221 _5997_/S VGND VGND VPWR VPWR _6058_/S sky130_fd_sc_hd__buf_4
X_6061_ hold995/X _7065_/Q _6061_/S VGND VGND VPWR VPWR _6061_/X sky130_fd_sc_hd__mux2_1
X_3273_ _3273_/A0 _3272_/X _3401_/S VGND VGND VPWR VPWR _6110_/D sky130_fd_sc_hd__mux2_1
XFILLER_61_1121 VGND VGND VPWR VPWR sky130_fd_sc_hd__decap_3
XFILLER_26_1241 VGND VGND VPWR VPWR sky130_fd_sc_hd__decap_3
Xhold1007 _6017_/X VGND VGND VPWR VPWR _7021_/D sky130_fd_sc_hd__dlygate4sd3_1
X_5012_ _6697_/Q _3063_/Y _5164_/B VGND VGND VPWR VPWR _5012_/X sky130_fd_sc_hd__mux2_1
XFILLER_6_1335 VGND VGND VPWR VPWR sky130_fd_sc_hd__decap_3
Xhold1018 _5981_/X VGND VGND VPWR VPWR _6985_/D sky130_fd_sc_hd__dlygate4sd3_1
XFILLER_38_200 VGND VGND VPWR VPWR sky130_fd_sc_hd__decap_3
Xhold1029 _7051_/Q VGND VGND VPWR VPWR _6047_/A1 sky130_fd_sc_hd__dlygate4sd3_1
XFILLER_26_1285 VGND VGND VPWR VPWR sky130_fd_sc_hd__decap_3
XFILLER_39_745 VGND VGND VPWR VPWR sky130_fd_sc_hd__fill_2
XFILLER_6_1368 VGND VGND VPWR VPWR sky130_fd_sc_hd__decap_3
XFILLER_38_233 VGND VGND VPWR VPWR sky130_fd_sc_hd__fill_2
XFILLER_6_1379 VGND VGND VPWR VPWR sky130_fd_sc_hd__decap_3
XFILLER_22_1149 VGND VGND VPWR VPWR sky130_fd_sc_hd__decap_3
XFILLER_27_918 VGND VGND VPWR VPWR sky130_fd_sc_hd__decap_3
XFILLER_66_575 VGND VGND VPWR VPWR sky130_fd_sc_hd__decap_3
XFILLER_26_439 VGND VGND VPWR VPWR sky130_fd_sc_hd__decap_3
XFILLER_53_225 VGND VGND VPWR VPWR sky130_fd_sc_hd__decap_3
X_6963_ _7027_/CLK _6963_/D load_slew845/X VGND VGND VPWR VPWR _6963_/Q sky130_fd_sc_hd__dfrtp_2
XFILLER_35_940 VGND VGND VPWR VPWR sky130_fd_sc_hd__decap_3
XFILLER_35_962 VGND VGND VPWR VPWR sky130_fd_sc_hd__decap_3
X_5914_ _5923_/A1 _5914_/A1 _5914_/S VGND VGND VPWR VPWR _6921_/D sky130_fd_sc_hd__mux2_1
X_6894_ _6926_/CLK _6894_/D fanout755/X VGND VGND VPWR VPWR _6894_/Q sky130_fd_sc_hd__dfrtp_2
XFILLER_62_770 VGND VGND VPWR VPWR sky130_fd_sc_hd__decap_3
X_5845_ _5845_/A0 _5793_/C _5845_/S VGND VGND VPWR VPWR _6861_/D sky130_fd_sc_hd__mux2_1
XFILLER_42_18 VGND VGND VPWR VPWR sky130_fd_sc_hd__fill_1
XFILLER_22_656 VGND VGND VPWR VPWR sky130_fd_sc_hd__fill_2
XFILLER_50_965 VGND VGND VPWR VPWR sky130_fd_sc_hd__decap_3
XFILLER_72_1250 VGND VGND VPWR VPWR sky130_fd_sc_hd__decap_3
XFILLER_72_1261 VGND VGND VPWR VPWR sky130_fd_sc_hd__decap_3
XFILLER_37_1381 VGND VGND VPWR VPWR sky130_fd_sc_hd__decap_3
XFILLER_21_166 VGND VGND VPWR VPWR sky130_fd_sc_hd__fill_2
X_5776_ _5776_/A0 _5899_/A0 _5782_/S VGND VGND VPWR VPWR _6811_/D sky130_fd_sc_hd__mux2_1
XFILLER_72_1294 VGND VGND VPWR VPWR sky130_fd_sc_hd__decap_3
XFILLER_33_1245 VGND VGND VPWR VPWR sky130_fd_sc_hd__decap_3
X_4727_ _4769_/B1 _4724_/X _4725_/Y _4726_/X _4597_/A VGND VGND VPWR VPWR _4727_/X
+ sky130_fd_sc_hd__o221a_2
XFILLER_33_1278 VGND VGND VPWR VPWR sky130_fd_sc_hd__decap_3
XFILLER_33_1289 VGND VGND VPWR VPWR sky130_fd_sc_hd__decap_3
X_4658_ _4344_/B _6551_/Q _4658_/S VGND VGND VPWR VPWR _4658_/X sky130_fd_sc_hd__mux2_1
X_3609_ _3644_/B _3644_/C _3636_/A VGND VGND VPWR VPWR _3665_/A sky130_fd_sc_hd__a21o_2
XFILLER_1_505 VGND VGND VPWR VPWR sky130_fd_sc_hd__decap_3
X_4589_ _4564_/B _4163_/B _4588_/Y _4756_/A1 VGND VGND VPWR VPWR _4589_/Y sky130_fd_sc_hd__o211ai_2
Xhold863 _5965_/X VGND VGND VPWR VPWR _6969_/D sky130_fd_sc_hd__dlygate4sd3_1
XFILLER_66_1043 VGND VGND VPWR VPWR sky130_fd_sc_hd__decap_3
Xhold874 _7078_/Q VGND VGND VPWR VPWR hold874/X sky130_fd_sc_hd__dlygate4sd3_1
X_6328_ _6986_/CLK _6328_/D wire652/X VGND VGND VPWR VPWR _6328_/Q sky130_fd_sc_hd__dfrtp_2
Xhold885 _6733_/Q VGND VGND VPWR VPWR hold885/X sky130_fd_sc_hd__dlygate4sd3_1
Xhold896 _6178_/Q VGND VGND VPWR VPWR hold896/X sky130_fd_sc_hd__dlygate4sd3_1
XFILLER_67_15 VGND VGND VPWR VPWR sky130_fd_sc_hd__decap_3
X_6259_ _7016_/CLK _6259_/D load_slew662/X VGND VGND VPWR VPWR _6259_/Q sky130_fd_sc_hd__dfrtp_2
XFILLER_44_1341 VGND VGND VPWR VPWR sky130_fd_sc_hd__decap_3
XTAP_TAPCELL_ROW_51_1520 VGND VPWR sky130_fd_sc_hd__tapvpwrvgnd_1
XFILLER_67_48 VGND VGND VPWR VPWR sky130_fd_sc_hd__decap_3
XTAP_TAPCELL_ROW_4_310 VGND VPWR sky130_fd_sc_hd__tapvpwrvgnd_1
XTAP_TAPCELL_ROW_51_1531 VGND VPWR sky130_fd_sc_hd__tapvpwrvgnd_1
XFILLER_40_1205 VGND VGND VPWR VPWR sky130_fd_sc_hd__fill_1
XFILLER_57_520 VGND VGND VPWR VPWR sky130_fd_sc_hd__fill_1
XFILLER_69_380 VGND VGND VPWR VPWR sky130_fd_sc_hd__decap_3
Xhold1530 _6646_/Q VGND VGND VPWR VPWR _5563_/B1 sky130_fd_sc_hd__dlygate4sd3_1
XFILLER_44_1385 VGND VGND VPWR VPWR sky130_fd_sc_hd__decap_3
XFILLER_79_1404 VGND VGND VPWR VPWR sky130_fd_sc_hd__decap_3
Xhold1541 _6676_/Q VGND VGND VPWR VPWR _5605_/B2 sky130_fd_sc_hd__dlygate4sd3_1
Xhold1552 _7110_/A VGND VGND VPWR VPWR _3482_/A2 sky130_fd_sc_hd__dlygate4sd3_1
XFILLER_18_918 VGND VGND VPWR VPWR sky130_fd_sc_hd__decap_3
Xhold1563 _6651_/Q VGND VGND VPWR VPWR _5573_/A1 sky130_fd_sc_hd__dlygate4sd3_1
XFILLER_40_1249 VGND VGND VPWR VPWR sky130_fd_sc_hd__decap_3
XFILLER_57_564 VGND VGND VPWR VPWR sky130_fd_sc_hd__decap_3
XFILLER_79_1437 VGND VGND VPWR VPWR sky130_fd_sc_hd__decap_3
XFILLER_17_406 VGND VGND VPWR VPWR sky130_fd_sc_hd__decap_3
Xhold1574 _7086_/Q VGND VGND VPWR VPWR _3097_/A sky130_fd_sc_hd__dlygate4sd3_1
XFILLER_29_277 VGND VGND VPWR VPWR sky130_fd_sc_hd__decap_3
XFILLER_44_203 VGND VGND VPWR VPWR sky130_fd_sc_hd__decap_3
XTAP_TAPCELL_ROW_28_924 VGND VPWR sky130_fd_sc_hd__tapvpwrvgnd_1
XTAP_TAPCELL_ROW_28_935 VGND VPWR sky130_fd_sc_hd__tapvpwrvgnd_1
XFILLER_72_545 VGND VGND VPWR VPWR sky130_fd_sc_hd__decap_3
XFILLER_72_578 VGND VGND VPWR VPWR sky130_fd_sc_hd__decap_3
XTAP_TAPCELL_ROW_49_1471 VGND VPWR sky130_fd_sc_hd__tapvpwrvgnd_1
XFILLER_60_729 VGND VGND VPWR VPWR sky130_fd_sc_hd__decap_3
XFILLER_77_1172 VGND VGND VPWR VPWR sky130_fd_sc_hd__decap_3
XFILLER_72_589 VGND VGND VPWR VPWR sky130_fd_sc_hd__decap_3
XTAP_TAPCELL_ROW_49_1482 VGND VPWR sky130_fd_sc_hd__tapvpwrvgnd_1
XFILLER_77_1183 VGND VGND VPWR VPWR sky130_fd_sc_hd__decap_3
XFILLER_73_1014 VGND VGND VPWR VPWR sky130_fd_sc_hd__fill_1
XFILLER_13_612 VGND VGND VPWR VPWR sky130_fd_sc_hd__decap_3
XFILLER_16_85 VGND VGND VPWR VPWR sky130_fd_sc_hd__decap_3
XPHY_EDGE_ROW_11_Right_11 VGND VGND VPWR VPWR sky130_fd_sc_hd__decap_3
XFILLER_41_943 VGND VGND VPWR VPWR sky130_fd_sc_hd__decap_3
XFILLER_38_1178 VGND VGND VPWR VPWR sky130_fd_sc_hd__decap_3
XFILLER_40_442 VGND VGND VPWR VPWR sky130_fd_sc_hd__decap_3
XTAP_TAPCELL_ROW_45_1368 VGND VPWR sky130_fd_sc_hd__tapvpwrvgnd_1
XFILLER_13_667 VGND VGND VPWR VPWR sky130_fd_sc_hd__decap_3
XFILLER_12_144 VGND VGND VPWR VPWR sky130_fd_sc_hd__decap_3
XFILLER_16_1421 VGND VGND VPWR VPWR sky130_fd_sc_hd__decap_3
XTAP_TAPCELL_ROW_45_1379 VGND VPWR sky130_fd_sc_hd__tapvpwrvgnd_1
XFILLER_51_1301 VGND VGND VPWR VPWR sky130_fd_sc_hd__decap_3
XFILLER_16_1432 VGND VGND VPWR VPWR sky130_fd_sc_hd__decap_3
XFILLER_40_475 VGND VGND VPWR VPWR sky130_fd_sc_hd__fill_1
XFILLER_32_40 VGND VGND VPWR VPWR sky130_fd_sc_hd__fill_1
XFILLER_51_1334 VGND VGND VPWR VPWR sky130_fd_sc_hd__decap_3
XFILLER_12_188 VGND VGND VPWR VPWR sky130_fd_sc_hd__decap_3
XFILLER_16_1465 VGND VGND VPWR VPWR sky130_fd_sc_hd__decap_3
XFILLER_51_1345 VGND VGND VPWR VPWR sky130_fd_sc_hd__decap_3
XFILLER_12_1329 VGND VGND VPWR VPWR sky130_fd_sc_hd__decap_3
XFILLER_51_1378 VGND VGND VPWR VPWR sky130_fd_sc_hd__decap_3
XTAP_TAPCELL_ROW_58_1707 VGND VPWR sky130_fd_sc_hd__tapvpwrvgnd_1
XTAP_TAPCELL_ROW_58_1718 VGND VPWR sky130_fd_sc_hd__tapvpwrvgnd_1
XFILLER_5_844 VGND VGND VPWR VPWR sky130_fd_sc_hd__decap_3
XFILLER_4_354 VGND VGND VPWR VPWR sky130_fd_sc_hd__decap_3
XFILLER_79_100 VGND VGND VPWR VPWR sky130_fd_sc_hd__decap_3
XPHY_EDGE_ROW_20_Right_20 VGND VGND VPWR VPWR sky130_fd_sc_hd__decap_3
XFILLER_49_1263 VGND VGND VPWR VPWR sky130_fd_sc_hd__decap_3
XFILLER_45_1149 VGND VGND VPWR VPWR sky130_fd_sc_hd__decap_3
XFILLER_79_166 VGND VGND VPWR VPWR sky130_fd_sc_hd__fill_2
XFILLER_62_1441 VGND VGND VPWR VPWR sky130_fd_sc_hd__decap_3
XFILLER_0_582 VGND VGND VPWR VPWR sky130_fd_sc_hd__decap_3
XFILLER_23_1425 VGND VGND VPWR VPWR sky130_fd_sc_hd__decap_3
XFILLER_48_542 VGND VGND VPWR VPWR sky130_fd_sc_hd__decap_3
XFILLER_48_553 VGND VGND VPWR VPWR sky130_fd_sc_hd__decap_3
XFILLER_36_704 VGND VGND VPWR VPWR sky130_fd_sc_hd__decap_3
XFILLER_48_564 VGND VGND VPWR VPWR sky130_fd_sc_hd__decap_3
XFILLER_57_81 VGND VGND VPWR VPWR sky130_fd_sc_hd__decap_3
XFILLER_63_501 VGND VGND VPWR VPWR sky130_fd_sc_hd__decap_3
XFILLER_1_1210 VGND VGND VPWR VPWR sky130_fd_sc_hd__decap_3
XFILLER_36_748 VGND VGND VPWR VPWR sky130_fd_sc_hd__decap_3
XFILLER_63_523 VGND VGND VPWR VPWR sky130_fd_sc_hd__decap_3
XFILLER_5_1390 VGND VGND VPWR VPWR sky130_fd_sc_hd__decap_3
XFILLER_35_225 VGND VGND VPWR VPWR sky130_fd_sc_hd__decap_3
XFILLER_1_1254 VGND VGND VPWR VPWR sky130_fd_sc_hd__decap_3
XFILLER_35_258 VGND VGND VPWR VPWR sky130_fd_sc_hd__decap_3
XFILLER_17_962 VGND VGND VPWR VPWR sky130_fd_sc_hd__decap_3
XFILLER_32_910 VGND VGND VPWR VPWR sky130_fd_sc_hd__decap_3
X_3960_ _3960_/A _3960_/B VGND VGND VPWR VPWR _3960_/Y sky130_fd_sc_hd__nand2_2
XFILLER_1_1287 VGND VGND VPWR VPWR sky130_fd_sc_hd__fill_1
XFILLER_16_461 VGND VGND VPWR VPWR sky130_fd_sc_hd__decap_3
XFILLER_44_770 VGND VGND VPWR VPWR sky130_fd_sc_hd__decap_3
XFILLER_1_1298 VGND VGND VPWR VPWR sky130_fd_sc_hd__decap_3
XFILLER_16_483 VGND VGND VPWR VPWR sky130_fd_sc_hd__decap_3
XFILLER_56_1256 VGND VGND VPWR VPWR sky130_fd_sc_hd__decap_3
X_3891_ _4010_/A _6236_/Q VGND VGND VPWR VPWR _3891_/X sky130_fd_sc_hd__and2b_2
XFILLER_56_1267 VGND VGND VPWR VPWR sky130_fd_sc_hd__decap_3
XFILLER_17_1229 VGND VGND VPWR VPWR sky130_fd_sc_hd__decap_3
XFILLER_32_987 VGND VGND VPWR VPWR sky130_fd_sc_hd__fill_2
X_5630_ _7066_/Q _5722_/A _5740_/C _5685_/C VGND VGND VPWR VPWR wire93/A sky130_fd_sc_hd__or4b_2
XFILLER_32_998 VGND VGND VPWR VPWR sky130_fd_sc_hd__decap_3
XFILLER_31_497 VGND VGND VPWR VPWR sky130_fd_sc_hd__decap_3
X_5561_ _6362_/Q _5566_/A2 hold873/X _5567_/B VGND VGND VPWR VPWR _6644_/D sky130_fd_sc_hd__a22o_2
XFILLER_30_1418 VGND VGND VPWR VPWR sky130_fd_sc_hd__decap_3
XFILLER_30_1429 VGND VGND VPWR VPWR sky130_fd_sc_hd__decap_3
X_4512_ _6523_/Q _4534_/B _4888_/C1 VGND VGND VPWR VPWR _4512_/X sky130_fd_sc_hd__a21bo_2
X_5492_ _6600_/Q _5488_/X _5492_/B1 VGND VGND VPWR VPWR _5492_/Y sky130_fd_sc_hd__a21oi_2
X_4443_ _6281_/Q _4745_/A2 _4440_/X _4442_/X VGND VGND VPWR VPWR _6281_/D sky130_fd_sc_hd__o22a_2
XFILLER_28_1303 VGND VGND VPWR VPWR sky130_fd_sc_hd__decap_3
X_4374_ _6297_/Q _4765_/A2 _3292_/X _4743_/B2 VGND VGND VPWR VPWR _4374_/X sky130_fd_sc_hd__a22o_2
XFILLER_67_1363 VGND VGND VPWR VPWR sky130_fd_sc_hd__decap_3
Xfanout606 input8/X VGND VGND VPWR VPWR _5931_/A0 sky130_fd_sc_hd__clkdlybuf4s25_1
Xfanout617 input6/X VGND VGND VPWR VPWR _5929_/A0 sky130_fd_sc_hd__clkdlybuf4s25_1
XFILLER_28_1347 VGND VGND VPWR VPWR sky130_fd_sc_hd__decap_3
XFILLER_63_1227 VGND VGND VPWR VPWR sky130_fd_sc_hd__decap_3
X_3325_ _5983_/A0 _3324_/X _3453_/S VGND VGND VPWR VPWR _6136_/D sky130_fd_sc_hd__mux2_1
X_6113_ _7036_/CLK _6113_/D load_slew840/X VGND VGND VPWR VPWR _6113_/Q sky130_fd_sc_hd__dfrtp_2
XFILLER_67_1396 VGND VGND VPWR VPWR sky130_fd_sc_hd__decap_3
X_7093_ _7096_/CLK _7093_/D load_slew679/X VGND VGND VPWR VPWR _7093_/Q sky130_fd_sc_hd__dfrtp_2
Xfanout628 _5917_/A1 VGND VGND VPWR VPWR _5908_/A0 sky130_fd_sc_hd__clkdlybuf4s25_1
XFILLER_59_829 VGND VGND VPWR VPWR sky130_fd_sc_hd__decap_3
X_6044_ hold921/X _7048_/Q _6044_/S VGND VGND VPWR VPWR _6044_/X sky130_fd_sc_hd__mux2_1
X_3256_ _6263_/Q _6359_/Q VGND VGND VPWR VPWR _3256_/X sky130_fd_sc_hd__xor2_2
XFILLER_6_1132 VGND VGND VPWR VPWR sky130_fd_sc_hd__decap_3
XFILLER_26_1082 VGND VGND VPWR VPWR sky130_fd_sc_hd__decap_3
XFILLER_26_1093 VGND VGND VPWR VPWR sky130_fd_sc_hd__decap_3
XFILLER_39_553 VGND VGND VPWR VPWR sky130_fd_sc_hd__decap_3
XFILLER_73_309 VGND VGND VPWR VPWR sky130_fd_sc_hd__decap_3
XFILLER_6_1176 VGND VGND VPWR VPWR sky130_fd_sc_hd__decap_3
X_3187_ _6943_/Q _3136_/A _3193_/A1 _3186_/X _3223_/C1 VGND VGND VPWR VPWR _3187_/X
+ sky130_fd_sc_hd__a221o_2
XFILLER_2_1029 VGND VGND VPWR VPWR sky130_fd_sc_hd__decap_3
XFILLER_26_203 VGND VGND VPWR VPWR sky130_fd_sc_hd__decap_3
XFILLER_54_512 VGND VGND VPWR VPWR sky130_fd_sc_hd__decap_3
XFILLER_54_523 VGND VGND VPWR VPWR sky130_fd_sc_hd__fill_1
XFILLER_27_748 VGND VGND VPWR VPWR sky130_fd_sc_hd__fill_2
XFILLER_39_1410 VGND VGND VPWR VPWR sky130_fd_sc_hd__decap_3
XFILLER_54_578 VGND VGND VPWR VPWR sky130_fd_sc_hd__fill_1
XFILLER_74_1312 VGND VGND VPWR VPWR sky130_fd_sc_hd__decap_3
X_6946_ _6954_/CLK _6946_/D load_slew650/X VGND VGND VPWR VPWR _6946_/Q sky130_fd_sc_hd__dfrtp_2
XFILLER_54_589 VGND VGND VPWR VPWR sky130_fd_sc_hd__decap_3
XFILLER_74_1323 VGND VGND VPWR VPWR sky130_fd_sc_hd__decap_3
XFILLER_35_781 VGND VGND VPWR VPWR sky130_fd_sc_hd__decap_3
XFILLER_39_1443 VGND VGND VPWR VPWR sky130_fd_sc_hd__decap_3
XFILLER_23_932 VGND VGND VPWR VPWR sky130_fd_sc_hd__fill_2
XFILLER_74_1356 VGND VGND VPWR VPWR sky130_fd_sc_hd__decap_3
XFILLER_35_1307 VGND VGND VPWR VPWR sky130_fd_sc_hd__decap_3
XFILLER_50_740 VGND VGND VPWR VPWR sky130_fd_sc_hd__decap_3
X_6877_ _7040_/CLK _6877_/D fanout688/X VGND VGND VPWR VPWR _6877_/Q sky130_fd_sc_hd__dfrtp_2
XPHY_EDGE_ROW_14_Left_95 VGND VGND VPWR VPWR sky130_fd_sc_hd__decap_3
XFILLER_50_773 VGND VGND VPWR VPWR sky130_fd_sc_hd__decap_3
X_5828_ _5902_/A0 _5828_/A1 _5831_/S VGND VGND VPWR VPWR _6846_/D sky130_fd_sc_hd__mux2_1
XFILLER_10_626 VGND VGND VPWR VPWR sky130_fd_sc_hd__decap_3
XFILLER_10_648 VGND VGND VPWR VPWR sky130_fd_sc_hd__decap_3
XTAP_TAPCELL_ROW_40_1232 VGND VPWR sky130_fd_sc_hd__tapvpwrvgnd_1
X_5759_ _5889_/A0 _5759_/A1 _5766_/S VGND VGND VPWR VPWR _6802_/D sky130_fd_sc_hd__mux2_1
XFILLER_6_608 VGND VGND VPWR VPWR sky130_fd_sc_hd__decap_3
XFILLER_33_1053 VGND VGND VPWR VPWR sky130_fd_sc_hd__fill_1
XTAP_TAPCELL_ROW_40_1243 VGND VPWR sky130_fd_sc_hd__tapvpwrvgnd_1
XFILLER_11_1340 VGND VGND VPWR VPWR sky130_fd_sc_hd__decap_3
XFILLER_11_1351 VGND VGND VPWR VPWR sky130_fd_sc_hd__decap_3
XFILLER_2_803 VGND VGND VPWR VPWR sky130_fd_sc_hd__decap_3
XTAP_TAPCELL_ROW_9_424 VGND VPWR sky130_fd_sc_hd__tapvpwrvgnd_1
XFILLER_11_1384 VGND VGND VPWR VPWR sky130_fd_sc_hd__decap_3
XFILLER_2_825 VGND VGND VPWR VPWR sky130_fd_sc_hd__decap_3
XTAP_TAPCELL_ROW_9_435 VGND VPWR sky130_fd_sc_hd__tapvpwrvgnd_1
XFILLER_1_302 VGND VGND VPWR VPWR sky130_fd_sc_hd__decap_3
XFILLER_46_1403 VGND VGND VPWR VPWR sky130_fd_sc_hd__decap_3
XTAP_TAPCELL_ROW_9_446 VGND VPWR sky130_fd_sc_hd__tapvpwrvgnd_1
XFILLER_78_47 VGND VGND VPWR VPWR sky130_fd_sc_hd__decap_3
XFILLER_2_858 VGND VGND VPWR VPWR sky130_fd_sc_hd__decap_3
XFILLER_1_335 VGND VGND VPWR VPWR sky130_fd_sc_hd__fill_1
XFILLER_2_869 VGND VGND VPWR VPWR sky130_fd_sc_hd__decap_3
XFILLER_1_346 VGND VGND VPWR VPWR sky130_fd_sc_hd__decap_3
XFILLER_46_1447 VGND VGND VPWR VPWR sky130_fd_sc_hd__decap_3
XTAP_TAPCELL_ROW_38_1183 VGND VPWR sky130_fd_sc_hd__tapvpwrvgnd_1
XTAP_TAPCELL_ROW_38_1194 VGND VPWR sky130_fd_sc_hd__tapvpwrvgnd_1
XFILLER_1_379 VGND VGND VPWR VPWR sky130_fd_sc_hd__decap_3
XFILLER_44_1182 VGND VGND VPWR VPWR sky130_fd_sc_hd__decap_3
XFILLER_79_1201 VGND VGND VPWR VPWR sky130_fd_sc_hd__decap_3
XFILLER_40_1035 VGND VGND VPWR VPWR sky130_fd_sc_hd__fill_1
XFILLER_40_1046 VGND VGND VPWR VPWR sky130_fd_sc_hd__decap_3
XFILLER_57_361 VGND VGND VPWR VPWR sky130_fd_sc_hd__decap_3
Xhold1360 _6822_/Q VGND VGND VPWR VPWR _5796_/A1 sky130_fd_sc_hd__dlygate4sd3_1
Xhold1371 _6583_/Q VGND VGND VPWR VPWR _5471_/A1 sky130_fd_sc_hd__dlygate4sd3_1
XFILLER_79_1245 VGND VGND VPWR VPWR sky130_fd_sc_hd__decap_3
XFILLER_17_225 VGND VGND VPWR VPWR sky130_fd_sc_hd__decap_3
Xhold1382 _6825_/Q VGND VGND VPWR VPWR _5802_/A1 sky130_fd_sc_hd__dlygate4sd3_1
Xhold1393 _6559_/Q VGND VGND VPWR VPWR _5447_/A1 sky130_fd_sc_hd__dlygate4sd3_1
XFILLER_40_1079 VGND VGND VPWR VPWR sky130_fd_sc_hd__decap_3
XFILLER_79_1278 VGND VGND VPWR VPWR sky130_fd_sc_hd__decap_3
XTAP_TAPCELL_ROW_47_1419 VGND VPWR sky130_fd_sc_hd__tapvpwrvgnd_1
XFILLER_79_1289 VGND VGND VPWR VPWR sky130_fd_sc_hd__decap_3
XFILLER_45_578 VGND VGND VPWR VPWR sky130_fd_sc_hd__decap_3
XFILLER_33_729 VGND VGND VPWR VPWR sky130_fd_sc_hd__decap_3
XFILLER_26_792 VGND VGND VPWR VPWR sky130_fd_sc_hd__decap_3
XFILLER_13_431 VGND VGND VPWR VPWR sky130_fd_sc_hd__decap_3
XFILLER_53_1407 VGND VGND VPWR VPWR sky130_fd_sc_hd__decap_3
XFILLER_43_50 VGND VGND VPWR VPWR sky130_fd_sc_hd__decap_3
XFILLER_9_402 VGND VGND VPWR VPWR sky130_fd_sc_hd__decap_3
XFILLER_41_762 VGND VGND VPWR VPWR sky130_fd_sc_hd__decap_3
XFILLER_9_435 VGND VGND VPWR VPWR sky130_fd_sc_hd__decap_3
XFILLER_43_83 VGND VGND VPWR VPWR sky130_fd_sc_hd__decap_3
XFILLER_9_446 VGND VGND VPWR VPWR sky130_fd_sc_hd__fill_2
XFILLER_51_1142 VGND VGND VPWR VPWR sky130_fd_sc_hd__fill_1
XFILLER_71_9 VGND VGND VPWR VPWR sky130_fd_sc_hd__decap_3
XFILLER_16_1273 VGND VGND VPWR VPWR sky130_fd_sc_hd__decap_3
XFILLER_51_1164 VGND VGND VPWR VPWR sky130_fd_sc_hd__decap_3
XFILLER_12_1137 VGND VGND VPWR VPWR sky130_fd_sc_hd__decap_3
XFILLER_5_663 VGND VGND VPWR VPWR sky130_fd_sc_hd__decap_3
XFILLER_4_162 VGND VGND VPWR VPWR sky130_fd_sc_hd__decap_3
XFILLER_4_184 VGND VGND VPWR VPWR sky130_fd_sc_hd__decap_3
XFILLER_4_44 VGND VGND VPWR VPWR sky130_fd_sc_hd__decap_3
XFILLER_4_77 VGND VGND VPWR VPWR sky130_fd_sc_hd__decap_3
XFILLER_4_88 VGND VGND VPWR VPWR sky130_fd_sc_hd__decap_3
X_3110_ _6081_/A _6962_/Q _6970_/Q _6081_/B VGND VGND VPWR VPWR _3110_/X sky130_fd_sc_hd__a22o_2
XFILLER_1_880 VGND VGND VPWR VPWR sky130_fd_sc_hd__decap_3
XFILLER_68_80 VGND VGND VPWR VPWR sky130_fd_sc_hd__decap_3
XFILLER_67_125 VGND VGND VPWR VPWR sky130_fd_sc_hd__decap_3
X_4090_ _6597_/Q _4762_/B _4091_/A1 VGND VGND VPWR VPWR _4090_/X sky130_fd_sc_hd__a21bo_2
XFILLER_7_1452 VGND VGND VPWR VPWR sky130_fd_sc_hd__decap_3
XFILLER_7_1463 VGND VGND VPWR VPWR sky130_fd_sc_hd__decap_3
X_3041_ _4394_/A VGND VGND VPWR VPWR _3041_/Y sky130_fd_sc_hd__inv_2
XFILLER_23_1233 VGND VGND VPWR VPWR sky130_fd_sc_hd__decap_3
XFILLER_49_862 VGND VGND VPWR VPWR sky130_fd_sc_hd__decap_3
XFILLER_55_309 VGND VGND VPWR VPWR sky130_fd_sc_hd__fill_2
XFILLER_62_1282 VGND VGND VPWR VPWR sky130_fd_sc_hd__decap_3
XFILLER_3_1316 VGND VGND VPWR VPWR sky130_fd_sc_hd__decap_3
XFILLER_67_169 VGND VGND VPWR VPWR sky130_fd_sc_hd__decap_3
XFILLER_23_1266 VGND VGND VPWR VPWR sky130_fd_sc_hd__decap_3
XFILLER_36_512 VGND VGND VPWR VPWR sky130_fd_sc_hd__decap_3
XFILLER_36_556 VGND VGND VPWR VPWR sky130_fd_sc_hd__decap_3
X_6800_ _7056_/CLK _6800_/D fanout699/A VGND VGND VPWR VPWR _6800_/Q sky130_fd_sc_hd__dfrtp_2
XFILLER_58_1329 VGND VGND VPWR VPWR sky130_fd_sc_hd__decap_3
XFILLER_1_1051 VGND VGND VPWR VPWR sky130_fd_sc_hd__decap_3
XFILLER_17_770 VGND VGND VPWR VPWR sky130_fd_sc_hd__decap_3
XFILLER_23_206 VGND VGND VPWR VPWR sky130_fd_sc_hd__decap_3
XFILLER_36_589 VGND VGND VPWR VPWR sky130_fd_sc_hd__decap_3
X_4992_ _6356_/Q _4991_/X _4992_/S VGND VGND VPWR VPWR _6356_/D sky130_fd_sc_hd__mux2_1
XFILLER_51_537 VGND VGND VPWR VPWR sky130_fd_sc_hd__decap_3
XFILLER_1_1095 VGND VGND VPWR VPWR sky130_fd_sc_hd__decap_3
X_6731_ _6988_/CLK _6731_/D fanout816/X VGND VGND VPWR VPWR _6731_/Q sky130_fd_sc_hd__dfrtp_2
X_3943_ _4347_/B _4181_/B VGND VGND VPWR VPWR _4250_/A sky130_fd_sc_hd__xnor2_2
XFILLER_51_559 VGND VGND VPWR VPWR sky130_fd_sc_hd__fill_1
XFILLER_17_1004 VGND VGND VPWR VPWR sky130_fd_sc_hd__decap_3
XTAP_TAPCELL_ROW_80_2280 VGND VPWR sky130_fd_sc_hd__tapvpwrvgnd_1
XFILLER_20_913 VGND VGND VPWR VPWR sky130_fd_sc_hd__decap_3
XTAP_TAPCELL_ROW_80_2291 VGND VPWR sky130_fd_sc_hd__tapvpwrvgnd_1
X_6662_ _6910_/CLK _6662_/D load_slew784/X VGND VGND VPWR VPWR _6662_/Q sky130_fd_sc_hd__dfrtp_2
X_3874_ _3874_/A _3874_/B VGND VGND VPWR VPWR _4083_/B sky130_fd_sc_hd__xnor2_2
XFILLER_32_795 VGND VGND VPWR VPWR sky130_fd_sc_hd__decap_3
X_5613_ _7110_/A _7091_/Q _7091_/D VGND VGND VPWR VPWR _6062_/B sky130_fd_sc_hd__or3b_2
X_6593_ _6807_/CLK _6593_/D fanout781/X VGND VGND VPWR VPWR _6593_/Q sky130_fd_sc_hd__dfrtp_2
XFILLER_20_979 VGND VGND VPWR VPWR sky130_fd_sc_hd__fill_1
XFILLER_34_1362 VGND VGND VPWR VPWR sky130_fd_sc_hd__decap_3
XFILLER_34_1373 VGND VGND VPWR VPWR sky130_fd_sc_hd__decap_3
XTAP_TAPCELL_ROW_30_974 VGND VPWR sky130_fd_sc_hd__tapvpwrvgnd_1
XFILLER_30_1226 VGND VGND VPWR VPWR sky130_fd_sc_hd__decap_3
XTAP_TAPCELL_ROW_30_985 VGND VPWR sky130_fd_sc_hd__tapvpwrvgnd_1
X_5544_ _6345_/Q _5564_/A2 _5544_/B1 _5552_/B2 VGND VGND VPWR VPWR _6627_/D sky130_fd_sc_hd__a22o_2
XFILLER_69_1425 VGND VGND VPWR VPWR sky130_fd_sc_hd__decap_3
XFILLER_30_1259 VGND VGND VPWR VPWR sky130_fd_sc_hd__fill_1
X_5475_ _5475_/A1 _5478_/A2 _4867_/X VGND VGND VPWR VPWR _6587_/D sky130_fd_sc_hd__a21o_2
X_4426_ _6849_/Q _4781_/A2 _4424_/X _4425_/X VGND VGND VPWR VPWR _4426_/X sky130_fd_sc_hd__a211o_2
XFILLER_63_1002 VGND VGND VPWR VPWR sky130_fd_sc_hd__decap_3
XFILLER_8_1205 VGND VGND VPWR VPWR sky130_fd_sc_hd__decap_3
Xfanout403 _4604_/A VGND VGND VPWR VPWR _4005_/C1 sky130_fd_sc_hd__clkdlybuf4s25_1
XFILLER_28_1144 VGND VGND VPWR VPWR sky130_fd_sc_hd__decap_3
Xfanout425 _3090_/X VGND VGND VPWR VPWR _3948_/B1 sky130_fd_sc_hd__clkdlybuf4s25_1
X_4357_ _4386_/A wire25/X _4586_/C VGND VGND VPWR VPWR _4358_/A sky130_fd_sc_hd__or3b_2
XFILLER_8_1238 VGND VGND VPWR VPWR sky130_fd_sc_hd__decap_3
Xfanout447 _3073_/Y VGND VGND VPWR VPWR _4010_/B sky130_fd_sc_hd__clkdlybuf4s25_1
Xfanout458 _4885_/B1 VGND VGND VPWR VPWR _4888_/C1 sky130_fd_sc_hd__clkdlybuf4s25_1
X_3308_ _6281_/Q _6385_/Q VGND VGND VPWR VPWR _3308_/X sky130_fd_sc_hd__xor2_2
XFILLER_28_1199 VGND VGND VPWR VPWR sky130_fd_sc_hd__decap_3
X_4288_ _6265_/Q _4622_/S _4285_/X _4287_/X VGND VGND VPWR VPWR _6265_/D sky130_fd_sc_hd__o22a_2
Xfanout469 _4779_/A1 VGND VGND VPWR VPWR _3098_/A sky130_fd_sc_hd__clkdlybuf4s25_1
X_7076_ _7076_/CLK _7076_/D load_slew681/X VGND VGND VPWR VPWR _7076_/Q sky130_fd_sc_hd__dfrtp_2
XFILLER_80_1360 VGND VGND VPWR VPWR sky130_fd_sc_hd__decap_3
XFILLER_41_1322 VGND VGND VPWR VPWR sky130_fd_sc_hd__decap_3
XFILLER_80_1382 VGND VGND VPWR VPWR sky130_fd_sc_hd__decap_3
X_3239_ _5940_/A0 _3238_/X _3355_/S VGND VGND VPWR VPWR _6093_/D sky130_fd_sc_hd__mux2_1
XFILLER_46_309 VGND VGND VPWR VPWR sky130_fd_sc_hd__decap_3
X_6027_ hold890/X hold972/X _6035_/S VGND VGND VPWR VPWR _7031_/D sky130_fd_sc_hd__mux2_1
XFILLER_41_1366 VGND VGND VPWR VPWR sky130_fd_sc_hd__decap_3
XFILLER_67_692 VGND VGND VPWR VPWR sky130_fd_sc_hd__decap_3
XFILLER_64_27 VGND VGND VPWR VPWR sky130_fd_sc_hd__fill_1
XFILLER_41_1399 VGND VGND VPWR VPWR sky130_fd_sc_hd__fill_1
XFILLER_64_38 VGND VGND VPWR VPWR sky130_fd_sc_hd__decap_3
XFILLER_76_1418 VGND VGND VPWR VPWR sky130_fd_sc_hd__decap_3
XFILLER_76_1429 VGND VGND VPWR VPWR sky130_fd_sc_hd__decap_3
XFILLER_15_729 VGND VGND VPWR VPWR sky130_fd_sc_hd__decap_3
XFILLER_27_589 VGND VGND VPWR VPWR sky130_fd_sc_hd__fill_1
XFILLER_54_375 VGND VGND VPWR VPWR sky130_fd_sc_hd__fill_1
XFILLER_42_526 VGND VGND VPWR VPWR sky130_fd_sc_hd__decap_3
XFILLER_74_1120 VGND VGND VPWR VPWR sky130_fd_sc_hd__decap_3
XFILLER_39_1251 VGND VGND VPWR VPWR sky130_fd_sc_hd__decap_3
X_6929_ _6929_/CLK _6929_/D wire712/X VGND VGND VPWR VPWR _6929_/Q sky130_fd_sc_hd__dfrtp_2
Xfanout21 _3830_/Y VGND VGND VPWR VPWR _5588_/A3 sky130_fd_sc_hd__clkdlybuf4s25_1
XFILLER_80_15 VGND VGND VPWR VPWR sky130_fd_sc_hd__decap_3
XFILLER_74_1164 VGND VGND VPWR VPWR sky130_fd_sc_hd__decap_3
Xfanout32 _4891_/B1 VGND VGND VPWR VPWR _4255_/B1 sky130_fd_sc_hd__clkdlybuf4s25_1
XFILLER_39_1284 VGND VGND VPWR VPWR sky130_fd_sc_hd__decap_3
XTAP_TAPCELL_ROW_42_1305 VGND VPWR sky130_fd_sc_hd__tapvpwrvgnd_1
XFILLER_70_1006 VGND VGND VPWR VPWR sky130_fd_sc_hd__fill_1
XFILLER_39_1295 VGND VGND VPWR VPWR sky130_fd_sc_hd__decap_3
XFILLER_74_1197 VGND VGND VPWR VPWR sky130_fd_sc_hd__decap_3
XFILLER_35_1148 VGND VGND VPWR VPWR sky130_fd_sc_hd__decap_3
Xfanout76 fanout78/A VGND VGND VPWR VPWR wire77/A sky130_fd_sc_hd__clkdlybuf4s25_1
XFILLER_11_946 VGND VGND VPWR VPWR sky130_fd_sc_hd__decap_3
XFILLER_13_1413 VGND VGND VPWR VPWR sky130_fd_sc_hd__decap_3
XFILLER_52_1462 VGND VGND VPWR VPWR sky130_fd_sc_hd__decap_3
XFILLER_6_416 VGND VGND VPWR VPWR sky130_fd_sc_hd__decap_3
XFILLER_6_427 VGND VGND VPWR VPWR sky130_fd_sc_hd__fill_1
XFILLER_13_1446 VGND VGND VPWR VPWR sky130_fd_sc_hd__decap_3
XFILLER_13_1457 VGND VGND VPWR VPWR sky130_fd_sc_hd__decap_3
XFILLER_6_449 VGND VGND VPWR VPWR sky130_fd_sc_hd__decap_3
XFILLER_2_622 VGND VGND VPWR VPWR sky130_fd_sc_hd__fill_2
XFILLER_11_1192 VGND VGND VPWR VPWR sky130_fd_sc_hd__decap_3
XFILLER_1_143 VGND VGND VPWR VPWR sky130_fd_sc_hd__decap_3
XFILLER_2_666 VGND VGND VPWR VPWR sky130_fd_sc_hd__decap_3
XFILLER_46_1244 VGND VGND VPWR VPWR sky130_fd_sc_hd__decap_3
XFILLER_2_699 VGND VGND VPWR VPWR sky130_fd_sc_hd__fill_1
XFILLER_1_187 VGND VGND VPWR VPWR sky130_fd_sc_hd__decap_3
XFILLER_46_1288 VGND VGND VPWR VPWR sky130_fd_sc_hd__decap_3
XFILLER_65_607 VGND VGND VPWR VPWR sky130_fd_sc_hd__fill_1
XFILLER_38_50 VGND VGND VPWR VPWR sky130_fd_sc_hd__decap_3
XFILLER_49_169 VGND VGND VPWR VPWR sky130_fd_sc_hd__decap_3
XFILLER_18_501 VGND VGND VPWR VPWR sky130_fd_sc_hd__fill_1
XFILLER_20_1406 VGND VGND VPWR VPWR sky130_fd_sc_hd__decap_3
XFILLER_38_83 VGND VGND VPWR VPWR sky130_fd_sc_hd__fill_1
XFILLER_58_692 VGND VGND VPWR VPWR sky130_fd_sc_hd__decap_3
XFILLER_64_128 VGND VGND VPWR VPWR sky130_fd_sc_hd__decap_3
Xhold1190 _6881_/Q VGND VGND VPWR VPWR _5867_/A0 sky130_fd_sc_hd__dlygate4sd3_1
XFILLER_73_673 VGND VGND VPWR VPWR sky130_fd_sc_hd__decap_3
XFILLER_72_150 VGND VGND VPWR VPWR sky130_fd_sc_hd__decap_3
XFILLER_2_1371 VGND VGND VPWR VPWR sky130_fd_sc_hd__fill_1
XFILLER_45_375 VGND VGND VPWR VPWR sky130_fd_sc_hd__fill_1
XFILLER_60_301 VGND VGND VPWR VPWR sky130_fd_sc_hd__decap_3
XFILLER_79_1097 VGND VGND VPWR VPWR sky130_fd_sc_hd__decap_3
XFILLER_2_1382 VGND VGND VPWR VPWR sky130_fd_sc_hd__decap_3
XFILLER_60_312 VGND VGND VPWR VPWR sky130_fd_sc_hd__decap_3
XFILLER_57_1340 VGND VGND VPWR VPWR sky130_fd_sc_hd__decap_3
XFILLER_57_1351 VGND VGND VPWR VPWR sky130_fd_sc_hd__decap_3
XFILLER_33_559 VGND VGND VPWR VPWR sky130_fd_sc_hd__fill_1
XFILLER_61_868 VGND VGND VPWR VPWR sky130_fd_sc_hd__decap_3
XFILLER_18_1335 VGND VGND VPWR VPWR sky130_fd_sc_hd__decap_3
XFILLER_57_1384 VGND VGND VPWR VPWR sky130_fd_sc_hd__decap_3
XFILLER_53_1248 VGND VGND VPWR VPWR sky130_fd_sc_hd__decap_3
XFILLER_18_1368 VGND VGND VPWR VPWR sky130_fd_sc_hd__decap_3
XFILLER_18_1379 VGND VGND VPWR VPWR sky130_fd_sc_hd__decap_3
XFILLER_9_243 VGND VGND VPWR VPWR sky130_fd_sc_hd__decap_3
XFILLER_16_1070 VGND VGND VPWR VPWR sky130_fd_sc_hd__decap_3
X_3590_ _3588_/B _3588_/C _3689_/A VGND VGND VPWR VPWR _3661_/B sky130_fd_sc_hd__a21o_2
Xclkload13 _6954_/CLK VGND VGND VPWR VPWR clkload13/X sky130_fd_sc_hd__clkbuf_4
Xclkload24 _7076_/CLK VGND VGND VPWR VPWR clkload24/Y sky130_fd_sc_hd__bufinv_16
Xclkload35 _7054_/CLK VGND VGND VPWR VPWR clkload35/X sky130_fd_sc_hd__clkbuf_4
XTAP_TAPCELL_ROW_11_484 VGND VPWR sky130_fd_sc_hd__tapvpwrvgnd_1
Xclkload46 _6991_/CLK VGND VGND VPWR VPWR clkload46/X sky130_fd_sc_hd__clkbuf_4
XTAP_TAPCELL_ROW_11_495 VGND VPWR sky130_fd_sc_hd__tapvpwrvgnd_1
Xclkload57 _7036_/CLK VGND VGND VPWR VPWR clkload57/X sky130_fd_sc_hd__clkbuf_8
X_5260_ _6428_/Q _5260_/A2 _5259_/X VGND VGND VPWR VPWR _6428_/D sky130_fd_sc_hd__a21o_2
XFILLER_5_482 VGND VGND VPWR VPWR sky130_fd_sc_hd__decap_3
XFILLER_48_3 VGND VGND VPWR VPWR sky130_fd_sc_hd__decap_3
XFILLER_64_1300 VGND VGND VPWR VPWR sky130_fd_sc_hd__decap_3
XFILLER_29_1431 VGND VGND VPWR VPWR sky130_fd_sc_hd__decap_3
X_4211_ _4211_/A _4211_/B VGND VGND VPWR VPWR _4624_/B sky130_fd_sc_hd__xnor2_2
X_5191_ _5190_/Y _5106_/X _5284_/A2 _6404_/Q VGND VGND VPWR VPWR _6404_/D sky130_fd_sc_hd__a2bb2o_2
XFILLER_64_1344 VGND VGND VPWR VPWR sky130_fd_sc_hd__decap_3
XFILLER_69_946 VGND VGND VPWR VPWR sky130_fd_sc_hd__fill_2
XFILLER_25_1328 VGND VGND VPWR VPWR sky130_fd_sc_hd__decap_3
X_4142_ _4222_/B _4221_/A VGND VGND VPWR VPWR _4143_/B sky130_fd_sc_hd__xor2_2
XFILLER_64_1388 VGND VGND VPWR VPWR sky130_fd_sc_hd__decap_3
XFILLER_28_309 VGND VGND VPWR VPWR sky130_fd_sc_hd__decap_3
XFILLER_7_1260 VGND VGND VPWR VPWR sky130_fd_sc_hd__decap_3
X_4073_ _3485_/B _4070_/X _4071_/Y _4072_/X _4734_/C1 VGND VGND VPWR VPWR _4073_/X
+ sky130_fd_sc_hd__o221a_2
XFILLER_49_670 VGND VGND VPWR VPWR sky130_fd_sc_hd__fill_2
XFILLER_3_1113 VGND VGND VPWR VPWR sky130_fd_sc_hd__decap_3
XFILLER_3_1124 VGND VGND VPWR VPWR sky130_fd_sc_hd__decap_3
XFILLER_3_1157 VGND VGND VPWR VPWR sky130_fd_sc_hd__decap_3
XFILLER_52_802 VGND VGND VPWR VPWR sky130_fd_sc_hd__decap_3
XFILLER_52_813 VGND VGND VPWR VPWR sky130_fd_sc_hd__decap_3
XFILLER_58_1126 VGND VGND VPWR VPWR sky130_fd_sc_hd__decap_3
XFILLER_75_1440 VGND VGND VPWR VPWR sky130_fd_sc_hd__decap_3
XFILLER_24_548 VGND VGND VPWR VPWR sky130_fd_sc_hd__decap_3
XFILLER_51_345 VGND VGND VPWR VPWR sky130_fd_sc_hd__fill_1
X_4975_ _6386_/Q _5228_/B _5031_/B1 VGND VGND VPWR VPWR _4975_/Y sky130_fd_sc_hd__a21oi_2
XFILLER_71_1304 VGND VGND VPWR VPWR sky130_fd_sc_hd__decap_3
XFILLER_36_1424 VGND VGND VPWR VPWR sky130_fd_sc_hd__decap_3
XFILLER_36_1435 VGND VGND VPWR VPWR sky130_fd_sc_hd__decap_3
X_6714_ _6752_/CLK _6714_/D load_slew669/X VGND VGND VPWR VPWR _6714_/Q sky130_fd_sc_hd__dfrtp_2
XFILLER_51_378 VGND VGND VPWR VPWR sky130_fd_sc_hd__decap_3
X_3926_ _6342_/Q _4887_/B _3924_/X _3925_/X VGND VGND VPWR VPWR _4347_/B sky130_fd_sc_hd__o22a_2
XFILLER_71_1337 VGND VGND VPWR VPWR sky130_fd_sc_hd__decap_3
XFILLER_71_1348 VGND VGND VPWR VPWR sky130_fd_sc_hd__decap_3
XFILLER_36_1468 VGND VGND VPWR VPWR sky130_fd_sc_hd__fill_1
XFILLER_32_592 VGND VGND VPWR VPWR sky130_fd_sc_hd__decap_3
Xclkload7 clkload7/A VGND VGND VPWR VPWR clkload7/X sky130_fd_sc_hd__clkbuf_4
X_6645_ _6882_/CLK _6645_/D load_slew662/X VGND VGND VPWR VPWR _6645_/Q sky130_fd_sc_hd__dfrtp_2
X_3857_ _4040_/A1 wire154/A _4312_/B _3089_/B _6500_/Q VGND VGND VPWR VPWR _3857_/X
+ sky130_fd_sc_hd__a32o_2
XFILLER_50_29 VGND VGND VPWR VPWR sky130_fd_sc_hd__decap_3
XFILLER_20_798 VGND VGND VPWR VPWR sky130_fd_sc_hd__fill_2
X_6576_ _6882_/CLK _6576_/D fanout663/X VGND VGND VPWR VPWR _6576_/Q sky130_fd_sc_hd__dfrtp_2
X_3788_ _3788_/A VGND VGND VPWR VPWR _3789_/C sky130_fd_sc_hd__inv_2
XFILLER_4_909 VGND VGND VPWR VPWR sky130_fd_sc_hd__decap_3
XFILLER_30_1045 VGND VGND VPWR VPWR sky130_fd_sc_hd__fill_1
XFILLER_69_1222 VGND VGND VPWR VPWR sky130_fd_sc_hd__decap_3
X_5527_ _7082_/Q _5525_/Y _5526_/X _5534_/B1 VGND VGND VPWR VPWR _5527_/X sky130_fd_sc_hd__a31o_2
XTAP_TAPCELL_ROW_76_2168 VGND VPWR sky130_fd_sc_hd__tapvpwrvgnd_1
XFILLER_3_408 VGND VGND VPWR VPWR sky130_fd_sc_hd__decap_3
XFILLER_69_1233 VGND VGND VPWR VPWR sky130_fd_sc_hd__decap_3
XTAP_TAPCELL_ROW_76_2179 VGND VPWR sky130_fd_sc_hd__tapvpwrvgnd_1
XFILLER_69_1266 VGND VGND VPWR VPWR sky130_fd_sc_hd__decap_3
X_5458_ _5458_/A1 _5461_/A2 _4742_/X VGND VGND VPWR VPWR _6570_/D sky130_fd_sc_hd__a21o_2
XFILLER_1_9 VGND VGND VPWR VPWR sky130_fd_sc_hd__decap_3
XFILLER_59_49 VGND VGND VPWR VPWR sky130_fd_sc_hd__decap_3
Xfanout200 _3413_/S VGND VGND VPWR VPWR _3423_/S sky130_fd_sc_hd__clkdlybuf4s25_1
X_4409_ _6847_/Q _4766_/A2 _4592_/B1 _4408_/X VGND VGND VPWR VPWR _4409_/X sky130_fd_sc_hd__a211o_2
XTAP_TAPCELL_ROW_35_1120 VGND VPWR sky130_fd_sc_hd__tapvpwrvgnd_1
Xfanout211 fanout216/X VGND VGND VPWR VPWR _5993_/S sky130_fd_sc_hd__clkdlybuf4s25_1
X_5389_ _5389_/A1 _5485_/A2 _3910_/X VGND VGND VPWR VPWR _6501_/D sky130_fd_sc_hd__a21o_2
Xfanout222 fanout234/X VGND VGND VPWR VPWR _5989_/S sky130_fd_sc_hd__clkdlybuf4s25_1
XFILLER_43_1428 VGND VGND VPWR VPWR sky130_fd_sc_hd__decap_3
Xfanout244 _5359_/X VGND VGND VPWR VPWR _5487_/A2 sky130_fd_sc_hd__clkdlybuf4s25_1
XFILLER_8_1046 VGND VGND VPWR VPWR sky130_fd_sc_hd__decap_3
XTAP_TAPCELL_ROW_31_1006 VGND VPWR sky130_fd_sc_hd__tapvpwrvgnd_1
XFILLER_75_916 VGND VGND VPWR VPWR sky130_fd_sc_hd__decap_3
XTAP_TAPCELL_ROW_31_1017 VGND VPWR sky130_fd_sc_hd__tapvpwrvgnd_1
Xfanout266 _4010_/X VGND VGND VPWR VPWR _4580_/B sky130_fd_sc_hd__clkdlybuf4s25_1
XFILLER_75_15 VGND VGND VPWR VPWR sky130_fd_sc_hd__decap_3
Xfanout288 fanout304/X VGND VGND VPWR VPWR _4751_/A2 sky130_fd_sc_hd__clkdlybuf4s25_1
X_7059_ _7060_/CLK _7059_/D fanout781/X VGND VGND VPWR VPWR _7059_/Q sky130_fd_sc_hd__dfrtp_2
XFILLER_46_117 VGND VGND VPWR VPWR sky130_fd_sc_hd__fill_2
XFILLER_28_843 VGND VGND VPWR VPWR sky130_fd_sc_hd__decap_3
XFILLER_39_180 VGND VGND VPWR VPWR sky130_fd_sc_hd__decap_3
XFILLER_55_640 VGND VGND VPWR VPWR sky130_fd_sc_hd__decap_3
XFILLER_27_364 VGND VGND VPWR VPWR sky130_fd_sc_hd__decap_3
XFILLER_28_887 VGND VGND VPWR VPWR sky130_fd_sc_hd__decap_3
XFILLER_55_673 VGND VGND VPWR VPWR sky130_fd_sc_hd__fill_2
XFILLER_76_1226 VGND VGND VPWR VPWR sky130_fd_sc_hd__decap_3
XFILLER_43_824 VGND VGND VPWR VPWR sky130_fd_sc_hd__decap_3
XFILLER_42_312 VGND VGND VPWR VPWR sky130_fd_sc_hd__decap_3
XFILLER_15_537 VGND VGND VPWR VPWR sky130_fd_sc_hd__decap_3
XFILLER_76_1259 VGND VGND VPWR VPWR sky130_fd_sc_hd__fill_1
XFILLER_70_643 VGND VGND VPWR VPWR sky130_fd_sc_hd__fill_1
XFILLER_43_857 VGND VGND VPWR VPWR sky130_fd_sc_hd__decap_3
XTAP_TAPCELL_ROW_65_1883 VGND VPWR sky130_fd_sc_hd__tapvpwrvgnd_1
XFILLER_30_529 VGND VGND VPWR VPWR sky130_fd_sc_hd__decap_3
XTAP_TAPCELL_ROW_65_1894 VGND VPWR sky130_fd_sc_hd__tapvpwrvgnd_1
XFILLER_11_721 VGND VGND VPWR VPWR sky130_fd_sc_hd__decap_3
XFILLER_23_592 VGND VGND VPWR VPWR sky130_fd_sc_hd__decap_3
XFILLER_11_754 VGND VGND VPWR VPWR sky130_fd_sc_hd__decap_3
XFILLER_7_714 VGND VGND VPWR VPWR sky130_fd_sc_hd__decap_3
XFILLER_13_1221 VGND VGND VPWR VPWR sky130_fd_sc_hd__decap_3
XFILLER_17_1390 VGND VGND VPWR VPWR sky130_fd_sc_hd__decap_3
XFILLER_52_1270 VGND VGND VPWR VPWR sky130_fd_sc_hd__decap_3
XFILLER_11_798 VGND VGND VPWR VPWR sky130_fd_sc_hd__decap_3
XFILLER_13_1254 VGND VGND VPWR VPWR sky130_fd_sc_hd__decap_3
XFILLER_13_1287 VGND VGND VPWR VPWR sky130_fd_sc_hd__fill_1
XFILLER_13_1298 VGND VGND VPWR VPWR sky130_fd_sc_hd__decap_3
XFILLER_48_1306 VGND VGND VPWR VPWR sky130_fd_sc_hd__decap_3
XFILLER_48_1317 VGND VGND VPWR VPWR sky130_fd_sc_hd__decap_3
XFILLER_3_953 VGND VGND VPWR VPWR sky130_fd_sc_hd__decap_3
XFILLER_34_9 VGND VGND VPWR VPWR sky130_fd_sc_hd__decap_3
XFILLER_2_485 VGND VGND VPWR VPWR sky130_fd_sc_hd__decap_3
XFILLER_78_754 VGND VGND VPWR VPWR sky130_fd_sc_hd__fill_2
XFILLER_66_916 VGND VGND VPWR VPWR sky130_fd_sc_hd__decap_3
XFILLER_4_1400 VGND VGND VPWR VPWR sky130_fd_sc_hd__decap_3
XFILLER_1_12 VGND VGND VPWR VPWR sky130_fd_sc_hd__decap_3
XFILLER_24_1350 VGND VGND VPWR VPWR sky130_fd_sc_hd__decap_3
XFILLER_59_990 VGND VGND VPWR VPWR sky130_fd_sc_hd__decap_3
XFILLER_1_45 VGND VGND VPWR VPWR sky130_fd_sc_hd__decap_3
XFILLER_4_1444 VGND VGND VPWR VPWR sky130_fd_sc_hd__decap_3
XFILLER_37_139 VGND VGND VPWR VPWR sky130_fd_sc_hd__decap_3
XFILLER_1_78 VGND VGND VPWR VPWR sky130_fd_sc_hd__decap_3
XFILLER_20_1225 VGND VGND VPWR VPWR sky130_fd_sc_hd__decap_3
XFILLER_24_1394 VGND VGND VPWR VPWR sky130_fd_sc_hd__decap_3
XFILLER_59_1413 VGND VGND VPWR VPWR sky130_fd_sc_hd__decap_3
XFILLER_34_802 VGND VGND VPWR VPWR sky130_fd_sc_hd__fill_2
XFILLER_80_418 VGND VGND VPWR VPWR sky130_fd_sc_hd__fill_2
XFILLER_20_1258 VGND VGND VPWR VPWR sky130_fd_sc_hd__fill_2
XFILLER_34_813 VGND VGND VPWR VPWR sky130_fd_sc_hd__fill_2
XFILLER_65_81 VGND VGND VPWR VPWR sky130_fd_sc_hd__decap_3
XFILLER_59_1446 VGND VGND VPWR VPWR sky130_fd_sc_hd__decap_3
XFILLER_59_1457 VGND VGND VPWR VPWR sky130_fd_sc_hd__decap_3
XFILLER_45_183 VGND VGND VPWR VPWR sky130_fd_sc_hd__decap_3
XFILLER_33_334 VGND VGND VPWR VPWR sky130_fd_sc_hd__fill_2
XFILLER_61_687 VGND VGND VPWR VPWR sky130_fd_sc_hd__decap_3
XFILLER_53_1012 VGND VGND VPWR VPWR sky130_fd_sc_hd__decap_3
XFILLER_21_529 VGND VGND VPWR VPWR sky130_fd_sc_hd__decap_3
X_4760_ _4760_/A _4760_/B VGND VGND VPWR VPWR _4760_/Y sky130_fd_sc_hd__nor2_2
XFILLER_57_1192 VGND VGND VPWR VPWR sky130_fd_sc_hd__fill_2
XFILLER_14_581 VGND VGND VPWR VPWR sky130_fd_sc_hd__fill_2
XFILLER_42_890 VGND VGND VPWR VPWR sky130_fd_sc_hd__decap_3
XFILLER_60_197 VGND VGND VPWR VPWR sky130_fd_sc_hd__fill_2
XFILLER_18_1176 VGND VGND VPWR VPWR sky130_fd_sc_hd__decap_3
X_3711_ _3711_/A VGND VGND VPWR VPWR _3711_/Y sky130_fd_sc_hd__inv_2
X_4691_ _6291_/Q _4868_/A2 _3392_/X _4868_/B2 VGND VGND VPWR VPWR _4691_/X sky130_fd_sc_hd__a22o_2
XFILLER_31_1310 VGND VGND VPWR VPWR sky130_fd_sc_hd__decap_3
X_6430_ _7056_/CLK _6430_/D load_slew700/X VGND VGND VPWR VPWR _6430_/Q sky130_fd_sc_hd__dfrtp_2
X_3642_ _3791_/A VGND VGND VPWR VPWR _3822_/A sky130_fd_sc_hd__inv_2
XFILLER_31_1343 VGND VGND VPWR VPWR sky130_fd_sc_hd__fill_1
XFILLER_31_1354 VGND VGND VPWR VPWR sky130_fd_sc_hd__decap_3
X_6361_ _7051_/CLK _6361_/D load_slew815/X VGND VGND VPWR VPWR _6361_/Q sky130_fd_sc_hd__dfrtp_2
XFILLER_31_1387 VGND VGND VPWR VPWR sky130_fd_sc_hd__decap_3
X_3573_ _4487_/A _3572_/X _3486_/A VGND VGND VPWR VPWR _3573_/Y sky130_fd_sc_hd__o21ai_2
XPHY_EDGE_ROW_49_Right_49 VGND VGND VPWR VPWR sky130_fd_sc_hd__decap_3
XFILLER_66_1406 VGND VGND VPWR VPWR sky130_fd_sc_hd__decap_3
X_5312_ _6787_/Q _4966_/B _5328_/S VGND VGND VPWR VPWR _5312_/X sky130_fd_sc_hd__mux2_1
X_6292_ _6982_/CLK _6292_/D fanout745/X VGND VGND VPWR VPWR _6292_/Q sky130_fd_sc_hd__dfrtp_2
XTAP_TAPCELL_ROW_71_2043 VGND VPWR sky130_fd_sc_hd__tapvpwrvgnd_1
XTAP_TAPCELL_ROW_71_2054 VGND VPWR sky130_fd_sc_hd__tapvpwrvgnd_1
X_5243_ _5318_/S _5243_/B VGND VGND VPWR VPWR _5243_/Y sky130_fd_sc_hd__nand2_2
XFILLER_9_1322 VGND VGND VPWR VPWR sky130_fd_sc_hd__decap_3
XFILLER_69_732 VGND VGND VPWR VPWR sky130_fd_sc_hd__fill_2
XFILLER_29_1272 VGND VGND VPWR VPWR sky130_fd_sc_hd__decap_3
XFILLER_9_1366 VGND VGND VPWR VPWR sky130_fd_sc_hd__decap_3
X_5174_ _6734_/Q _5318_/S VGND VGND VPWR VPWR _5174_/X sky130_fd_sc_hd__or2_2
XFILLER_60_1005 VGND VGND VPWR VPWR sky130_fd_sc_hd__fill_1
XFILLER_5_1219 VGND VGND VPWR VPWR sky130_fd_sc_hd__decap_3
XFILLER_68_253 VGND VGND VPWR VPWR sky130_fd_sc_hd__decap_3
XFILLER_9_1399 VGND VGND VPWR VPWR sky130_fd_sc_hd__fill_1
XFILLER_29_629 VGND VGND VPWR VPWR sky130_fd_sc_hd__decap_3
XFILLER_56_404 VGND VGND VPWR VPWR sky130_fd_sc_hd__decap_3
X_4125_ _6273_/Q _4765_/A2 _3228_/X _4743_/B2 VGND VGND VPWR VPWR _4125_/X sky130_fd_sc_hd__a22o_2
XFILLER_42_1450 VGND VGND VPWR VPWR sky130_fd_sc_hd__decap_3
X_4056_ _3416_/X _4056_/A2 _4781_/A2 _6905_/Q _4104_/C1 VGND VGND VPWR VPWR _4056_/X
+ sky130_fd_sc_hd__a221o_2
XPHY_EDGE_ROW_58_Right_58 VGND VGND VPWR VPWR sky130_fd_sc_hd__decap_3
XFILLER_36_183 VGND VGND VPWR VPWR sky130_fd_sc_hd__decap_3
XFILLER_52_643 VGND VGND VPWR VPWR sky130_fd_sc_hd__fill_1
XFILLER_40_816 VGND VGND VPWR VPWR sky130_fd_sc_hd__decap_3
XFILLER_75_1281 VGND VGND VPWR VPWR sky130_fd_sc_hd__decap_3
X_4958_ _6448_/Q _6666_/Q VGND VGND VPWR VPWR _4959_/B sky130_fd_sc_hd__xor2_2
XFILLER_75_1292 VGND VGND VPWR VPWR sky130_fd_sc_hd__decap_3
XFILLER_36_1243 VGND VGND VPWR VPWR sky130_fd_sc_hd__decap_3
XFILLER_51_186 VGND VGND VPWR VPWR sky130_fd_sc_hd__decap_3
XFILLER_61_39 VGND VGND VPWR VPWR sky130_fd_sc_hd__decap_3
XFILLER_71_1156 VGND VGND VPWR VPWR sky130_fd_sc_hd__decap_3
XFILLER_36_1276 VGND VGND VPWR VPWR sky130_fd_sc_hd__decap_3
X_3909_ _6501_/Q _4330_/A2 _4734_/C1 _3908_/Y VGND VGND VPWR VPWR _3909_/X sky130_fd_sc_hd__o211a_2
XTAP_TAPCELL_ROW_78_2219 VGND VPWR sky130_fd_sc_hd__tapvpwrvgnd_1
X_4889_ _4889_/A _4889_/B _4889_/C VGND VGND VPWR VPWR _4889_/X sky130_fd_sc_hd__and3_2
XFILLER_71_1189 VGND VGND VPWR VPWR sky130_fd_sc_hd__decap_3
X_6628_ _7012_/CLK _6628_/D load_slew801/X VGND VGND VPWR VPWR _6628_/Q sky130_fd_sc_hd__dfrtp_2
XPHY_EDGE_ROW_67_Right_67 VGND VGND VPWR VPWR sky130_fd_sc_hd__decap_3
XFILLER_10_1427 VGND VGND VPWR VPWR sky130_fd_sc_hd__fill_1
X_6559_ _6929_/CLK _6559_/D fanout706/X VGND VGND VPWR VPWR _6559_/Q sky130_fd_sc_hd__dfrtp_2
XFILLER_10_1438 VGND VGND VPWR VPWR sky130_fd_sc_hd__decap_3
XFILLER_10_21 VGND VGND VPWR VPWR sky130_fd_sc_hd__decap_3
XFILLER_69_1063 VGND VGND VPWR VPWR sky130_fd_sc_hd__fill_1
XFILLER_10_76 VGND VGND VPWR VPWR sky130_fd_sc_hd__decap_3
XFILLER_79_529 VGND VGND VPWR VPWR sky130_fd_sc_hd__decap_3
XFILLER_0_912 VGND VGND VPWR VPWR sky130_fd_sc_hd__decap_3
XFILLER_0_934 VGND VGND VPWR VPWR sky130_fd_sc_hd__decap_3
XFILLER_47_1372 VGND VGND VPWR VPWR sky130_fd_sc_hd__decap_3
XFILLER_0_956 VGND VGND VPWR VPWR sky130_fd_sc_hd__decap_3
XFILLER_59_231 VGND VGND VPWR VPWR sky130_fd_sc_hd__decap_3
XFILLER_48_905 VGND VGND VPWR VPWR sky130_fd_sc_hd__decap_3
XFILLER_43_1236 VGND VGND VPWR VPWR sky130_fd_sc_hd__decap_3
XTAP_TAPCELL_ROW_54_1595 VGND VPWR sky130_fd_sc_hd__tapvpwrvgnd_1
XFILLER_19_106 VGND VGND VPWR VPWR sky130_fd_sc_hd__decap_3
XFILLER_75_735 VGND VGND VPWR VPWR sky130_fd_sc_hd__decap_3
XFILLER_43_1269 VGND VGND VPWR VPWR sky130_fd_sc_hd__decap_3
XFILLER_47_426 VGND VGND VPWR VPWR sky130_fd_sc_hd__decap_3
XPHY_EDGE_ROW_76_Right_76 VGND VGND VPWR VPWR sky130_fd_sc_hd__decap_3
XFILLER_75_779 VGND VGND VPWR VPWR sky130_fd_sc_hd__decap_3
XFILLER_28_651 VGND VGND VPWR VPWR sky130_fd_sc_hd__decap_3
XTAP_TAPCELL_ROW_2_260 VGND VPWR sky130_fd_sc_hd__tapvpwrvgnd_1
XFILLER_16_813 VGND VGND VPWR VPWR sky130_fd_sc_hd__decap_3
XFILLER_62_429 VGND VGND VPWR VPWR sky130_fd_sc_hd__decap_3
XTAP_TAPCELL_ROW_67_1934 VGND VPWR sky130_fd_sc_hd__tapvpwrvgnd_1
XFILLER_16_835 VGND VGND VPWR VPWR sky130_fd_sc_hd__decap_3
XTAP_TAPCELL_ROW_67_1945 VGND VPWR sky130_fd_sc_hd__tapvpwrvgnd_1
XFILLER_15_312 VGND VGND VPWR VPWR sky130_fd_sc_hd__decap_3
XFILLER_35_51 VGND VGND VPWR VPWR sky130_fd_sc_hd__decap_3
XFILLER_76_1067 VGND VGND VPWR VPWR sky130_fd_sc_hd__decap_3
XFILLER_43_665 VGND VGND VPWR VPWR sky130_fd_sc_hd__decap_3
XFILLER_71_985 VGND VGND VPWR VPWR sky130_fd_sc_hd__decap_3
XFILLER_43_676 VGND VGND VPWR VPWR sky130_fd_sc_hd__decap_3
XTAP_TAPCELL_ROW_26_874 VGND VPWR sky130_fd_sc_hd__tapvpwrvgnd_1
XTAP_TAPCELL_ROW_26_885 VGND VPWR sky130_fd_sc_hd__tapvpwrvgnd_1
XFILLER_31_838 VGND VGND VPWR VPWR sky130_fd_sc_hd__fill_2
XFILLER_19_1452 VGND VGND VPWR VPWR sky130_fd_sc_hd__decap_3
XFILLER_54_1332 VGND VGND VPWR VPWR sky130_fd_sc_hd__decap_3
XFILLER_19_1463 VGND VGND VPWR VPWR sky130_fd_sc_hd__decap_3
XFILLER_42_197 VGND VGND VPWR VPWR sky130_fd_sc_hd__decap_3
XTAP_TAPCELL_ROW_13_535 VGND VPWR sky130_fd_sc_hd__tapvpwrvgnd_1
XTAP_TAPCELL_ROW_13_546 VGND VPWR sky130_fd_sc_hd__tapvpwrvgnd_1
XFILLER_15_1316 VGND VGND VPWR VPWR sky130_fd_sc_hd__decap_3
XFILLER_54_1365 VGND VGND VPWR VPWR sky130_fd_sc_hd__decap_3
XFILLER_54_1376 VGND VGND VPWR VPWR sky130_fd_sc_hd__decap_3
XFILLER_7_511 VGND VGND VPWR VPWR sky130_fd_sc_hd__decap_3
Xwire431 wire431/A VGND VGND VPWR VPWR wire431/X sky130_fd_sc_hd__buf_4
XFILLER_7_544 VGND VGND VPWR VPWR sky130_fd_sc_hd__decap_3
XFILLER_13_1040 VGND VGND VPWR VPWR sky130_fd_sc_hd__decap_3
XPHY_EDGE_ROW_2_Left_83 VGND VGND VPWR VPWR sky130_fd_sc_hd__decap_3
XFILLER_48_1147 VGND VGND VPWR VPWR sky130_fd_sc_hd__fill_1
XFILLER_48_1158 VGND VGND VPWR VPWR sky130_fd_sc_hd__fill_2
Xload_slew414 fanout413/X VGND VGND VPWR VPWR _4604_/A sky130_fd_sc_hd__clkbuf_4
XFILLER_3_794 VGND VGND VPWR VPWR sky130_fd_sc_hd__decap_3
XFILLER_26_1412 VGND VGND VPWR VPWR sky130_fd_sc_hd__decap_3
XFILLER_32_6 VGND VGND VPWR VPWR sky130_fd_sc_hd__decap_3
XFILLER_2_282 VGND VGND VPWR VPWR sky130_fd_sc_hd__decap_3
Xload_slew436 _5123_/A VGND VGND VPWR VPWR _5359_/B sky130_fd_sc_hd__buf_4
XFILLER_61_1325 VGND VGND VPWR VPWR sky130_fd_sc_hd__decap_3
XFILLER_26_1456 VGND VGND VPWR VPWR sky130_fd_sc_hd__decap_3
XFILLER_22_1309 VGND VGND VPWR VPWR sky130_fd_sc_hd__decap_3
XFILLER_78_584 VGND VGND VPWR VPWR sky130_fd_sc_hd__decap_3
XFILLER_61_1369 VGND VGND VPWR VPWR sky130_fd_sc_hd__decap_3
XFILLER_65_201 VGND VGND VPWR VPWR sky130_fd_sc_hd__decap_3
XFILLER_78_595 VGND VGND VPWR VPWR sky130_fd_sc_hd__decap_3
XFILLER_38_437 VGND VGND VPWR VPWR sky130_fd_sc_hd__fill_2
XFILLER_4_1241 VGND VGND VPWR VPWR sky130_fd_sc_hd__decap_3
XTAP_TAPCELL_ROW_0_208 VGND VPWR sky130_fd_sc_hd__tapvpwrvgnd_1
XFILLER_0_1105 VGND VGND VPWR VPWR sky130_fd_sc_hd__decap_3
X_5930_ _5930_/A0 _5930_/A1 _5932_/S VGND VGND VPWR VPWR _6935_/D sky130_fd_sc_hd__mux2_1
XFILLER_4_1285 VGND VGND VPWR VPWR sky130_fd_sc_hd__decap_3
XFILLER_18_150 VGND VGND VPWR VPWR sky130_fd_sc_hd__decap_3
XFILLER_53_429 VGND VGND VPWR VPWR sky130_fd_sc_hd__decap_3
XFILLER_0_1127 VGND VGND VPWR VPWR sky130_fd_sc_hd__decap_3
XFILLER_65_289 VGND VGND VPWR VPWR sky130_fd_sc_hd__decap_3
XFILLER_20_1077 VGND VGND VPWR VPWR sky130_fd_sc_hd__fill_1
XFILLER_0_1149 VGND VGND VPWR VPWR sky130_fd_sc_hd__decap_3
XFILLER_46_492 VGND VGND VPWR VPWR sky130_fd_sc_hd__fill_2
XFILLER_59_1254 VGND VGND VPWR VPWR sky130_fd_sc_hd__decap_3
XFILLER_18_194 VGND VGND VPWR VPWR sky130_fd_sc_hd__fill_2
XFILLER_34_643 VGND VGND VPWR VPWR sky130_fd_sc_hd__fill_1
X_5861_ _5861_/A0 _5899_/A0 _5867_/S VGND VGND VPWR VPWR _6875_/D sky130_fd_sc_hd__mux2_1
XFILLER_61_440 VGND VGND VPWR VPWR sky130_fd_sc_hd__fill_1
XFILLER_33_142 VGND VGND VPWR VPWR sky130_fd_sc_hd__decap_3
XFILLER_55_1118 VGND VGND VPWR VPWR sky130_fd_sc_hd__fill_2
XFILLER_59_1287 VGND VGND VPWR VPWR sky130_fd_sc_hd__fill_1
XFILLER_55_1129 VGND VGND VPWR VPWR sky130_fd_sc_hd__decap_3
XFILLER_34_687 VGND VGND VPWR VPWR sky130_fd_sc_hd__decap_3
XFILLER_59_1298 VGND VGND VPWR VPWR sky130_fd_sc_hd__decap_3
XFILLER_62_996 VGND VGND VPWR VPWR sky130_fd_sc_hd__decap_3
X_4812_ _6917_/Q _4869_/A2 _4810_/X _4811_/X VGND VGND VPWR VPWR _4812_/X sky130_fd_sc_hd__a211o_2
XFILLER_22_838 VGND VGND VPWR VPWR sky130_fd_sc_hd__decap_3
XFILLER_72_1421 VGND VGND VPWR VPWR sky130_fd_sc_hd__decap_3
XFILLER_72_1432 VGND VGND VPWR VPWR sky130_fd_sc_hd__decap_3
X_5792_ _6820_/Q _5783_/X _5841_/C _5791_/X VGND VGND VPWR VPWR _6820_/D sky130_fd_sc_hd__a22o_2
XFILLER_61_495 VGND VGND VPWR VPWR sky130_fd_sc_hd__decap_3
XFILLER_21_337 VGND VGND VPWR VPWR sky130_fd_sc_hd__decap_3
XFILLER_72_1465 VGND VGND VPWR VPWR sky130_fd_sc_hd__decap_3
XFILLER_33_1416 VGND VGND VPWR VPWR sky130_fd_sc_hd__decap_3
X_4743_ _6250_/Q _4743_/A2 _3422_/X _4743_/B2 VGND VGND VPWR VPWR _4743_/X sky130_fd_sc_hd__a22o_2
XFILLER_33_1449 VGND VGND VPWR VPWR sky130_fd_sc_hd__decap_3
X_4674_ _4703_/A _4851_/B VGND VGND VPWR VPWR _4674_/Y sky130_fd_sc_hd__nor2_2
X_6413_ _7004_/CLK _6413_/D load_slew840/X VGND VGND VPWR VPWR _6413_/Q sky130_fd_sc_hd__dfrtp_2
X_3625_ _6288_/Q _5594_/A1 _3630_/C1 _6272_/Q VGND VGND VPWR VPWR _3625_/X sky130_fd_sc_hd__a22o_2
XTAP_TAPCELL_ROW_73_2105 VGND VPWR sky130_fd_sc_hd__tapvpwrvgnd_1
X_6344_ _6752_/CLK _6344_/D load_slew669/X VGND VGND VPWR VPWR _6344_/Q sky130_fd_sc_hd__dfrtp_2
XFILLER_66_1214 VGND VGND VPWR VPWR sky130_fd_sc_hd__decap_3
X_3556_ _6321_/Q _6329_/Q _6337_/Q _6241_/Q _3550_/B _3566_/A VGND VGND VPWR VPWR
+ _3557_/B sky130_fd_sc_hd__mux4_2
XFILLER_1_709 VGND VGND VPWR VPWR sky130_fd_sc_hd__decap_3
XFILLER_66_1247 VGND VGND VPWR VPWR sky130_fd_sc_hd__decap_3
X_6275_ _7034_/CLK _6275_/D fanout685/X VGND VGND VPWR VPWR _6275_/Q sky130_fd_sc_hd__dfrtp_2
X_3487_ _7082_/Q _7086_/Q VGND VGND VPWR VPWR _3487_/X sky130_fd_sc_hd__or2_2
XFILLER_9_1130 VGND VGND VPWR VPWR sky130_fd_sc_hd__decap_3
X_5226_ _6755_/Q _5328_/S _5321_/S _5225_/Y VGND VGND VPWR VPWR _5226_/X sky130_fd_sc_hd__o211a_2
XFILLER_9_1163 VGND VGND VPWR VPWR sky130_fd_sc_hd__decap_3
XFILLER_69_573 VGND VGND VPWR VPWR sky130_fd_sc_hd__decap_3
X_5157_ _6387_/Q _5257_/A2 _4985_/S _5156_/X VGND VGND VPWR VPWR _6387_/D sky130_fd_sc_hd__a22o_2
XFILLER_40_1409 VGND VGND VPWR VPWR sky130_fd_sc_hd__decap_3
XFILLER_57_746 VGND VGND VPWR VPWR sky130_fd_sc_hd__fill_1
XFILLER_5_1049 VGND VGND VPWR VPWR sky130_fd_sc_hd__decap_3
X_4108_ wire25/X _4108_/B VGND VGND VPWR VPWR _4108_/Y sky130_fd_sc_hd__nor2_2
X_5088_ _6434_/Q _5088_/B VGND VGND VPWR VPWR _5276_/B sky130_fd_sc_hd__xnor2_2
XFILLER_57_779 VGND VGND VPWR VPWR sky130_fd_sc_hd__decap_3
XFILLER_42_1291 VGND VGND VPWR VPWR sky130_fd_sc_hd__decap_3
XFILLER_77_1310 VGND VGND VPWR VPWR sky130_fd_sc_hd__decap_3
XFILLER_56_278 VGND VGND VPWR VPWR sky130_fd_sc_hd__decap_3
X_4039_ _6236_/Q wire77/X _4037_/X _4038_/X VGND VGND VPWR VPWR _6236_/D sky130_fd_sc_hd__o22a_2
XFILLER_71_215 VGND VGND VPWR VPWR sky130_fd_sc_hd__fill_1
XFILLER_37_470 VGND VGND VPWR VPWR sky130_fd_sc_hd__fill_2
XFILLER_77_1343 VGND VGND VPWR VPWR sky130_fd_sc_hd__fill_1
XFILLER_77_1354 VGND VGND VPWR VPWR sky130_fd_sc_hd__decap_3
XFILLER_25_643 VGND VGND VPWR VPWR sky130_fd_sc_hd__decap_3
XFILLER_72_27 VGND VGND VPWR VPWR sky130_fd_sc_hd__fill_1
XFILLER_71_259 VGND VGND VPWR VPWR sky130_fd_sc_hd__decap_3
XFILLER_73_1207 VGND VGND VPWR VPWR sky130_fd_sc_hd__decap_3
XFILLER_72_38 VGND VGND VPWR VPWR sky130_fd_sc_hd__decap_3
XFILLER_25_665 VGND VGND VPWR VPWR sky130_fd_sc_hd__decap_3
XFILLER_80_760 VGND VGND VPWR VPWR sky130_fd_sc_hd__decap_3
XFILLER_77_1387 VGND VGND VPWR VPWR sky130_fd_sc_hd__decap_3
XFILLER_38_1338 VGND VGND VPWR VPWR sky130_fd_sc_hd__decap_3
XFILLER_25_676 VGND VGND VPWR VPWR sky130_fd_sc_hd__decap_3
XTAP_TAPCELL_ROW_23_800 VGND VPWR sky130_fd_sc_hd__tapvpwrvgnd_1
XFILLER_13_838 VGND VGND VPWR VPWR sky130_fd_sc_hd__fill_2
XTAP_TAPCELL_ROW_23_811 VGND VPWR sky130_fd_sc_hd__tapvpwrvgnd_1
XTAP_TAPCELL_ROW_62_1820 VGND VPWR sky130_fd_sc_hd__tapvpwrvgnd_1
XFILLER_36_1040 VGND VGND VPWR VPWR sky130_fd_sc_hd__decap_3
XFILLER_40_679 VGND VGND VPWR VPWR sky130_fd_sc_hd__decap_3
XFILLER_36_1084 VGND VGND VPWR VPWR sky130_fd_sc_hd__decap_3
XANTENNA_60 _4738_/A VGND VGND VPWR VPWR sky130_fd_sc_hd__diode_2
XANTENNA_71 _5107_/A VGND VGND VPWR VPWR sky130_fd_sc_hd__diode_2
XANTENNA_82 fanout848/X VGND VGND VPWR VPWR sky130_fd_sc_hd__diode_2
XFILLER_20_392 VGND VGND VPWR VPWR sky130_fd_sc_hd__fill_1
XFILLER_14_1371 VGND VGND VPWR VPWR sky130_fd_sc_hd__fill_1
XFILLER_14_1382 VGND VGND VPWR VPWR sky130_fd_sc_hd__decap_3
XFILLER_21_53 VGND VGND VPWR VPWR sky130_fd_sc_hd__decap_3
XFILLER_49_1401 VGND VGND VPWR VPWR sky130_fd_sc_hd__decap_3
XFILLER_10_1235 VGND VGND VPWR VPWR sky130_fd_sc_hd__decap_3
XFILLER_4_536 VGND VGND VPWR VPWR sky130_fd_sc_hd__decap_3
XFILLER_49_1434 VGND VGND VPWR VPWR sky130_fd_sc_hd__decap_3
XFILLER_10_1279 VGND VGND VPWR VPWR sky130_fd_sc_hd__decap_3
XFILLER_4_569 VGND VGND VPWR VPWR sky130_fd_sc_hd__decap_3
XTAP_TAPCELL_ROW_56_1646 VGND VPWR sky130_fd_sc_hd__tapvpwrvgnd_1
XTAP_TAPCELL_ROW_56_1657 VGND VPWR sky130_fd_sc_hd__tapvpwrvgnd_1
XTAP_TAPCELL_ROW_56_1668 VGND VPWR sky130_fd_sc_hd__tapvpwrvgnd_1
XFILLER_79_337 VGND VGND VPWR VPWR sky130_fd_sc_hd__fill_2
XFILLER_0_753 VGND VGND VPWR VPWR sky130_fd_sc_hd__decap_3
XFILLER_47_1180 VGND VGND VPWR VPWR sky130_fd_sc_hd__fill_2
XFILLER_43_1022 VGND VGND VPWR VPWR sky130_fd_sc_hd__decap_3
XTAP_TAPCELL_ROW_7_374 VGND VPWR sky130_fd_sc_hd__tapvpwrvgnd_1
XTAP_TAPCELL_ROW_7_385 VGND VPWR sky130_fd_sc_hd__tapvpwrvgnd_1
XFILLER_0_775 VGND VGND VPWR VPWR sky130_fd_sc_hd__decap_3
XFILLER_48_724 VGND VGND VPWR VPWR sky130_fd_sc_hd__decap_3
XFILLER_0_797 VGND VGND VPWR VPWR sky130_fd_sc_hd__decap_3
XFILLER_21_1331 VGND VGND VPWR VPWR sky130_fd_sc_hd__decap_3
XFILLER_78_1129 VGND VGND VPWR VPWR sky130_fd_sc_hd__decap_3
XFILLER_60_1391 VGND VGND VPWR VPWR sky130_fd_sc_hd__decap_3
XFILLER_63_727 VGND VGND VPWR VPWR sky130_fd_sc_hd__fill_1
XFILLER_1_1425 VGND VGND VPWR VPWR sky130_fd_sc_hd__decap_3
XFILLER_46_61 VGND VGND VPWR VPWR sky130_fd_sc_hd__fill_2
XFILLER_63_738 VGND VGND VPWR VPWR sky130_fd_sc_hd__decap_3
XFILLER_16_610 VGND VGND VPWR VPWR sky130_fd_sc_hd__decap_3
XFILLER_21_1375 VGND VGND VPWR VPWR sky130_fd_sc_hd__decap_3
Xmax_cap84 _5845_/S VGND VGND VPWR VPWR _5849_/S sky130_fd_sc_hd__buf_6
XFILLER_56_1427 VGND VGND VPWR VPWR sky130_fd_sc_hd__fill_1
XFILLER_71_771 VGND VGND VPWR VPWR sky130_fd_sc_hd__decap_3
XFILLER_56_1438 VGND VGND VPWR VPWR sky130_fd_sc_hd__decap_3
XFILLER_44_996 VGND VGND VPWR VPWR sky130_fd_sc_hd__decap_3
XFILLER_31_646 VGND VGND VPWR VPWR sky130_fd_sc_hd__decap_3
XFILLER_19_1260 VGND VGND VPWR VPWR sky130_fd_sc_hd__decap_3
XFILLER_31_679 VGND VGND VPWR VPWR sky130_fd_sc_hd__decap_3
XFILLER_62_93 VGND VGND VPWR VPWR sky130_fd_sc_hd__fill_2
XFILLER_15_1135 VGND VGND VPWR VPWR sky130_fd_sc_hd__fill_2
XFILLER_11_370 VGND VGND VPWR VPWR sky130_fd_sc_hd__fill_1
XFILLER_8_842 VGND VGND VPWR VPWR sky130_fd_sc_hd__decap_3
XFILLER_50_1037 VGND VGND VPWR VPWR sky130_fd_sc_hd__decap_3
XFILLER_7_33 VGND VGND VPWR VPWR sky130_fd_sc_hd__fill_2
X_3410_ _6236_/Q _6436_/Q VGND VGND VPWR VPWR _3410_/X sky130_fd_sc_hd__xor2_2
X_4390_ _4769_/B1 _4387_/X _4388_/Y _4389_/X _4597_/A VGND VGND VPWR VPWR _4390_/X
+ sky130_fd_sc_hd__o221a_2
X_3341_ hold968/X _3340_/X _3423_/S VGND VGND VPWR VPWR _6144_/D sky130_fd_sc_hd__mux2_1
X_6060_ _6060_/A0 _7064_/Q _6060_/S VGND VGND VPWR VPWR _6060_/X sky130_fd_sc_hd__mux2_1
XFILLER_30_3 VGND VGND VPWR VPWR sky130_fd_sc_hd__decap_3
X_3272_ _6271_/Q _6367_/Q VGND VGND VPWR VPWR _3272_/X sky130_fd_sc_hd__xor2_2
Xload_slew233 _5971_/S VGND VGND VPWR VPWR _6035_/S sky130_fd_sc_hd__clkbuf_4
XFILLER_6_1303 VGND VGND VPWR VPWR sky130_fd_sc_hd__decap_3
Xload_slew255 _4610_/A VGND VGND VPWR VPWR _4710_/A sky130_fd_sc_hd__clkbuf_4
XFILLER_26_1253 VGND VGND VPWR VPWR sky130_fd_sc_hd__decap_3
X_5011_ _5009_/X _5010_/Y wire112/A VGND VGND VPWR VPWR _5013_/S sky130_fd_sc_hd__a21oi_2
Xhold1008 _6096_/Q VGND VGND VPWR VPWR _5943_/A0 sky130_fd_sc_hd__dlygate4sd3_1
XFILLER_26_1264 VGND VGND VPWR VPWR sky130_fd_sc_hd__decap_3
Xhold1019 _6184_/Q VGND VGND VPWR VPWR _6031_/A0 sky130_fd_sc_hd__dlygate4sd3_1
XFILLER_6_1347 VGND VGND VPWR VPWR sky130_fd_sc_hd__decap_3
Xload_slew299 fanout298/X VGND VGND VPWR VPWR _4883_/A2 sky130_fd_sc_hd__buf_4
XFILLER_26_1297 VGND VGND VPWR VPWR sky130_fd_sc_hd__decap_3
XFILLER_54_738 VGND VGND VPWR VPWR sky130_fd_sc_hd__decap_3
XFILLER_19_470 VGND VGND VPWR VPWR sky130_fd_sc_hd__decap_3
X_6962_ _7034_/CLK _6962_/D fanout675/X VGND VGND VPWR VPWR _6962_/Q sky130_fd_sc_hd__dfrtp_2
XFILLER_4_1082 VGND VGND VPWR VPWR sky130_fd_sc_hd__decap_3
XFILLER_4_1093 VGND VGND VPWR VPWR sky130_fd_sc_hd__decap_3
XFILLER_19_492 VGND VGND VPWR VPWR sky130_fd_sc_hd__decap_3
XFILLER_53_237 VGND VGND VPWR VPWR sky130_fd_sc_hd__decap_3
X_5913_ _5913_/A0 _5913_/A1 _5913_/S VGND VGND VPWR VPWR _6920_/D sky130_fd_sc_hd__mux2_1
X_6893_ clkload9/A _6893_/D fanout656/X VGND VGND VPWR VPWR _6893_/Q sky130_fd_sc_hd__dfrtp_2
XFILLER_34_451 VGND VGND VPWR VPWR sky130_fd_sc_hd__decap_3
XFILLER_59_1062 VGND VGND VPWR VPWR sky130_fd_sc_hd__fill_2
XFILLER_22_602 VGND VGND VPWR VPWR sky130_fd_sc_hd__decap_3
XFILLER_50_911 VGND VGND VPWR VPWR sky130_fd_sc_hd__decap_3
X_5844_ _5844_/A0 _5918_/A1 _5849_/S VGND VGND VPWR VPWR _6860_/D sky130_fd_sc_hd__mux2_1
XFILLER_50_944 VGND VGND VPWR VPWR sky130_fd_sc_hd__decap_3
XFILLER_61_281 VGND VGND VPWR VPWR sky130_fd_sc_hd__fill_2
XFILLER_37_1360 VGND VGND VPWR VPWR sky130_fd_sc_hd__decap_3
XFILLER_50_977 VGND VGND VPWR VPWR sky130_fd_sc_hd__decap_3
XFILLER_10_819 VGND VGND VPWR VPWR sky130_fd_sc_hd__fill_2
X_5775_ _5775_/A0 _5784_/C _5781_/S VGND VGND VPWR VPWR _6810_/D sky130_fd_sc_hd__mux2_1
XFILLER_72_1273 VGND VGND VPWR VPWR sky130_fd_sc_hd__decap_3
XFILLER_50_999 VGND VGND VPWR VPWR sky130_fd_sc_hd__decap_3
XFILLER_37_1393 VGND VGND VPWR VPWR sky130_fd_sc_hd__decap_3
X_4726_ _6568_/Q _4747_/A _4769_/B1 VGND VGND VPWR VPWR _4726_/X sky130_fd_sc_hd__a21bo_2
XFILLER_33_1257 VGND VGND VPWR VPWR sky130_fd_sc_hd__decap_3
X_4657_ _6310_/Q wire52/X _4654_/X _4656_/X VGND VGND VPWR VPWR _6310_/D sky130_fd_sc_hd__o22a_2
XFILLER_68_1309 VGND VGND VPWR VPWR sky130_fd_sc_hd__decap_3
X_3608_ _3644_/B _3644_/C VGND VGND VPWR VPWR _3635_/A sky130_fd_sc_hd__nand2_2
X_4588_ _6541_/Q _4588_/B VGND VGND VPWR VPWR _4588_/Y sky130_fd_sc_hd__nand2_2
XFILLER_1_517 VGND VGND VPWR VPWR sky130_fd_sc_hd__decap_3
X_6327_ _6913_/CLK _6327_/D fanout729/X VGND VGND VPWR VPWR _6327_/Q sky130_fd_sc_hd__dfrtp_2
Xhold864 _6123_/Q VGND VGND VPWR VPWR hold864/X sky130_fd_sc_hd__dlygate4sd3_1
Xhold875 _6725_/Q VGND VGND VPWR VPWR hold875/X sky130_fd_sc_hd__dlygate4sd3_1
X_3539_ _6645_/Q _4723_/C VGND VGND VPWR VPWR _3539_/X sky130_fd_sc_hd__or2_2
Xhold886 _6732_/Q VGND VGND VPWR VPWR hold886/X sky130_fd_sc_hd__dlygate4sd3_1
Xhold897 _6025_/X VGND VGND VPWR VPWR _7029_/D sky130_fd_sc_hd__dlygate4sd3_1
XFILLER_27_1039 VGND VGND VPWR VPWR sky130_fd_sc_hd__decap_3
X_6258_ _6959_/CLK _6258_/D load_slew801/X VGND VGND VPWR VPWR _6258_/Q sky130_fd_sc_hd__dfrtp_2
XFILLER_67_27 VGND VGND VPWR VPWR sky130_fd_sc_hd__decap_3
XFILLER_44_1320 VGND VGND VPWR VPWR sky130_fd_sc_hd__decap_3
XTAP_TAPCELL_ROW_4_300 VGND VPWR sky130_fd_sc_hd__tapvpwrvgnd_1
XTAP_TAPCELL_ROW_51_1521 VGND VPWR sky130_fd_sc_hd__tapvpwrvgnd_1
XTAP_TAPCELL_ROW_51_1532 VGND VPWR sky130_fd_sc_hd__tapvpwrvgnd_1
XTAP_TAPCELL_ROW_4_311 VGND VPWR sky130_fd_sc_hd__tapvpwrvgnd_1
XFILLER_44_1353 VGND VGND VPWR VPWR sky130_fd_sc_hd__decap_3
X_5209_ _6411_/Q wire105/X _5208_/X VGND VGND VPWR VPWR _6411_/D sky130_fd_sc_hd__a21o_2
X_6189_ _7040_/CLK _6189_/D wire715/X VGND VGND VPWR VPWR _6189_/Q sky130_fd_sc_hd__dfrtp_2
Xhold1520 _6526_/Q VGND VGND VPWR VPWR _5414_/A1 sky130_fd_sc_hd__dlygate4sd3_1
XFILLER_29_223 VGND VGND VPWR VPWR sky130_fd_sc_hd__fill_1
Xhold1531 _6589_/Q VGND VGND VPWR VPWR _5477_/A1 sky130_fd_sc_hd__dlygate4sd3_1
Xhold1542 _6678_/Q VGND VGND VPWR VPWR _5607_/B2 sky130_fd_sc_hd__dlygate4sd3_1
XFILLER_44_1397 VGND VGND VPWR VPWR sky130_fd_sc_hd__decap_3
Xhold1553 _6653_/Q VGND VGND VPWR VPWR _5575_/B2 sky130_fd_sc_hd__dlygate4sd3_1
XFILLER_79_1416 VGND VGND VPWR VPWR sky130_fd_sc_hd__decap_3
XFILLER_45_705 VGND VGND VPWR VPWR sky130_fd_sc_hd__decap_3
XFILLER_57_576 VGND VGND VPWR VPWR sky130_fd_sc_hd__fill_2
Xhold1564 _6657_/Q VGND VGND VPWR VPWR _5583_/A1 sky130_fd_sc_hd__dlygate4sd3_1
XFILLER_79_1449 VGND VGND VPWR VPWR sky130_fd_sc_hd__decap_3
XFILLER_72_513 VGND VGND VPWR VPWR sky130_fd_sc_hd__decap_3
XTAP_TAPCELL_ROW_28_925 VGND VPWR sky130_fd_sc_hd__tapvpwrvgnd_1
XFILLER_45_738 VGND VGND VPWR VPWR sky130_fd_sc_hd__decap_3
XFILLER_57_598 VGND VGND VPWR VPWR sky130_fd_sc_hd__decap_3
XTAP_TAPCELL_ROW_28_936 VGND VPWR sky130_fd_sc_hd__tapvpwrvgnd_1
XFILLER_44_248 VGND VGND VPWR VPWR sky130_fd_sc_hd__decap_3
XFILLER_77_1151 VGND VGND VPWR VPWR sky130_fd_sc_hd__decap_3
XFILLER_41_900 VGND VGND VPWR VPWR sky130_fd_sc_hd__fill_2
XFILLER_16_53 VGND VGND VPWR VPWR sky130_fd_sc_hd__decap_3
XTAP_TAPCELL_ROW_49_1472 VGND VPWR sky130_fd_sc_hd__tapvpwrvgnd_1
XTAP_TAPCELL_ROW_49_1483 VGND VPWR sky130_fd_sc_hd__tapvpwrvgnd_1
XFILLER_77_1195 VGND VGND VPWR VPWR sky130_fd_sc_hd__decap_3
XFILLER_25_495 VGND VGND VPWR VPWR sky130_fd_sc_hd__decap_3
XFILLER_13_646 VGND VGND VPWR VPWR sky130_fd_sc_hd__decap_3
XFILLER_40_421 VGND VGND VPWR VPWR sky130_fd_sc_hd__decap_3
XFILLER_16_1400 VGND VGND VPWR VPWR sky130_fd_sc_hd__decap_3
XTAP_TAPCELL_ROW_45_1358 VGND VPWR sky130_fd_sc_hd__tapvpwrvgnd_1
XFILLER_9_606 VGND VGND VPWR VPWR sky130_fd_sc_hd__decap_3
XTAP_TAPCELL_ROW_45_1369 VGND VPWR sky130_fd_sc_hd__tapvpwrvgnd_1
XFILLER_9_617 VGND VGND VPWR VPWR sky130_fd_sc_hd__fill_2
XFILLER_55_1460 VGND VGND VPWR VPWR sky130_fd_sc_hd__decap_3
XFILLER_51_1313 VGND VGND VPWR VPWR sky130_fd_sc_hd__decap_3
XFILLER_16_1444 VGND VGND VPWR VPWR sky130_fd_sc_hd__decap_3
XFILLER_51_1357 VGND VGND VPWR VPWR sky130_fd_sc_hd__decap_3
XFILLER_5_801 VGND VGND VPWR VPWR sky130_fd_sc_hd__decap_3
XFILLER_32_85 VGND VGND VPWR VPWR sky130_fd_sc_hd__decap_3
XTAP_TAPCELL_ROW_58_1708 VGND VPWR sky130_fd_sc_hd__tapvpwrvgnd_1
XTAP_TAPCELL_ROW_58_1719 VGND VPWR sky130_fd_sc_hd__tapvpwrvgnd_1
XFILLER_49_1242 VGND VGND VPWR VPWR sky130_fd_sc_hd__decap_3
XFILLER_10_1087 VGND VGND VPWR VPWR sky130_fd_sc_hd__decap_3
XFILLER_49_1275 VGND VGND VPWR VPWR sky130_fd_sc_hd__decap_3
XFILLER_0_561 VGND VGND VPWR VPWR sky130_fd_sc_hd__decap_3
XFILLER_23_1404 VGND VGND VPWR VPWR sky130_fd_sc_hd__decap_3
XFILLER_62_1453 VGND VGND VPWR VPWR sky130_fd_sc_hd__decap_3
XFILLER_76_830 VGND VGND VPWR VPWR sky130_fd_sc_hd__decap_3
XFILLER_23_1437 VGND VGND VPWR VPWR sky130_fd_sc_hd__decap_3
XFILLER_76_863 VGND VGND VPWR VPWR sky130_fd_sc_hd__decap_3
XFILLER_36_716 VGND VGND VPWR VPWR sky130_fd_sc_hd__decap_3
XFILLER_48_587 VGND VGND VPWR VPWR sky130_fd_sc_hd__fill_1
XFILLER_48_598 VGND VGND VPWR VPWR sky130_fd_sc_hd__fill_2
XFILLER_1_1222 VGND VGND VPWR VPWR sky130_fd_sc_hd__decap_3
XFILLER_1_1233 VGND VGND VPWR VPWR sky130_fd_sc_hd__decap_3
XFILLER_17_941 VGND VGND VPWR VPWR sky130_fd_sc_hd__decap_3
XFILLER_35_237 VGND VGND VPWR VPWR sky130_fd_sc_hd__decap_3
XFILLER_1_1266 VGND VGND VPWR VPWR sky130_fd_sc_hd__decap_3
XFILLER_17_974 VGND VGND VPWR VPWR sky130_fd_sc_hd__decap_3
XFILLER_16_473 VGND VGND VPWR VPWR sky130_fd_sc_hd__decap_3
XFILLER_44_782 VGND VGND VPWR VPWR sky130_fd_sc_hd__decap_3
XFILLER_73_81 VGND VGND VPWR VPWR sky130_fd_sc_hd__decap_3
XFILLER_56_1235 VGND VGND VPWR VPWR sky130_fd_sc_hd__decap_3
XFILLER_17_1208 VGND VGND VPWR VPWR sky130_fd_sc_hd__decap_3
XFILLER_43_281 VGND VGND VPWR VPWR sky130_fd_sc_hd__decap_3
X_3890_ _4040_/A1 wire154/X _4586_/B _3089_/B _6501_/Q VGND VGND VPWR VPWR _3890_/X
+ sky130_fd_sc_hd__a32o_2
XFILLER_31_443 VGND VGND VPWR VPWR sky130_fd_sc_hd__decap_3
XFILLER_32_966 VGND VGND VPWR VPWR sky130_fd_sc_hd__decap_3
XFILLER_56_1279 VGND VGND VPWR VPWR sky130_fd_sc_hd__decap_3
X_5560_ _6361_/Q _5566_/A2 _5560_/B1 wire331/X VGND VGND VPWR VPWR _6643_/D sky130_fd_sc_hd__a22o_2
XFILLER_78_3 VGND VGND VPWR VPWR sky130_fd_sc_hd__decap_3
X_4511_ _4534_/B _4865_/B VGND VGND VPWR VPWR _4511_/Y sky130_fd_sc_hd__nor2_2
XFILLER_8_661 VGND VGND VPWR VPWR sky130_fd_sc_hd__decap_3
X_5491_ _6600_/Q _5489_/Y _5490_/X VGND VGND VPWR VPWR _6600_/D sky130_fd_sc_hd__a21o_2
XFILLER_7_193 VGND VGND VPWR VPWR sky130_fd_sc_hd__decap_3
X_4442_ _6851_/Q _4805_/A2 _4744_/B1 _4441_/X VGND VGND VPWR VPWR _4442_/X sky130_fd_sc_hd__a211o_2
XFILLER_67_1331 VGND VGND VPWR VPWR sky130_fd_sc_hd__decap_3
XFILLER_28_1315 VGND VGND VPWR VPWR sky130_fd_sc_hd__fill_1
X_4373_ _4756_/A1 _4370_/X _4371_/Y _4372_/X _4558_/A VGND VGND VPWR VPWR _4373_/X
+ sky130_fd_sc_hd__o221a_2
XFILLER_28_1326 VGND VGND VPWR VPWR sky130_fd_sc_hd__decap_3
XFILLER_67_1375 VGND VGND VPWR VPWR sky130_fd_sc_hd__decap_3
Xfanout607 wire613/X VGND VGND VPWR VPWR wire608/A sky130_fd_sc_hd__clkdlybuf4s25_1
XFILLER_8_1409 VGND VGND VPWR VPWR sky130_fd_sc_hd__decap_3
X_6112_ _7035_/CLK _6112_/D load_slew843/X VGND VGND VPWR VPWR _6112_/Q sky130_fd_sc_hd__dfrtp_2
Xfanout618 input5/X VGND VGND VPWR VPWR _5910_/A0 sky130_fd_sc_hd__clkdlybuf4s25_1
X_3324_ _6289_/Q _6393_/Q VGND VGND VPWR VPWR _3324_/X sky130_fd_sc_hd__xor2_2
X_7092_ _7092_/CLK _7092_/D fanout678/X VGND VGND VPWR VPWR _7092_/Q sky130_fd_sc_hd__dfrtp_2
XFILLER_28_1359 VGND VGND VPWR VPWR sky130_fd_sc_hd__decap_3
Xfanout629 _5825_/A0 VGND VGND VPWR VPWR _5917_/A1 sky130_fd_sc_hd__clkdlybuf4s25_1
XFILLER_63_1239 VGND VGND VPWR VPWR sky130_fd_sc_hd__decap_3
X_6043_ _6043_/A0 _7047_/Q _6048_/S VGND VGND VPWR VPWR _6043_/X sky130_fd_sc_hd__mux2_1
XFILLER_6_1111 VGND VGND VPWR VPWR sky130_fd_sc_hd__decap_3
X_3255_ hold974/X _3254_/X _3377_/S VGND VGND VPWR VPWR _6101_/D sky130_fd_sc_hd__mux2_1
XFILLER_67_841 VGND VGND VPWR VPWR sky130_fd_sc_hd__decap_3
XFILLER_6_1144 VGND VGND VPWR VPWR sky130_fd_sc_hd__decap_3
XFILLER_6_1155 VGND VGND VPWR VPWR sky130_fd_sc_hd__decap_3
XFILLER_2_1008 VGND VGND VPWR VPWR sky130_fd_sc_hd__decap_3
X_3186_ _6951_/Q _6959_/Q _3191_/S VGND VGND VPWR VPWR _3186_/X sky130_fd_sc_hd__mux2_1
XFILLER_66_351 VGND VGND VPWR VPWR sky130_fd_sc_hd__decap_3
XFILLER_27_716 VGND VGND VPWR VPWR sky130_fd_sc_hd__decap_3
XFILLER_39_576 VGND VGND VPWR VPWR sky130_fd_sc_hd__decap_3
XFILLER_54_502 VGND VGND VPWR VPWR sky130_fd_sc_hd__fill_2
XFILLER_67_885 VGND VGND VPWR VPWR sky130_fd_sc_hd__decap_3
XFILLER_6_1188 VGND VGND VPWR VPWR sky130_fd_sc_hd__decap_3
XFILLER_66_373 VGND VGND VPWR VPWR sky130_fd_sc_hd__decap_3
X_6945_ _7025_/CLK _6945_/D load_slew728/X VGND VGND VPWR VPWR _6945_/Q sky130_fd_sc_hd__dfrtp_2
XFILLER_39_1422 VGND VGND VPWR VPWR sky130_fd_sc_hd__decap_3
XFILLER_74_1335 VGND VGND VPWR VPWR sky130_fd_sc_hd__decap_3
XFILLER_22_410 VGND VGND VPWR VPWR sky130_fd_sc_hd__decap_3
XFILLER_39_1455 VGND VGND VPWR VPWR sky130_fd_sc_hd__fill_1
XFILLER_22_421 VGND VGND VPWR VPWR sky130_fd_sc_hd__fill_1
XFILLER_39_1466 VGND VGND VPWR VPWR sky130_fd_sc_hd__decap_3
X_6876_ _7007_/CLK _6876_/D fanout823/X VGND VGND VPWR VPWR _6876_/Q sky130_fd_sc_hd__dfrtp_2
XFILLER_74_1368 VGND VGND VPWR VPWR sky130_fd_sc_hd__decap_3
XFILLER_35_1319 VGND VGND VPWR VPWR sky130_fd_sc_hd__decap_3
XFILLER_74_1379 VGND VGND VPWR VPWR sky130_fd_sc_hd__decap_3
XFILLER_50_752 VGND VGND VPWR VPWR sky130_fd_sc_hd__decap_3
XFILLER_22_454 VGND VGND VPWR VPWR sky130_fd_sc_hd__decap_3
XFILLER_50_763 VGND VGND VPWR VPWR sky130_fd_sc_hd__decap_3
X_5827_ _5901_/A0 _5827_/A1 _5831_/S VGND VGND VPWR VPWR _6845_/D sky130_fd_sc_hd__mux2_1
XFILLER_23_999 VGND VGND VPWR VPWR sky130_fd_sc_hd__decap_3
XFILLER_50_785 VGND VGND VPWR VPWR sky130_fd_sc_hd__decap_3
XFILLER_22_498 VGND VGND VPWR VPWR sky130_fd_sc_hd__fill_1
X_5758_ _7068_/Q _5758_/B _5758_/C VGND VGND VPWR VPWR _5766_/S sky130_fd_sc_hd__or3_2
XTAP_TAPCELL_ROW_40_1233 VGND VPWR sky130_fd_sc_hd__tapvpwrvgnd_1
XTAP_TAPCELL_ROW_40_1244 VGND VPWR sky130_fd_sc_hd__tapvpwrvgnd_1
XFILLER_5_108 VGND VGND VPWR VPWR sky130_fd_sc_hd__decap_3
X_4709_ _4783_/B _3717_/A _4532_/C _4665_/X _6558_/Q VGND VGND VPWR VPWR _4709_/X
+ sky130_fd_sc_hd__a32o_2
XFILLER_5_119 VGND VGND VPWR VPWR sky130_fd_sc_hd__decap_3
X_5689_ _5689_/A0 _5901_/A0 _5693_/S VGND VGND VPWR VPWR _6741_/D sky130_fd_sc_hd__mux2_1
XFILLER_11_1363 VGND VGND VPWR VPWR sky130_fd_sc_hd__decap_3
XFILLER_78_15 VGND VGND VPWR VPWR sky130_fd_sc_hd__decap_3
XTAP_TAPCELL_ROW_9_425 VGND VPWR sky130_fd_sc_hd__tapvpwrvgnd_1
XTAP_TAPCELL_ROW_9_436 VGND VPWR sky130_fd_sc_hd__tapvpwrvgnd_1
XFILLER_11_1396 VGND VGND VPWR VPWR sky130_fd_sc_hd__decap_3
XTAP_TAPCELL_ROW_9_447 VGND VPWR sky130_fd_sc_hd__tapvpwrvgnd_1
XFILLER_2_837 VGND VGND VPWR VPWR sky130_fd_sc_hd__decap_3
XFILLER_1_314 VGND VGND VPWR VPWR sky130_fd_sc_hd__decap_3
XFILLER_46_1415 VGND VGND VPWR VPWR sky130_fd_sc_hd__decap_3
XFILLER_78_59 VGND VGND VPWR VPWR sky130_fd_sc_hd__decap_3
XTAP_TAPCELL_ROW_38_1184 VGND VPWR sky130_fd_sc_hd__tapvpwrvgnd_1
XFILLER_1_358 VGND VGND VPWR VPWR sky130_fd_sc_hd__decap_3
XFILLER_46_1459 VGND VGND VPWR VPWR sky130_fd_sc_hd__decap_3
XTAP_TAPCELL_ROW_38_1195 VGND VPWR sky130_fd_sc_hd__tapvpwrvgnd_1
XFILLER_77_638 VGND VGND VPWR VPWR sky130_fd_sc_hd__decap_3
XFILLER_76_126 VGND VGND VPWR VPWR sky130_fd_sc_hd__decap_3
XFILLER_57_340 VGND VGND VPWR VPWR sky130_fd_sc_hd__decap_3
XFILLER_44_1194 VGND VGND VPWR VPWR sky130_fd_sc_hd__fill_1
XFILLER_79_1213 VGND VGND VPWR VPWR sky130_fd_sc_hd__decap_3
Xhold1350 _6639_/Q VGND VGND VPWR VPWR _5556_/B1 sky130_fd_sc_hd__dlygate4sd3_1
Xhold1361 _6916_/Q VGND VGND VPWR VPWR _5909_/A1 sky130_fd_sc_hd__dlygate4sd3_1
Xhold1372 _6892_/Q VGND VGND VPWR VPWR _5882_/A1 sky130_fd_sc_hd__dlygate4sd3_1
Xhold1383 _6824_/Q VGND VGND VPWR VPWR _5800_/A1 sky130_fd_sc_hd__dlygate4sd3_1
XFILLER_45_535 VGND VGND VPWR VPWR sky130_fd_sc_hd__decap_3
XFILLER_79_1257 VGND VGND VPWR VPWR sky130_fd_sc_hd__decap_3
XFILLER_17_237 VGND VGND VPWR VPWR sky130_fd_sc_hd__fill_1
XFILLER_27_63 VGND VGND VPWR VPWR sky130_fd_sc_hd__decap_3
Xhold1394 _6826_/Q VGND VGND VPWR VPWR _5806_/A1 sky130_fd_sc_hd__dlygate4sd3_1
XFILLER_73_866 VGND VGND VPWR VPWR sky130_fd_sc_hd__decap_3
XFILLER_72_365 VGND VGND VPWR VPWR sky130_fd_sc_hd__decap_3
XFILLER_60_505 VGND VGND VPWR VPWR sky130_fd_sc_hd__decap_3
XFILLER_26_760 VGND VGND VPWR VPWR sky130_fd_sc_hd__decap_3
XFILLER_14_922 VGND VGND VPWR VPWR sky130_fd_sc_hd__fill_2
XFILLER_14_944 VGND VGND VPWR VPWR sky130_fd_sc_hd__fill_1
XFILLER_25_292 VGND VGND VPWR VPWR sky130_fd_sc_hd__decap_3
XFILLER_41_741 VGND VGND VPWR VPWR sky130_fd_sc_hd__decap_3
XFILLER_14_966 VGND VGND VPWR VPWR sky130_fd_sc_hd__decap_3
XFILLER_53_1419 VGND VGND VPWR VPWR sky130_fd_sc_hd__decap_3
XFILLER_13_465 VGND VGND VPWR VPWR sky130_fd_sc_hd__decap_3
XFILLER_41_774 VGND VGND VPWR VPWR sky130_fd_sc_hd__decap_3
XFILLER_9_414 VGND VGND VPWR VPWR sky130_fd_sc_hd__decap_3
XFILLER_40_251 VGND VGND VPWR VPWR sky130_fd_sc_hd__fill_1
XFILLER_40_262 VGND VGND VPWR VPWR sky130_fd_sc_hd__fill_1
XFILLER_41_785 VGND VGND VPWR VPWR sky130_fd_sc_hd__decap_3
XFILLER_16_1241 VGND VGND VPWR VPWR sky130_fd_sc_hd__decap_3
XFILLER_43_95 VGND VGND VPWR VPWR sky130_fd_sc_hd__decap_3
XFILLER_51_1121 VGND VGND VPWR VPWR sky130_fd_sc_hd__fill_1
XFILLER_9_469 VGND VGND VPWR VPWR sky130_fd_sc_hd__decap_3
XFILLER_16_1285 VGND VGND VPWR VPWR sky130_fd_sc_hd__decap_3
XFILLER_5_620 VGND VGND VPWR VPWR sky130_fd_sc_hd__decap_3
XFILLER_64_9 VGND VGND VPWR VPWR sky130_fd_sc_hd__decap_3
XFILLER_5_642 VGND VGND VPWR VPWR sky130_fd_sc_hd__decap_3
XFILLER_4_141 VGND VGND VPWR VPWR sky130_fd_sc_hd__decap_3
XFILLER_4_12 VGND VGND VPWR VPWR sky130_fd_sc_hd__decap_3
XFILLER_49_1061 VGND VGND VPWR VPWR sky130_fd_sc_hd__decap_3
XFILLER_4_56 VGND VGND VPWR VPWR sky130_fd_sc_hd__decap_3
XFILLER_7_1431 VGND VGND VPWR VPWR sky130_fd_sc_hd__decap_3
XFILLER_1_892 VGND VGND VPWR VPWR sky130_fd_sc_hd__decap_3
XFILLER_49_830 VGND VGND VPWR VPWR sky130_fd_sc_hd__decap_3
XFILLER_62_1250 VGND VGND VPWR VPWR sky130_fd_sc_hd__decap_3
XFILLER_0_380 VGND VGND VPWR VPWR sky130_fd_sc_hd__decap_3
XFILLER_27_1381 VGND VGND VPWR VPWR sky130_fd_sc_hd__decap_3
XFILLER_62_1261 VGND VGND VPWR VPWR sky130_fd_sc_hd__decap_3
X_3040_ _7081_/Q VGND VGND VPWR VPWR _3488_/B sky130_fd_sc_hd__inv_2
XFILLER_67_159 VGND VGND VPWR VPWR sky130_fd_sc_hd__fill_1
XFILLER_23_1245 VGND VGND VPWR VPWR sky130_fd_sc_hd__decap_3
XFILLER_49_874 VGND VGND VPWR VPWR sky130_fd_sc_hd__fill_1
XFILLER_62_1294 VGND VGND VPWR VPWR sky130_fd_sc_hd__decap_3
XFILLER_3_1328 VGND VGND VPWR VPWR sky130_fd_sc_hd__decap_3
XTAP_TAPCELL_ROW_19_700 VGND VPWR sky130_fd_sc_hd__tapvpwrvgnd_1
XFILLER_23_1278 VGND VGND VPWR VPWR sky130_fd_sc_hd__decap_3
XFILLER_23_1289 VGND VGND VPWR VPWR sky130_fd_sc_hd__decap_3
XFILLER_1_1030 VGND VGND VPWR VPWR sky130_fd_sc_hd__decap_3
X_4991_ _6694_/Q _3060_/Y _5318_/S VGND VGND VPWR VPWR _4991_/X sky130_fd_sc_hd__mux2_1
XFILLER_64_899 VGND VGND VPWR VPWR sky130_fd_sc_hd__decap_3
XFILLER_1_1063 VGND VGND VPWR VPWR sky130_fd_sc_hd__fill_1
XFILLER_1_1074 VGND VGND VPWR VPWR sky130_fd_sc_hd__decap_3
X_6730_ _6858_/CLK _6730_/D fanout646/X VGND VGND VPWR VPWR _6730_/Q sky130_fd_sc_hd__dfrtp_2
X_3942_ _6246_/Q _4786_/B _3940_/X _3941_/X VGND VGND VPWR VPWR _4181_/B sky130_fd_sc_hd__o22a_2
XFILLER_51_549 VGND VGND VPWR VPWR sky130_fd_sc_hd__fill_1
XTAP_TAPCELL_ROW_80_2270 VGND VPWR sky130_fd_sc_hd__tapvpwrvgnd_1
XTAP_TAPCELL_ROW_80_2281 VGND VPWR sky130_fd_sc_hd__tapvpwrvgnd_1
XFILLER_56_1076 VGND VGND VPWR VPWR sky130_fd_sc_hd__decap_3
X_6661_ _7077_/CLK _6661_/D load_slew692/X VGND VGND VPWR VPWR _6661_/Q sky130_fd_sc_hd__dfrtp_2
X_3873_ _4152_/A _4240_/A VGND VGND VPWR VPWR _3874_/B sky130_fd_sc_hd__xnor2_2
XTAP_TAPCELL_ROW_80_2292 VGND VPWR sky130_fd_sc_hd__tapvpwrvgnd_1
X_5612_ _7095_/Q _7095_/D VGND VGND VPWR VPWR _6073_/D sky130_fd_sc_hd__nand2b_2
XFILLER_73_1390 VGND VGND VPWR VPWR sky130_fd_sc_hd__decap_3
XFILLER_31_284 VGND VGND VPWR VPWR sky130_fd_sc_hd__decap_3
XFILLER_34_1341 VGND VGND VPWR VPWR sky130_fd_sc_hd__decap_3
X_6592_ _7090_/CLK _6592_/D load_slew723/X VGND VGND VPWR VPWR _6592_/Q sky130_fd_sc_hd__dfrtp_2
XTAP_TAPCELL_ROW_30_975 VGND VPWR sky130_fd_sc_hd__tapvpwrvgnd_1
XFILLER_34_1385 VGND VGND VPWR VPWR sky130_fd_sc_hd__decap_3
X_5543_ _6344_/Q _5501_/B _5543_/B1 _5562_/B2 VGND VGND VPWR VPWR _6626_/D sky130_fd_sc_hd__a22o_2
XFILLER_69_1404 VGND VGND VPWR VPWR sky130_fd_sc_hd__decap_3
XTAP_TAPCELL_ROW_30_986 VGND VPWR sky130_fd_sc_hd__tapvpwrvgnd_1
XFILLER_30_1238 VGND VGND VPWR VPWR sky130_fd_sc_hd__decap_3
XFILLER_69_1437 VGND VGND VPWR VPWR sky130_fd_sc_hd__decap_3
X_5474_ _5474_/A1 _5474_/A2 _4860_/X VGND VGND VPWR VPWR _6586_/D sky130_fd_sc_hd__a21o_2
X_4425_ _6303_/Q _5358_/D _3304_/X _4780_/B2 VGND VGND VPWR VPWR _4425_/X sky130_fd_sc_hd__a22o_2
XFILLER_28_1123 VGND VGND VPWR VPWR sky130_fd_sc_hd__decap_3
XFILLER_67_1172 VGND VGND VPWR VPWR sky130_fd_sc_hd__decap_3
XFILLER_67_1183 VGND VGND VPWR VPWR sky130_fd_sc_hd__decap_3
X_4356_ _4547_/B _4356_/B VGND VGND VPWR VPWR _4768_/B sky130_fd_sc_hd__and2_2
XFILLER_8_1217 VGND VGND VPWR VPWR sky130_fd_sc_hd__decap_3
Xfanout415 _3207_/B2 VGND VGND VPWR VPWR _6081_/B sky130_fd_sc_hd__clkdlybuf4s25_1
Xfanout426 _3902_/B1 VGND VGND VPWR VPWR _3928_/B1 sky130_fd_sc_hd__clkdlybuf4s25_1
XFILLER_63_1036 VGND VGND VPWR VPWR sky130_fd_sc_hd__decap_3
XFILLER_48_29 VGND VGND VPWR VPWR sky130_fd_sc_hd__fill_1
Xfanout448 _4420_/C VGND VGND VPWR VPWR _4783_/B sky130_fd_sc_hd__clkdlybuf4s25_1
X_3307_ hold985/X _3306_/X _3435_/S VGND VGND VPWR VPWR _6127_/D sky130_fd_sc_hd__mux2_1
XFILLER_59_638 VGND VGND VPWR VPWR sky130_fd_sc_hd__decap_3
Xfanout459 _4654_/A1 VGND VGND VPWR VPWR _4885_/B1 sky130_fd_sc_hd__clkdlybuf4s25_1
X_7075_ _7076_/CLK _7075_/D load_slew679/X VGND VGND VPWR VPWR _7075_/Q sky130_fd_sc_hd__dfrtp_2
X_4287_ _6827_/Q _4862_/A2 _4766_/B1 _4286_/X VGND VGND VPWR VPWR _4287_/X sky130_fd_sc_hd__a211o_2
XFILLER_41_1301 VGND VGND VPWR VPWR sky130_fd_sc_hd__decap_3
X_6026_ _6026_/A0 _7030_/Q _6058_/S VGND VGND VPWR VPWR _6026_/X sky130_fd_sc_hd__mux2_1
XTAP_TAPCELL_ROW_33_1070 VGND VPWR sky130_fd_sc_hd__tapvpwrvgnd_1
XFILLER_41_1334 VGND VGND VPWR VPWR sky130_fd_sc_hd__decap_3
X_3238_ _6254_/Q _6350_/Q VGND VGND VPWR VPWR _3238_/X sky130_fd_sc_hd__xor2_2
XFILLER_80_1394 VGND VGND VPWR VPWR sky130_fd_sc_hd__decap_3
XFILLER_41_1345 VGND VGND VPWR VPWR sky130_fd_sc_hd__decap_3
XFILLER_39_362 VGND VGND VPWR VPWR sky130_fd_sc_hd__decap_3
XFILLER_41_1378 VGND VGND VPWR VPWR sky130_fd_sc_hd__decap_3
X_3169_ _7046_/Q _7054_/Q _3172_/S VGND VGND VPWR VPWR _3169_/X sky130_fd_sc_hd__mux2_1
XFILLER_66_192 VGND VGND VPWR VPWR sky130_fd_sc_hd__decap_3
XFILLER_15_708 VGND VGND VPWR VPWR sky130_fd_sc_hd__decap_3
XFILLER_54_365 VGND VGND VPWR VPWR sky130_fd_sc_hd__decap_3
XFILLER_14_218 VGND VGND VPWR VPWR sky130_fd_sc_hd__decap_3
XFILLER_39_1230 VGND VGND VPWR VPWR sky130_fd_sc_hd__fill_2
XFILLER_74_1132 VGND VGND VPWR VPWR sky130_fd_sc_hd__decap_3
X_6928_ _7056_/CLK _6928_/D fanout699/A VGND VGND VPWR VPWR _6928_/Q sky130_fd_sc_hd__dfrtp_2
XFILLER_35_590 VGND VGND VPWR VPWR sky130_fd_sc_hd__fill_2
XFILLER_70_869 VGND VGND VPWR VPWR sky130_fd_sc_hd__decap_3
XFILLER_39_1263 VGND VGND VPWR VPWR sky130_fd_sc_hd__decap_3
Xfanout22 wire23/X VGND VGND VPWR VPWR _4277_/B sky130_fd_sc_hd__clkdlybuf4s25_1
XFILLER_80_27 VGND VGND VPWR VPWR sky130_fd_sc_hd__fill_1
Xfanout44 fanout47/X VGND VGND VPWR VPWR _4744_/B1 sky130_fd_sc_hd__clkdlybuf4s25_1
XFILLER_74_1176 VGND VGND VPWR VPWR sky130_fd_sc_hd__decap_3
XFILLER_22_251 VGND VGND VPWR VPWR sky130_fd_sc_hd__fill_1
XFILLER_80_38 VGND VGND VPWR VPWR sky130_fd_sc_hd__decap_3
XFILLER_23_785 VGND VGND VPWR VPWR sky130_fd_sc_hd__decap_3
X_6859_ _6923_/CLK _6859_/D fanout802/X VGND VGND VPWR VPWR _6859_/Q sky130_fd_sc_hd__dfrtp_2
Xfanout55 _4775_/A2 VGND VGND VPWR VPWR _4427_/S sky130_fd_sc_hd__clkdlybuf4s25_1
Xfanout66 _4759_/A2 VGND VGND VPWR VPWR _4745_/A2 sky130_fd_sc_hd__clkdlybuf4s25_1
XFILLER_13_21 VGND VGND VPWR VPWR sky130_fd_sc_hd__decap_3
XFILLER_10_424 VGND VGND VPWR VPWR sky130_fd_sc_hd__decap_3
Xfanout99 _5787_/Y VGND VGND VPWR VPWR _5841_/C sky130_fd_sc_hd__clkdlybuf4s25_1
XFILLER_52_1441 VGND VGND VPWR VPWR sky130_fd_sc_hd__decap_3
Xwire827 wire827/A VGND VGND VPWR VPWR wire827/X sky130_fd_sc_hd__clkbuf_4
XFILLER_13_54 VGND VGND VPWR VPWR sky130_fd_sc_hd__fill_2
XFILLER_13_1425 VGND VGND VPWR VPWR sky130_fd_sc_hd__decap_3
XFILLER_11_1171 VGND VGND VPWR VPWR sky130_fd_sc_hd__decap_3
XFILLER_8_3 VGND VGND VPWR VPWR sky130_fd_sc_hd__decap_3
XFILLER_1_111 VGND VGND VPWR VPWR sky130_fd_sc_hd__fill_1
XFILLER_1_122 VGND VGND VPWR VPWR sky130_fd_sc_hd__decap_3
XFILLER_2_645 VGND VGND VPWR VPWR sky130_fd_sc_hd__decap_3
XFILLER_78_903 VGND VGND VPWR VPWR sky130_fd_sc_hd__decap_3
XFILLER_77_402 VGND VGND VPWR VPWR sky130_fd_sc_hd__decap_3
XFILLER_1_155 VGND VGND VPWR VPWR sky130_fd_sc_hd__decap_3
XFILLER_2_678 VGND VGND VPWR VPWR sky130_fd_sc_hd__decap_3
XFILLER_46_1256 VGND VGND VPWR VPWR sky130_fd_sc_hd__decap_3
XFILLER_46_1267 VGND VGND VPWR VPWR sky130_fd_sc_hd__decap_3
XFILLER_77_446 VGND VGND VPWR VPWR sky130_fd_sc_hd__fill_2
XFILLER_1_199 VGND VGND VPWR VPWR sky130_fd_sc_hd__decap_3
XFILLER_49_137 VGND VGND VPWR VPWR sky130_fd_sc_hd__decap_3
XFILLER_46_811 VGND VGND VPWR VPWR sky130_fd_sc_hd__fill_1
XFILLER_20_1418 VGND VGND VPWR VPWR sky130_fd_sc_hd__decap_3
XFILLER_46_822 VGND VGND VPWR VPWR sky130_fd_sc_hd__decap_3
XFILLER_45_310 VGND VGND VPWR VPWR sky130_fd_sc_hd__decap_3
XFILLER_20_1429 VGND VGND VPWR VPWR sky130_fd_sc_hd__decap_3
Xclkbuf_leaf_84_clk clkbuf_leaf_2_clk/A VGND VGND VPWR VPWR _6925_/CLK sky130_fd_sc_hd__clkbuf_8
Xhold1180 _6980_/Q VGND VGND VPWR VPWR _5976_/A1 sky130_fd_sc_hd__dlygate4sd3_1
Xhold1191 _6865_/Q VGND VGND VPWR VPWR _5849_/A0 sky130_fd_sc_hd__dlygate4sd3_1
XFILLER_2_1350 VGND VGND VPWR VPWR sky130_fd_sc_hd__decap_3
XFILLER_45_354 VGND VGND VPWR VPWR sky130_fd_sc_hd__decap_3
XFILLER_79_1076 VGND VGND VPWR VPWR sky130_fd_sc_hd__decap_3
XFILLER_33_505 VGND VGND VPWR VPWR sky130_fd_sc_hd__decap_3
XFILLER_72_162 VGND VGND VPWR VPWR sky130_fd_sc_hd__decap_3
XFILLER_2_1394 VGND VGND VPWR VPWR sky130_fd_sc_hd__decap_3
XFILLER_18_1303 VGND VGND VPWR VPWR sky130_fd_sc_hd__decap_3
XFILLER_57_1363 VGND VGND VPWR VPWR sky130_fd_sc_hd__decap_3
XFILLER_60_357 VGND VGND VPWR VPWR sky130_fd_sc_hd__decap_3
XFILLER_18_1347 VGND VGND VPWR VPWR sky130_fd_sc_hd__decap_3
XFILLER_57_1396 VGND VGND VPWR VPWR sky130_fd_sc_hd__decap_3
XFILLER_13_273 VGND VGND VPWR VPWR sky130_fd_sc_hd__decap_3
XFILLER_13_284 VGND VGND VPWR VPWR sky130_fd_sc_hd__fill_1
XFILLER_16_1093 VGND VGND VPWR VPWR sky130_fd_sc_hd__fill_1
Xclkload14 _7073_/CLK VGND VGND VPWR VPWR clkload14/X sky130_fd_sc_hd__clkbuf_4
XTAP_TAPCELL_ROW_11_474 VGND VPWR sky130_fd_sc_hd__tapvpwrvgnd_1
XFILLER_62_6 VGND VGND VPWR VPWR sky130_fd_sc_hd__fill_1
Xclkload25 _7077_/CLK VGND VGND VPWR VPWR clkload25/X sky130_fd_sc_hd__clkbuf_8
XTAP_TAPCELL_ROW_11_485 VGND VPWR sky130_fd_sc_hd__tapvpwrvgnd_1
Xclkload36 _6918_/CLK VGND VGND VPWR VPWR clkload36/X sky130_fd_sc_hd__clkbuf_8
XTAP_TAPCELL_ROW_11_496 VGND VPWR sky130_fd_sc_hd__tapvpwrvgnd_1
Xclkload47 _6987_/CLK VGND VGND VPWR VPWR clkload47/X sky130_fd_sc_hd__clkbuf_8
XFILLER_6_962 VGND VGND VPWR VPWR sky130_fd_sc_hd__decap_3
Xclkload58 _7004_/CLK VGND VGND VPWR VPWR clkload58/X sky130_fd_sc_hd__clkbuf_4
XFILLER_6_984 VGND VGND VPWR VPWR sky130_fd_sc_hd__fill_1
XFILLER_5_461 VGND VGND VPWR VPWR sky130_fd_sc_hd__decap_3
XFILLER_29_1410 VGND VGND VPWR VPWR sky130_fd_sc_hd__decap_3
X_4210_ _4210_/A _4293_/A VGND VGND VPWR VPWR _4211_/B sky130_fd_sc_hd__xor2_2
XFILLER_64_1312 VGND VGND VPWR VPWR sky130_fd_sc_hd__decap_3
XFILLER_29_1443 VGND VGND VPWR VPWR sky130_fd_sc_hd__decap_3
XFILLER_64_1323 VGND VGND VPWR VPWR sky130_fd_sc_hd__decap_3
XFILLER_69_903 VGND VGND VPWR VPWR sky130_fd_sc_hd__fill_2
X_5190_ _6742_/Q _5350_/S VGND VGND VPWR VPWR _5190_/Y sky130_fd_sc_hd__nor2_2
XFILLER_25_1307 VGND VGND VPWR VPWR sky130_fd_sc_hd__decap_3
XFILLER_64_1356 VGND VGND VPWR VPWR sky130_fd_sc_hd__decap_3
X_4141_ _4292_/A _4258_/B VGND VGND VPWR VPWR _4221_/A sky130_fd_sc_hd__xnor2_2
X_4072_ _6594_/Q _4732_/A _3485_/B VGND VGND VPWR VPWR _4072_/X sky130_fd_sc_hd__a21bo_2
XFILLER_7_1272 VGND VGND VPWR VPWR sky130_fd_sc_hd__decap_3
XFILLER_62_1080 VGND VGND VPWR VPWR sky130_fd_sc_hd__decap_3
XFILLER_37_811 VGND VGND VPWR VPWR sky130_fd_sc_hd__decap_3
XFILLER_3_1136 VGND VGND VPWR VPWR sky130_fd_sc_hd__decap_3
Xclkbuf_leaf_75_clk clkload4/A VGND VGND VPWR VPWR _7022_/CLK sky130_fd_sc_hd__clkbuf_8
XFILLER_3_1169 VGND VGND VPWR VPWR sky130_fd_sc_hd__decap_3
XFILLER_24_505 VGND VGND VPWR VPWR sky130_fd_sc_hd__decap_3
XFILLER_36_365 VGND VGND VPWR VPWR sky130_fd_sc_hd__decap_3
XFILLER_63_151 VGND VGND VPWR VPWR sky130_fd_sc_hd__fill_1
XFILLER_52_825 VGND VGND VPWR VPWR sky130_fd_sc_hd__decap_3
XFILLER_58_1138 VGND VGND VPWR VPWR sky130_fd_sc_hd__decap_3
X_4974_ _6386_/Q _5228_/B VGND VGND VPWR VPWR _4974_/X sky130_fd_sc_hd__or2_2
XFILLER_51_335 VGND VGND VPWR VPWR sky130_fd_sc_hd__fill_1
XFILLER_52_869 VGND VGND VPWR VPWR sky130_fd_sc_hd__decap_3
XFILLER_75_1452 VGND VGND VPWR VPWR sky130_fd_sc_hd__decap_3
XFILLER_36_1403 VGND VGND VPWR VPWR sky130_fd_sc_hd__decap_3
XFILLER_75_1463 VGND VGND VPWR VPWR sky130_fd_sc_hd__decap_3
X_6713_ _7065_/CLK _6713_/D load_slew736/X VGND VGND VPWR VPWR _6713_/Q sky130_fd_sc_hd__dfrtp_2
XFILLER_71_1316 VGND VGND VPWR VPWR sky130_fd_sc_hd__decap_3
X_3925_ _6294_/Q _3948_/A2 _3948_/B1 _6270_/Q _3948_/C1 VGND VGND VPWR VPWR _3925_/X
+ sky130_fd_sc_hd__a221o_2
XFILLER_36_1447 VGND VGND VPWR VPWR sky130_fd_sc_hd__decap_3
XFILLER_20_722 VGND VGND VPWR VPWR sky130_fd_sc_hd__decap_3
X_6644_ _7012_/CLK _6644_/D load_slew801/X VGND VGND VPWR VPWR _6644_/Q sky130_fd_sc_hd__dfrtp_2
X_3856_ _3913_/A _3913_/B VGND VGND VPWR VPWR _3856_/Y sky130_fd_sc_hd__nand2_2
Xclkload8 clkload8/A VGND VGND VPWR VPWR clkload8/X sky130_fd_sc_hd__clkbuf_4
XFILLER_20_755 VGND VGND VPWR VPWR sky130_fd_sc_hd__fill_1
X_6575_ _7041_/CLK _6575_/D load_slew726/X VGND VGND VPWR VPWR _6575_/Q sky130_fd_sc_hd__dfrtp_2
X_3787_ _3787_/A _3787_/B VGND VGND VPWR VPWR _3788_/A sky130_fd_sc_hd__xnor2_2
XFILLER_30_1035 VGND VGND VPWR VPWR sky130_fd_sc_hd__fill_1
XFILLER_69_1201 VGND VGND VPWR VPWR sky130_fd_sc_hd__decap_3
X_5526_ _6612_/Q _6617_/Q VGND VGND VPWR VPWR _5526_/X sky130_fd_sc_hd__or2_2
XTAP_TAPCELL_ROW_76_2169 VGND VPWR sky130_fd_sc_hd__tapvpwrvgnd_1
XFILLER_69_1245 VGND VGND VPWR VPWR sky130_fd_sc_hd__decap_3
X_5457_ _5457_/A1 _5485_/A2 _4734_/X VGND VGND VPWR VPWR _6569_/D sky130_fd_sc_hd__a21o_2
XFILLER_69_1278 VGND VGND VPWR VPWR sky130_fd_sc_hd__decap_3
XFILLER_69_1289 VGND VGND VPWR VPWR sky130_fd_sc_hd__decap_3
X_4408_ _6301_/Q _4408_/A2 _3300_/X _4765_/B2 VGND VGND VPWR VPWR _4408_/X sky130_fd_sc_hd__a22o_2
XTAP_TAPCELL_ROW_35_1110 VGND VPWR sky130_fd_sc_hd__tapvpwrvgnd_1
XTAP_TAPCELL_ROW_35_1121 VGND VPWR sky130_fd_sc_hd__tapvpwrvgnd_1
X_5388_ _5388_/A1 _5484_/A2 _3876_/X VGND VGND VPWR VPWR _6500_/D sky130_fd_sc_hd__a21o_2
XFILLER_59_402 VGND VGND VPWR VPWR sky130_fd_sc_hd__decap_3
XFILLER_43_1407 VGND VGND VPWR VPWR sky130_fd_sc_hd__decap_3
Xfanout234 _5933_/Y VGND VGND VPWR VPWR fanout234/X sky130_fd_sc_hd__clkdlybuf4s25_1
X_4339_ _6494_/Q _3483_/A _4831_/C1 _4338_/Y VGND VGND VPWR VPWR _4339_/X sky130_fd_sc_hd__o211a_2
Xfanout245 _5465_/A2 VGND VGND VPWR VPWR _5477_/A2 sky130_fd_sc_hd__clkdlybuf4s25_1
XFILLER_8_1058 VGND VGND VPWR VPWR sky130_fd_sc_hd__decap_3
XTAP_TAPCELL_ROW_31_1007 VGND VPWR sky130_fd_sc_hd__tapvpwrvgnd_1
Xfanout256 _4717_/A VGND VGND VPWR VPWR _4549_/B sky130_fd_sc_hd__clkdlybuf4s25_1
XFILLER_59_446 VGND VGND VPWR VPWR sky130_fd_sc_hd__fill_2
XTAP_TAPCELL_ROW_31_1018 VGND VPWR sky130_fd_sc_hd__tapvpwrvgnd_1
Xfanout278 _3960_/Y VGND VGND VPWR VPWR _4518_/A sky130_fd_sc_hd__clkdlybuf4s25_1
X_7058_ _7092_/CLK _7058_/D load_slew690/X VGND VGND VPWR VPWR _7058_/Q sky130_fd_sc_hd__dfrtp_2
XFILLER_75_928 VGND VGND VPWR VPWR sky130_fd_sc_hd__fill_1
XFILLER_75_27 VGND VGND VPWR VPWR sky130_fd_sc_hd__decap_3
XFILLER_74_405 VGND VGND VPWR VPWR sky130_fd_sc_hd__decap_3
XFILLER_28_800 VGND VGND VPWR VPWR sky130_fd_sc_hd__decap_3
Xfanout289 _4758_/A2 VGND VGND VPWR VPWR _4263_/A2 sky130_fd_sc_hd__clkdlybuf4s25_1
XFILLER_80_1180 VGND VGND VPWR VPWR sky130_fd_sc_hd__decap_3
X_6009_ hold997/X _7013_/Q _6017_/S VGND VGND VPWR VPWR _6009_/X sky130_fd_sc_hd__mux2_1
XFILLER_74_449 VGND VGND VPWR VPWR sky130_fd_sc_hd__fill_2
XFILLER_41_1175 VGND VGND VPWR VPWR sky130_fd_sc_hd__fill_1
Xclkbuf_leaf_66_clk clkbuf_leaf_67_clk/A VGND VGND VPWR VPWR _7020_/CLK sky130_fd_sc_hd__clkbuf_8
XFILLER_28_855 VGND VGND VPWR VPWR sky130_fd_sc_hd__decap_3
XFILLER_39_192 VGND VGND VPWR VPWR sky130_fd_sc_hd__decap_3
XFILLER_41_1186 VGND VGND VPWR VPWR sky130_fd_sc_hd__fill_2
XFILLER_76_1205 VGND VGND VPWR VPWR sky130_fd_sc_hd__decap_3
XFILLER_15_505 VGND VGND VPWR VPWR sky130_fd_sc_hd__decap_3
XFILLER_15_516 VGND VGND VPWR VPWR sky130_fd_sc_hd__decap_3
XFILLER_76_1238 VGND VGND VPWR VPWR sky130_fd_sc_hd__decap_3
XFILLER_43_836 VGND VGND VPWR VPWR sky130_fd_sc_hd__decap_3
XFILLER_54_184 VGND VGND VPWR VPWR sky130_fd_sc_hd__decap_3
XFILLER_43_869 VGND VGND VPWR VPWR sky130_fd_sc_hd__decap_3
XFILLER_42_357 VGND VGND VPWR VPWR sky130_fd_sc_hd__decap_3
XFILLER_39_1060 VGND VGND VPWR VPWR sky130_fd_sc_hd__decap_3
XFILLER_39_1071 VGND VGND VPWR VPWR sky130_fd_sc_hd__fill_1
XTAP_TAPCELL_ROW_65_1884 VGND VPWR sky130_fd_sc_hd__tapvpwrvgnd_1
XFILLER_70_699 VGND VGND VPWR VPWR sky130_fd_sc_hd__fill_1
XTAP_TAPCELL_ROW_65_1895 VGND VPWR sky130_fd_sc_hd__tapvpwrvgnd_1
XFILLER_24_64 VGND VGND VPWR VPWR sky130_fd_sc_hd__decap_3
Xwire613 input7/X VGND VGND VPWR VPWR wire613/X sky130_fd_sc_hd__buf_2
XFILLER_13_1200 VGND VGND VPWR VPWR sky130_fd_sc_hd__decap_3
XFILLER_11_766 VGND VGND VPWR VPWR sky130_fd_sc_hd__decap_3
XFILLER_10_232 VGND VGND VPWR VPWR sky130_fd_sc_hd__decap_3
XFILLER_7_726 VGND VGND VPWR VPWR sky130_fd_sc_hd__fill_2
XTAP_TAPCELL_ROW_21_750 VGND VPWR sky130_fd_sc_hd__tapvpwrvgnd_1
XFILLER_10_265 VGND VGND VPWR VPWR sky130_fd_sc_hd__decap_3
XFILLER_13_1233 VGND VGND VPWR VPWR sky130_fd_sc_hd__decap_3
XFILLER_52_1282 VGND VGND VPWR VPWR sky130_fd_sc_hd__decap_3
XFILLER_10_287 VGND VGND VPWR VPWR sky130_fd_sc_hd__decap_3
XFILLER_6_247 VGND VGND VPWR VPWR sky130_fd_sc_hd__decap_3
XFILLER_13_1266 VGND VGND VPWR VPWR sky130_fd_sc_hd__decap_3
XFILLER_3_921 VGND VGND VPWR VPWR sky130_fd_sc_hd__decap_3
XFILLER_40_85 VGND VGND VPWR VPWR sky130_fd_sc_hd__decap_3
XFILLER_48_1329 VGND VGND VPWR VPWR sky130_fd_sc_hd__decap_3
XFILLER_3_965 VGND VGND VPWR VPWR sky130_fd_sc_hd__decap_3
XFILLER_66_928 VGND VGND VPWR VPWR sky130_fd_sc_hd__fill_1
XFILLER_4_1412 VGND VGND VPWR VPWR sky130_fd_sc_hd__decap_3
XFILLER_1_24 VGND VGND VPWR VPWR sky130_fd_sc_hd__decap_3
Xfanout790 fanout848/X VGND VGND VPWR VPWR fanout790/X sky130_fd_sc_hd__clkdlybuf4s25_1
XFILLER_65_427 VGND VGND VPWR VPWR sky130_fd_sc_hd__decap_3
XFILLER_24_1362 VGND VGND VPWR VPWR sky130_fd_sc_hd__decap_3
XFILLER_24_1373 VGND VGND VPWR VPWR sky130_fd_sc_hd__decap_3
XFILLER_1_57 VGND VGND VPWR VPWR sky130_fd_sc_hd__decap_3
XFILLER_65_449 VGND VGND VPWR VPWR sky130_fd_sc_hd__fill_2
XFILLER_4_1456 VGND VGND VPWR VPWR sky130_fd_sc_hd__decap_3
Xclkbuf_leaf_57_clk clkload4/A VGND VGND VPWR VPWR _6958_/CLK sky130_fd_sc_hd__clkbuf_8
XFILLER_20_1237 VGND VGND VPWR VPWR sky130_fd_sc_hd__decap_3
XFILLER_65_60 VGND VGND VPWR VPWR sky130_fd_sc_hd__decap_3
XFILLER_59_1425 VGND VGND VPWR VPWR sky130_fd_sc_hd__decap_3
XFILLER_18_365 VGND VGND VPWR VPWR sky130_fd_sc_hd__decap_3
XFILLER_73_482 VGND VGND VPWR VPWR sky130_fd_sc_hd__fill_1
XFILLER_61_633 VGND VGND VPWR VPWR sky130_fd_sc_hd__fill_1
XFILLER_2_1191 VGND VGND VPWR VPWR sky130_fd_sc_hd__decap_3
X_3710_ _4532_/B _3957_/B wire25/X VGND VGND VPWR VPWR _3711_/A sky130_fd_sc_hd__or3_2
X_4690_ _4888_/C1 _4687_/X _4688_/Y _4689_/X _4889_/A VGND VGND VPWR VPWR _4690_/X
+ sky130_fd_sc_hd__o221a_2
XFILLER_41_390 VGND VGND VPWR VPWR sky130_fd_sc_hd__fill_2
XFILLER_14_1019 VGND VGND VPWR VPWR sky130_fd_sc_hd__decap_3
XFILLER_53_1068 VGND VGND VPWR VPWR sky130_fd_sc_hd__fill_2
X_3641_ _3706_/A _3879_/A VGND VGND VPWR VPWR _3791_/A sky130_fd_sc_hd__xor2_2
XFILLER_70_1371 VGND VGND VPWR VPWR sky130_fd_sc_hd__fill_1
XFILLER_31_1322 VGND VGND VPWR VPWR sky130_fd_sc_hd__decap_3
XFILLER_70_1382 VGND VGND VPWR VPWR sky130_fd_sc_hd__decap_3
X_6360_ _6858_/CLK _6360_/D fanout644/X VGND VGND VPWR VPWR _6360_/Q sky130_fd_sc_hd__dfrtp_2
XFILLER_31_1366 VGND VGND VPWR VPWR sky130_fd_sc_hd__decap_3
XFILLER_60_3 VGND VGND VPWR VPWR sky130_fd_sc_hd__decap_3
X_3572_ _3570_/X _3571_/X _4355_/A VGND VGND VPWR VPWR _3572_/X sky130_fd_sc_hd__mux2_1
X_5311_ _6448_/Q _5310_/X _5327_/S VGND VGND VPWR VPWR _6448_/D sky130_fd_sc_hd__mux2_1
XFILLER_31_1399 VGND VGND VPWR VPWR sky130_fd_sc_hd__fill_1
X_6291_ clkload9/A _6291_/D fanout656/X VGND VGND VPWR VPWR _6291_/Q sky130_fd_sc_hd__dfrtp_2
XFILLER_66_1418 VGND VGND VPWR VPWR sky130_fd_sc_hd__decap_3
XFILLER_66_1429 VGND VGND VPWR VPWR sky130_fd_sc_hd__decap_3
X_5242_ _6422_/Q _5248_/A2 _5241_/X VGND VGND VPWR VPWR _6422_/D sky130_fd_sc_hd__a21o_2
XTAP_TAPCELL_ROW_71_2044 VGND VPWR sky130_fd_sc_hd__tapvpwrvgnd_1
XFILLER_9_1301 VGND VGND VPWR VPWR sky130_fd_sc_hd__decap_3
XFILLER_64_1120 VGND VGND VPWR VPWR sky130_fd_sc_hd__decap_3
XTAP_TAPCELL_ROW_71_2055 VGND VPWR sky130_fd_sc_hd__tapvpwrvgnd_1
XFILLER_29_1251 VGND VGND VPWR VPWR sky130_fd_sc_hd__decap_3
XFILLER_9_1334 VGND VGND VPWR VPWR sky130_fd_sc_hd__decap_3
XFILLER_9_1345 VGND VGND VPWR VPWR sky130_fd_sc_hd__decap_3
X_5173_ _6395_/Q _5257_/A2 _5041_/S _5172_/X VGND VGND VPWR VPWR _6395_/D sky130_fd_sc_hd__a22o_2
XFILLER_25_1115 VGND VGND VPWR VPWR sky130_fd_sc_hd__decap_3
XFILLER_29_1284 VGND VGND VPWR VPWR sky130_fd_sc_hd__decap_3
XFILLER_64_1164 VGND VGND VPWR VPWR sky130_fd_sc_hd__decap_3
XFILLER_29_1295 VGND VGND VPWR VPWR sky130_fd_sc_hd__decap_3
XFILLER_9_1378 VGND VGND VPWR VPWR sky130_fd_sc_hd__decap_3
XFILLER_25_1148 VGND VGND VPWR VPWR sky130_fd_sc_hd__decap_3
X_4124_ _6473_/Q _4330_/A2 _4382_/C1 _4123_/X VGND VGND VPWR VPWR _4124_/X sky130_fd_sc_hd__o211a_2
XFILLER_57_928 VGND VGND VPWR VPWR sky130_fd_sc_hd__decap_3
XFILLER_56_416 VGND VGND VPWR VPWR sky130_fd_sc_hd__decap_3
XFILLER_56_427 VGND VGND VPWR VPWR sky130_fd_sc_hd__fill_1
Xinput1 rst_n VGND VGND VPWR VPWR input1/X sky130_fd_sc_hd__clkdlybuf4s25_1
XFILLER_42_1462 VGND VGND VPWR VPWR sky130_fd_sc_hd__decap_3
X_4055_ _4779_/A1 _4052_/X _4053_/Y _4054_/X _4772_/C1 VGND VGND VPWR VPWR _4055_/X
+ sky130_fd_sc_hd__o221a_2
XFILLER_72_909 VGND VGND VPWR VPWR sky130_fd_sc_hd__decap_3
Xclkbuf_leaf_48_clk clkbuf_leaf_54_clk/A VGND VGND VPWR VPWR _7039_/CLK sky130_fd_sc_hd__clkbuf_8
XFILLER_65_961 VGND VGND VPWR VPWR sky130_fd_sc_hd__decap_3
XFILLER_24_302 VGND VGND VPWR VPWR sky130_fd_sc_hd__decap_3
XFILLER_36_195 VGND VGND VPWR VPWR sky130_fd_sc_hd__fill_1
XFILLER_51_132 VGND VGND VPWR VPWR sky130_fd_sc_hd__decap_3
XFILLER_75_1260 VGND VGND VPWR VPWR sky130_fd_sc_hd__decap_3
XFILLER_40_828 VGND VGND VPWR VPWR sky130_fd_sc_hd__fill_1
X_4957_ _6351_/Q _4956_/X _4957_/S VGND VGND VPWR VPWR _6351_/D sky130_fd_sc_hd__mux2_1
XFILLER_52_699 VGND VGND VPWR VPWR sky130_fd_sc_hd__fill_1
XFILLER_71_1135 VGND VGND VPWR VPWR sky130_fd_sc_hd__decap_3
XFILLER_36_1255 VGND VGND VPWR VPWR sky130_fd_sc_hd__decap_3
X_3908_ _4283_/A wire69/X VGND VGND VPWR VPWR _3908_/Y sky130_fd_sc_hd__nand2_2
X_4888_ _4887_/B _4710_/B _4887_/Y _4888_/C1 VGND VGND VPWR VPWR _4889_/C sky130_fd_sc_hd__o211ai_2
XFILLER_71_1168 VGND VGND VPWR VPWR sky130_fd_sc_hd__decap_3
XFILLER_36_1288 VGND VGND VPWR VPWR sky130_fd_sc_hd__decap_3
XFILLER_20_563 VGND VGND VPWR VPWR sky130_fd_sc_hd__fill_2
X_3839_ _4303_/B _3839_/B VGND VGND VPWR VPWR _4143_/A sky130_fd_sc_hd__xnor2_2
X_6627_ _7036_/CLK _6627_/D load_slew822/X VGND VGND VPWR VPWR _6627_/Q sky130_fd_sc_hd__dfrtp_2
XTAP_TAPCELL_ROW_60_1770 VGND VPWR sky130_fd_sc_hd__tapvpwrvgnd_1
Xtt_um_aes128_optimized_860 VGND VGND VPWR VPWR uio_oe[7] tt_um_aes128_optimized_860/LO
+ sky130_fd_sc_hd__conb_1
XFILLER_10_1406 VGND VGND VPWR VPWR sky130_fd_sc_hd__decap_3
XFILLER_4_707 VGND VGND VPWR VPWR sky130_fd_sc_hd__fill_2
X_6558_ _7024_/CLK _6558_/D fanout699/A VGND VGND VPWR VPWR _6558_/Q sky130_fd_sc_hd__dfrtp_2
X_5509_ _3957_/B _5504_/Y _5513_/A _5508_/Y VGND VGND VPWR VPWR _6605_/D sky130_fd_sc_hd__o211a_2
XFILLER_3_239 VGND VGND VPWR VPWR sky130_fd_sc_hd__decap_3
X_6489_ _6958_/CLK _6489_/D fanout759/A VGND VGND VPWR VPWR _6489_/Q sky130_fd_sc_hd__dfrtp_2
XFILLER_10_55 VGND VGND VPWR VPWR sky130_fd_sc_hd__fill_2
XFILLER_79_508 VGND VGND VPWR VPWR sky130_fd_sc_hd__decap_3
XFILLER_47_1340 VGND VGND VPWR VPWR sky130_fd_sc_hd__decap_3
XFILLER_10_88 VGND VGND VPWR VPWR sky130_fd_sc_hd__decap_3
XFILLER_47_1351 VGND VGND VPWR VPWR sky130_fd_sc_hd__decap_3
XFILLER_0_946 VGND VGND VPWR VPWR sky130_fd_sc_hd__decap_3
XFILLER_47_1384 VGND VGND VPWR VPWR sky130_fd_sc_hd__decap_3
XFILLER_0_968 VGND VGND VPWR VPWR sky130_fd_sc_hd__decap_3
XTAP_TAPCELL_ROW_54_1596 VGND VPWR sky130_fd_sc_hd__tapvpwrvgnd_1
XFILLER_43_1248 VGND VGND VPWR VPWR sky130_fd_sc_hd__decap_3
XFILLER_74_213 VGND VGND VPWR VPWR sky130_fd_sc_hd__decap_3
XFILLER_59_287 VGND VGND VPWR VPWR sky130_fd_sc_hd__decap_3
XFILLER_47_438 VGND VGND VPWR VPWR sky130_fd_sc_hd__fill_2
XFILLER_59_298 VGND VGND VPWR VPWR sky130_fd_sc_hd__fill_1
XFILLER_75_758 VGND VGND VPWR VPWR sky130_fd_sc_hd__decap_3
XFILLER_74_246 VGND VGND VPWR VPWR sky130_fd_sc_hd__decap_3
Xclkbuf_leaf_39_clk clkload6/A VGND VGND VPWR VPWR _7001_/CLK sky130_fd_sc_hd__clkbuf_8
XFILLER_74_268 VGND VGND VPWR VPWR sky130_fd_sc_hd__decap_3
XTAP_TAPCELL_ROW_2_250 VGND VPWR sky130_fd_sc_hd__tapvpwrvgnd_1
XFILLER_16_803 VGND VGND VPWR VPWR sky130_fd_sc_hd__decap_3
XTAP_TAPCELL_ROW_2_261 VGND VPWR sky130_fd_sc_hd__tapvpwrvgnd_1
XFILLER_28_663 VGND VGND VPWR VPWR sky130_fd_sc_hd__decap_3
XFILLER_62_419 VGND VGND VPWR VPWR sky130_fd_sc_hd__fill_1
XTAP_TAPCELL_ROW_67_1935 VGND VPWR sky130_fd_sc_hd__tapvpwrvgnd_1
XFILLER_76_1024 VGND VGND VPWR VPWR sky130_fd_sc_hd__decap_3
XTAP_TAPCELL_ROW_67_1946 VGND VPWR sky130_fd_sc_hd__tapvpwrvgnd_1
XFILLER_16_847 VGND VGND VPWR VPWR sky130_fd_sc_hd__decap_3
XFILLER_55_482 VGND VGND VPWR VPWR sky130_fd_sc_hd__fill_1
XFILLER_71_953 VGND VGND VPWR VPWR sky130_fd_sc_hd__decap_3
XFILLER_70_441 VGND VGND VPWR VPWR sky130_fd_sc_hd__decap_3
XFILLER_42_132 VGND VGND VPWR VPWR sky130_fd_sc_hd__decap_3
XFILLER_15_357 VGND VGND VPWR VPWR sky130_fd_sc_hd__decap_3
XFILLER_31_806 VGND VGND VPWR VPWR sky130_fd_sc_hd__fill_1
XFILLER_76_1079 VGND VGND VPWR VPWR sky130_fd_sc_hd__decap_3
XTAP_TAPCELL_ROW_26_864 VGND VPWR sky130_fd_sc_hd__tapvpwrvgnd_1
XFILLER_54_1300 VGND VGND VPWR VPWR sky130_fd_sc_hd__decap_3
XFILLER_35_85 VGND VGND VPWR VPWR sky130_fd_sc_hd__decap_3
XFILLER_19_1431 VGND VGND VPWR VPWR sky130_fd_sc_hd__decap_3
XTAP_TAPCELL_ROW_26_875 VGND VPWR sky130_fd_sc_hd__tapvpwrvgnd_1
XTAP_TAPCELL_ROW_26_886 VGND VPWR sky130_fd_sc_hd__tapvpwrvgnd_1
XFILLER_30_327 VGND VGND VPWR VPWR sky130_fd_sc_hd__decap_3
XFILLER_54_1344 VGND VGND VPWR VPWR sky130_fd_sc_hd__decap_3
XTAP_TAPCELL_ROW_13_536 VGND VPWR sky130_fd_sc_hd__tapvpwrvgnd_1
XFILLER_30_349 VGND VGND VPWR VPWR sky130_fd_sc_hd__fill_2
XTAP_TAPCELL_ROW_13_547 VGND VPWR sky130_fd_sc_hd__tapvpwrvgnd_1
XFILLER_15_1328 VGND VGND VPWR VPWR sky130_fd_sc_hd__decap_3
XFILLER_54_1388 VGND VGND VPWR VPWR sky130_fd_sc_hd__decap_3
Xwire443 wire443/A VGND VGND VPWR VPWR _5502_/C sky130_fd_sc_hd__buf_4
XFILLER_7_556 VGND VGND VPWR VPWR sky130_fd_sc_hd__decap_3
XFILLER_13_1052 VGND VGND VPWR VPWR sky130_fd_sc_hd__decap_3
XFILLER_7_567 VGND VGND VPWR VPWR sky130_fd_sc_hd__decap_3
XFILLER_48_1126 VGND VGND VPWR VPWR sky130_fd_sc_hd__decap_3
XFILLER_65_1440 VGND VGND VPWR VPWR sky130_fd_sc_hd__decap_3
Xload_slew404 _4005_/C1 VGND VGND VPWR VPWR _4772_/C1 sky130_fd_sc_hd__clkbuf_4
XFILLER_26_1424 VGND VGND VPWR VPWR sky130_fd_sc_hd__decap_3
XFILLER_61_1304 VGND VGND VPWR VPWR sky130_fd_sc_hd__decap_3
XFILLER_2_294 VGND VGND VPWR VPWR sky130_fd_sc_hd__decap_3
XFILLER_26_1435 VGND VGND VPWR VPWR sky130_fd_sc_hd__decap_3
XFILLER_39_906 VGND VGND VPWR VPWR sky130_fd_sc_hd__decap_3
XFILLER_25_6 VGND VGND VPWR VPWR sky130_fd_sc_hd__decap_3
XFILLER_61_1337 VGND VGND VPWR VPWR sky130_fd_sc_hd__decap_3
XFILLER_26_1468 VGND VGND VPWR VPWR sky130_fd_sc_hd__fill_1
XFILLER_61_1348 VGND VGND VPWR VPWR sky130_fd_sc_hd__decap_3
XFILLER_39_939 VGND VGND VPWR VPWR sky130_fd_sc_hd__decap_3
XFILLER_65_213 VGND VGND VPWR VPWR sky130_fd_sc_hd__fill_2
XFILLER_4_1220 VGND VGND VPWR VPWR sky130_fd_sc_hd__decap_3
XFILLER_65_235 VGND VGND VPWR VPWR sky130_fd_sc_hd__decap_3
XFILLER_4_1253 VGND VGND VPWR VPWR sky130_fd_sc_hd__decap_3
XTAP_TAPCELL_ROW_0_209 VGND VPWR sky130_fd_sc_hd__tapvpwrvgnd_1
XFILLER_47_950 VGND VGND VPWR VPWR sky130_fd_sc_hd__fill_2
XFILLER_4_1264 VGND VGND VPWR VPWR sky130_fd_sc_hd__decap_3
XFILLER_19_652 VGND VGND VPWR VPWR sky130_fd_sc_hd__decap_3
XFILLER_53_408 VGND VGND VPWR VPWR sky130_fd_sc_hd__decap_3
XFILLER_0_1117 VGND VGND VPWR VPWR sky130_fd_sc_hd__decap_3
XFILLER_46_460 VGND VGND VPWR VPWR sky130_fd_sc_hd__decap_3
XFILLER_47_994 VGND VGND VPWR VPWR sky130_fd_sc_hd__decap_3
XFILLER_59_1222 VGND VGND VPWR VPWR sky130_fd_sc_hd__decap_3
XFILLER_4_1297 VGND VGND VPWR VPWR sky130_fd_sc_hd__decap_3
XFILLER_59_1233 VGND VGND VPWR VPWR sky130_fd_sc_hd__decap_3
XFILLER_0_1139 VGND VGND VPWR VPWR sky130_fd_sc_hd__decap_3
XFILLER_20_1089 VGND VGND VPWR VPWR sky130_fd_sc_hd__decap_3
X_5860_ _5860_/A0 _5889_/A0 _5867_/S VGND VGND VPWR VPWR _6874_/D sky130_fd_sc_hd__mux2_1
XFILLER_33_121 VGND VGND VPWR VPWR sky130_fd_sc_hd__decap_3
XFILLER_59_1266 VGND VGND VPWR VPWR sky130_fd_sc_hd__decap_3
XFILLER_34_666 VGND VGND VPWR VPWR sky130_fd_sc_hd__decap_3
XFILLER_72_1400 VGND VGND VPWR VPWR sky130_fd_sc_hd__decap_3
X_4811_ _6283_/Q _4868_/A2 _3440_/X _4868_/B2 VGND VGND VPWR VPWR _4811_/X sky130_fd_sc_hd__a22o_2
XFILLER_61_463 VGND VGND VPWR VPWR sky130_fd_sc_hd__decap_3
X_5791_ _5801_/A_N _5868_/B _5791_/C VGND VGND VPWR VPWR _5791_/X sky130_fd_sc_hd__and3b_2
XFILLER_72_1444 VGND VGND VPWR VPWR sky130_fd_sc_hd__decap_3
X_4742_ _4738_/Y _4739_/X _4741_/Y _4558_/A VGND VGND VPWR VPWR _4742_/X sky130_fd_sc_hd__o211a_2
XFILLER_33_1428 VGND VGND VPWR VPWR sky130_fd_sc_hd__decap_3
X_4673_ _4842_/B _4694_/B _4277_/X _4665_/X _6553_/Q VGND VGND VPWR VPWR _4673_/X
+ sky130_fd_sc_hd__a32o_2
X_6412_ _6974_/CLK _6412_/D load_slew767/X VGND VGND VPWR VPWR _6412_/Q sky130_fd_sc_hd__dfrtp_2
X_3624_ _6216_/Q _3631_/A2 _5594_/A1 _6264_/Q _3623_/X VGND VGND VPWR VPWR _3624_/X
+ sky130_fd_sc_hd__a221o_2
XTAP_TAPCELL_ROW_73_2106 VGND VPWR sky130_fd_sc_hd__tapvpwrvgnd_1
X_6343_ _6929_/CLK _6343_/D load_slew707/X VGND VGND VPWR VPWR _6343_/Q sky130_fd_sc_hd__dfrtp_2
X_3555_ _3553_/X _3554_/X _4665_/B VGND VGND VPWR VPWR _3555_/X sky130_fd_sc_hd__mux2_1
XFILLER_66_1226 VGND VGND VPWR VPWR sky130_fd_sc_hd__decap_3
X_6274_ _6987_/CLK _6274_/D load_slew834/X VGND VGND VPWR VPWR _6274_/Q sky130_fd_sc_hd__dfrtp_2
XFILLER_0_209 VGND VGND VPWR VPWR sky130_fd_sc_hd__decap_3
X_3486_ _3486_/A _3486_/B VGND VGND VPWR VPWR _3486_/X sky130_fd_sc_hd__or2_2
XFILLER_66_1259 VGND VGND VPWR VPWR sky130_fd_sc_hd__fill_1
X_5225_ _5328_/S _5225_/B VGND VGND VPWR VPWR _5225_/Y sky130_fd_sc_hd__nand2_2
XFILLER_9_1142 VGND VGND VPWR VPWR sky130_fd_sc_hd__decap_3
XFILLER_9_1175 VGND VGND VPWR VPWR sky130_fd_sc_hd__fill_1
X_5156_ _6725_/Q _5332_/S VGND VGND VPWR VPWR _5156_/X sky130_fd_sc_hd__or2_2
XFILLER_5_1006 VGND VGND VPWR VPWR sky130_fd_sc_hd__fill_2
XFILLER_29_405 VGND VGND VPWR VPWR sky130_fd_sc_hd__decap_3
XFILLER_9_1186 VGND VGND VPWR VPWR sky130_fd_sc_hd__decap_3
XFILLER_56_18 VGND VGND VPWR VPWR sky130_fd_sc_hd__fill_1
X_4107_ _3743_/B _3490_/C _3490_/B VGND VGND VPWR VPWR _4107_/X sky130_fd_sc_hd__a21o_2
XFILLER_29_449 VGND VGND VPWR VPWR sky130_fd_sc_hd__decap_3
X_5087_ _6466_/Q _5087_/B VGND VGND VPWR VPWR _5088_/B sky130_fd_sc_hd__xnor2_2
XFILLER_42_1270 VGND VGND VPWR VPWR sky130_fd_sc_hd__decap_3
XFILLER_38_950 VGND VGND VPWR VPWR sky130_fd_sc_hd__decap_3
XFILLER_44_408 VGND VGND VPWR VPWR sky130_fd_sc_hd__decap_3
X_4038_ _3410_/X _4583_/B2 _4584_/A2 _6902_/Q _4092_/C1 VGND VGND VPWR VPWR _4038_/X
+ sky130_fd_sc_hd__a221o_2
XFILLER_72_728 VGND VGND VPWR VPWR sky130_fd_sc_hd__decap_3
XFILLER_77_1322 VGND VGND VPWR VPWR sky130_fd_sc_hd__decap_3
XFILLER_53_920 VGND VGND VPWR VPWR sky130_fd_sc_hd__fill_1
XFILLER_38_1306 VGND VGND VPWR VPWR sky130_fd_sc_hd__decap_3
XFILLER_77_1366 VGND VGND VPWR VPWR sky130_fd_sc_hd__decap_3
XFILLER_38_1317 VGND VGND VPWR VPWR sky130_fd_sc_hd__decap_3
XFILLER_52_430 VGND VGND VPWR VPWR sky130_fd_sc_hd__fill_1
XFILLER_64_290 VGND VGND VPWR VPWR sky130_fd_sc_hd__decap_3
XFILLER_80_750 VGND VGND VPWR VPWR sky130_fd_sc_hd__decap_3
XFILLER_25_655 VGND VGND VPWR VPWR sky130_fd_sc_hd__fill_2
XFILLER_52_441 VGND VGND VPWR VPWR sky130_fd_sc_hd__fill_1
XFILLER_13_806 VGND VGND VPWR VPWR sky130_fd_sc_hd__decap_3
XFILLER_73_1219 VGND VGND VPWR VPWR sky130_fd_sc_hd__decap_3
XFILLER_80_772 VGND VGND VPWR VPWR sky130_fd_sc_hd__decap_3
XFILLER_77_1399 VGND VGND VPWR VPWR sky130_fd_sc_hd__fill_1
XTAP_TAPCELL_ROW_23_801 VGND VPWR sky130_fd_sc_hd__tapvpwrvgnd_1
XFILLER_24_154 VGND VGND VPWR VPWR sky130_fd_sc_hd__decap_3
XTAP_TAPCELL_ROW_62_1810 VGND VPWR sky130_fd_sc_hd__tapvpwrvgnd_1
XFILLER_52_474 VGND VGND VPWR VPWR sky130_fd_sc_hd__fill_2
XTAP_TAPCELL_ROW_62_1821 VGND VPWR sky130_fd_sc_hd__tapvpwrvgnd_1
X_5989_ hold930/X _6993_/Q _5989_/S VGND VGND VPWR VPWR _5989_/X sky130_fd_sc_hd__mux2_1
XFILLER_75_1090 VGND VGND VPWR VPWR sky130_fd_sc_hd__decap_3
XANTENNA_50 _5840_/S VGND VGND VPWR VPWR sky130_fd_sc_hd__diode_2
XANTENNA_61 _4738_/A VGND VGND VPWR VPWR sky130_fd_sc_hd__diode_2
XANTENNA_72 _5502_/C VGND VGND VPWR VPWR sky130_fd_sc_hd__diode_2
XFILLER_14_1350 VGND VGND VPWR VPWR sky130_fd_sc_hd__decap_3
XANTENNA_83 _3270_/X VGND VGND VPWR VPWR sky130_fd_sc_hd__diode_2
XFILLER_10_1203 VGND VGND VPWR VPWR sky130_fd_sc_hd__fill_1
XFILLER_10_1214 VGND VGND VPWR VPWR sky130_fd_sc_hd__decap_3
XFILLER_4_515 VGND VGND VPWR VPWR sky130_fd_sc_hd__decap_3
XFILLER_14_1394 VGND VGND VPWR VPWR sky130_fd_sc_hd__decap_3
XFILLER_10_1247 VGND VGND VPWR VPWR sky130_fd_sc_hd__decap_3
XFILLER_49_1413 VGND VGND VPWR VPWR sky130_fd_sc_hd__decap_3
XFILLER_4_548 VGND VGND VPWR VPWR sky130_fd_sc_hd__decap_3
XFILLER_49_1446 VGND VGND VPWR VPWR sky130_fd_sc_hd__decap_3
XFILLER_49_1457 VGND VGND VPWR VPWR sky130_fd_sc_hd__decap_3
XTAP_TAPCELL_ROW_56_1647 VGND VPWR sky130_fd_sc_hd__tapvpwrvgnd_1
XTAP_TAPCELL_ROW_56_1658 VGND VPWR sky130_fd_sc_hd__tapvpwrvgnd_1
XTAP_TAPCELL_ROW_56_1669 VGND VPWR sky130_fd_sc_hd__tapvpwrvgnd_1
XFILLER_0_710 VGND VGND VPWR VPWR sky130_fd_sc_hd__decap_3
XFILLER_0_732 VGND VGND VPWR VPWR sky130_fd_sc_hd__decap_3
XFILLER_43_1001 VGND VGND VPWR VPWR sky130_fd_sc_hd__decap_3
XTAP_TAPCELL_ROW_7_375 VGND VPWR sky130_fd_sc_hd__tapvpwrvgnd_1
XFILLER_47_1192 VGND VGND VPWR VPWR sky130_fd_sc_hd__decap_3
XTAP_TAPCELL_ROW_7_386 VGND VPWR sky130_fd_sc_hd__tapvpwrvgnd_1
XFILLER_75_511 VGND VGND VPWR VPWR sky130_fd_sc_hd__decap_3
XFILLER_47_213 VGND VGND VPWR VPWR sky130_fd_sc_hd__decap_3
XFILLER_48_736 VGND VGND VPWR VPWR sky130_fd_sc_hd__decap_3
XFILLER_21_1310 VGND VGND VPWR VPWR sky130_fd_sc_hd__decap_3
XFILLER_78_1108 VGND VGND VPWR VPWR sky130_fd_sc_hd__decap_3
XFILLER_47_257 VGND VGND VPWR VPWR sky130_fd_sc_hd__fill_2
XFILLER_1_1404 VGND VGND VPWR VPWR sky130_fd_sc_hd__decap_3
XFILLER_21_1343 VGND VGND VPWR VPWR sky130_fd_sc_hd__fill_1
XFILLER_21_1354 VGND VGND VPWR VPWR sky130_fd_sc_hd__decap_3
XFILLER_1_1437 VGND VGND VPWR VPWR sky130_fd_sc_hd__decap_3
XFILLER_21_1387 VGND VGND VPWR VPWR sky130_fd_sc_hd__decap_3
XFILLER_15_110 VGND VGND VPWR VPWR sky130_fd_sc_hd__fill_2
XFILLER_28_493 VGND VGND VPWR VPWR sky130_fd_sc_hd__decap_3
XFILLER_44_942 VGND VGND VPWR VPWR sky130_fd_sc_hd__fill_2
XFILLER_15_121 VGND VGND VPWR VPWR sky130_fd_sc_hd__decap_3
XFILLER_56_1406 VGND VGND VPWR VPWR sky130_fd_sc_hd__decap_3
Xmax_cap85 _5750_/S VGND VGND VPWR VPWR _5757_/S sky130_fd_sc_hd__buf_6
Xmax_cap96 wire97/X VGND VGND VPWR VPWR _5856_/S sky130_fd_sc_hd__buf_2
XFILLER_43_463 VGND VGND VPWR VPWR sky130_fd_sc_hd__decap_3
XFILLER_71_783 VGND VGND VPWR VPWR sky130_fd_sc_hd__fill_1
XFILLER_31_614 VGND VGND VPWR VPWR sky130_fd_sc_hd__fill_2
XFILLER_70_282 VGND VGND VPWR VPWR sky130_fd_sc_hd__decap_3
XFILLER_30_135 VGND VGND VPWR VPWR sky130_fd_sc_hd__decap_3
XFILLER_15_1103 VGND VGND VPWR VPWR sky130_fd_sc_hd__decap_3
XFILLER_19_1272 VGND VGND VPWR VPWR sky130_fd_sc_hd__decap_3
XFILLER_54_1163 VGND VGND VPWR VPWR sky130_fd_sc_hd__decap_3
XFILLER_8_810 VGND VGND VPWR VPWR sky130_fd_sc_hd__fill_2
XFILLER_50_1005 VGND VGND VPWR VPWR sky130_fd_sc_hd__fill_2
XFILLER_30_168 VGND VGND VPWR VPWR sky130_fd_sc_hd__fill_2
XFILLER_7_12 VGND VGND VPWR VPWR sky130_fd_sc_hd__decap_3
XFILLER_15_1158 VGND VGND VPWR VPWR sky130_fd_sc_hd__decap_3
XFILLER_8_854 VGND VGND VPWR VPWR sky130_fd_sc_hd__decap_3
XFILLER_11_393 VGND VGND VPWR VPWR sky130_fd_sc_hd__decap_3
XFILLER_32_1450 VGND VGND VPWR VPWR sky130_fd_sc_hd__decap_3
Xwire295 wire295/A VGND VGND VPWR VPWR wire295/X sky130_fd_sc_hd__clkbuf_4
X_3340_ _6225_/Q _6401_/Q VGND VGND VPWR VPWR _3340_/X sky130_fd_sc_hd__xor2_2
XFILLER_3_570 VGND VGND VPWR VPWR sky130_fd_sc_hd__decap_3
Xload_slew201 _3423_/S VGND VGND VPWR VPWR _3389_/S sky130_fd_sc_hd__buf_4
Xload_slew212 _5993_/S VGND VGND VPWR VPWR _6033_/S sky130_fd_sc_hd__clkbuf_4
X_3271_ _5956_/A0 _3270_/X _3457_/S VGND VGND VPWR VPWR _6109_/D sky130_fd_sc_hd__mux2_1
Xload_slew223 _5989_/S VGND VGND VPWR VPWR _6050_/S sky130_fd_sc_hd__buf_4
XFILLER_26_1232 VGND VGND VPWR VPWR sky130_fd_sc_hd__decap_3
X_5010_ _6391_/Q _5243_/B _5052_/B1 VGND VGND VPWR VPWR _5010_/Y sky130_fd_sc_hd__a21oi_2
XFILLER_65_1281 VGND VGND VPWR VPWR sky130_fd_sc_hd__decap_3
XFILLER_79_872 VGND VGND VPWR VPWR sky130_fd_sc_hd__decap_3
XFILLER_6_1315 VGND VGND VPWR VPWR sky130_fd_sc_hd__fill_1
XFILLER_65_1292 VGND VGND VPWR VPWR sky130_fd_sc_hd__decap_3
XFILLER_6_1326 VGND VGND VPWR VPWR sky130_fd_sc_hd__decap_3
XFILLER_23_3 VGND VGND VPWR VPWR sky130_fd_sc_hd__decap_3
Xhold1009 _5943_/X VGND VGND VPWR VPWR _6947_/D sky130_fd_sc_hd__dlygate4sd3_1
Xload_slew267 _4580_/B VGND VGND VPWR VPWR _4696_/B sky130_fd_sc_hd__clkbuf_4
XFILLER_26_1276 VGND VGND VPWR VPWR sky130_fd_sc_hd__decap_3
XFILLER_6_1359 VGND VGND VPWR VPWR sky130_fd_sc_hd__decap_3
XFILLER_38_224 VGND VGND VPWR VPWR sky130_fd_sc_hd__decap_3
XFILLER_26_408 VGND VGND VPWR VPWR sky130_fd_sc_hd__decap_3
X_6961_ _7025_/CLK _6961_/D load_slew728/X VGND VGND VPWR VPWR _6961_/Q sky130_fd_sc_hd__dfrtp_2
XFILLER_35_931 VGND VGND VPWR VPWR sky130_fd_sc_hd__decap_3
X_5912_ _5912_/A0 _5912_/A1 _5914_/S VGND VGND VPWR VPWR _6919_/D sky130_fd_sc_hd__mux2_1
XFILLER_35_953 VGND VGND VPWR VPWR sky130_fd_sc_hd__decap_3
XFILLER_53_249 VGND VGND VPWR VPWR sky130_fd_sc_hd__decap_3
X_6892_ _7052_/CLK _6892_/D fanout804/X VGND VGND VPWR VPWR _6892_/Q sky130_fd_sc_hd__dfrtp_2
XTAP_TAPCELL_ROW_17_650 VGND VPWR sky130_fd_sc_hd__tapvpwrvgnd_1
XFILLER_22_614 VGND VGND VPWR VPWR sky130_fd_sc_hd__decap_3
XFILLER_50_923 VGND VGND VPWR VPWR sky130_fd_sc_hd__fill_1
X_5843_ _5843_/A0 _5917_/A1 _5849_/S VGND VGND VPWR VPWR _6859_/D sky130_fd_sc_hd__mux2_1
XFILLER_21_113 VGND VGND VPWR VPWR sky130_fd_sc_hd__decap_3
XFILLER_50_956 VGND VGND VPWR VPWR sky130_fd_sc_hd__decap_3
XFILLER_72_1241 VGND VGND VPWR VPWR sky130_fd_sc_hd__decap_3
XFILLER_10_809 VGND VGND VPWR VPWR sky130_fd_sc_hd__decap_3
XFILLER_37_1372 VGND VGND VPWR VPWR sky130_fd_sc_hd__decap_3
X_5774_ _7073_/Q _5868_/A _5859_/C VGND VGND VPWR VPWR _5780_/S sky130_fd_sc_hd__and3_2
XFILLER_72_1285 VGND VGND VPWR VPWR sky130_fd_sc_hd__decap_3
XFILLER_33_1236 VGND VGND VPWR VPWR sky130_fd_sc_hd__decap_3
X_4725_ _4770_/B _4725_/B VGND VGND VPWR VPWR _4725_/Y sky130_fd_sc_hd__nor2_2
XFILLER_33_1269 VGND VGND VPWR VPWR sky130_fd_sc_hd__decap_3
X_4656_ _6888_/Q _4833_/A2 _4833_/B1 _4655_/X VGND VGND VPWR VPWR _4656_/X sky130_fd_sc_hd__a211o_2
X_3607_ _3640_/B _3607_/B _3607_/C VGND VGND VPWR VPWR _3644_/C sky130_fd_sc_hd__nand3_2
X_4587_ _6541_/Q _4547_/X _4756_/A1 VGND VGND VPWR VPWR _4587_/X sky130_fd_sc_hd__a21o_2
X_3538_ _6621_/Q _3631_/A2 _3537_/X VGND VGND VPWR VPWR _3538_/X sky130_fd_sc_hd__a21o_2
X_6326_ _6912_/CLK _6326_/D wire715/X VGND VGND VPWR VPWR _6326_/Q sky130_fd_sc_hd__dfrtp_2
Xhold865 _5970_/X VGND VGND VPWR VPWR _6974_/D sky130_fd_sc_hd__dlygate4sd3_1
XFILLER_1_529 VGND VGND VPWR VPWR sky130_fd_sc_hd__decap_3
Xhold876 _6723_/Q VGND VGND VPWR VPWR hold876/X sky130_fd_sc_hd__dlygate4sd3_1
Xhold887 _6166_/Q VGND VGND VPWR VPWR hold887/X sky130_fd_sc_hd__dlygate4sd3_1
Xhold898 _6736_/Q VGND VGND VPWR VPWR hold898/X sky130_fd_sc_hd__dlygate4sd3_1
X_6257_ _6923_/CLK _6257_/D load_slew799/X VGND VGND VPWR VPWR _6257_/Q sky130_fd_sc_hd__dfrtp_2
X_3469_ hold959/X _3468_/X _3477_/S VGND VGND VPWR VPWR _6208_/D sky130_fd_sc_hd__mux2_1
XFILLER_44_1332 VGND VGND VPWR VPWR sky130_fd_sc_hd__decap_3
XFILLER_67_39 VGND VGND VPWR VPWR sky130_fd_sc_hd__decap_3
XTAP_TAPCELL_ROW_4_301 VGND VPWR sky130_fd_sc_hd__tapvpwrvgnd_1
XTAP_TAPCELL_ROW_51_1522 VGND VPWR sky130_fd_sc_hd__tapvpwrvgnd_1
X_5208_ _6749_/Q _5306_/S _5307_/S _5207_/Y VGND VGND VPWR VPWR _5208_/X sky130_fd_sc_hd__o211a_2
XTAP_TAPCELL_ROW_4_312 VGND VPWR sky130_fd_sc_hd__tapvpwrvgnd_1
XTAP_TAPCELL_ROW_51_1533 VGND VPWR sky130_fd_sc_hd__tapvpwrvgnd_1
X_6188_ _7007_/CLK _6188_/D fanout820/X VGND VGND VPWR VPWR _6188_/Q sky130_fd_sc_hd__dfrtp_2
XFILLER_29_202 VGND VGND VPWR VPWR sky130_fd_sc_hd__decap_3
XFILLER_44_1365 VGND VGND VPWR VPWR sky130_fd_sc_hd__decap_3
Xhold1510 _6541_/Q VGND VGND VPWR VPWR _5429_/A1 sky130_fd_sc_hd__dlygate4sd3_1
XFILLER_44_1376 VGND VGND VPWR VPWR sky130_fd_sc_hd__decap_3
Xhold1521 _6574_/Q VGND VGND VPWR VPWR _5462_/A1 sky130_fd_sc_hd__dlygate4sd3_1
XFILLER_69_393 VGND VGND VPWR VPWR sky130_fd_sc_hd__decap_3
XFILLER_29_235 VGND VGND VPWR VPWR sky130_fd_sc_hd__fill_1
X_5139_ _6378_/Q _5215_/A2 _4922_/S _5138_/X VGND VGND VPWR VPWR _6378_/D sky130_fd_sc_hd__a22o_2
Xhold1532 _6540_/Q VGND VGND VPWR VPWR _5428_/A1 sky130_fd_sc_hd__dlygate4sd3_1
Xhold1543 _6660_/Q VGND VGND VPWR VPWR _5587_/B2 sky130_fd_sc_hd__dlygate4sd3_1
Xhold1554 _6663_/Q VGND VGND VPWR VPWR _5590_/B2 sky130_fd_sc_hd__dlygate4sd3_1
XFILLER_79_1428 VGND VGND VPWR VPWR sky130_fd_sc_hd__decap_3
Xhold1565 _6669_/Q VGND VGND VPWR VPWR _5597_/B2 sky130_fd_sc_hd__dlygate4sd3_1
XFILLER_29_268 VGND VGND VPWR VPWR sky130_fd_sc_hd__decap_3
XTAP_TAPCELL_ROW_28_926 VGND VPWR sky130_fd_sc_hd__tapvpwrvgnd_1
XFILLER_72_525 VGND VGND VPWR VPWR sky130_fd_sc_hd__decap_3
XTAP_TAPCELL_ROW_28_937 VGND VPWR sky130_fd_sc_hd__tapvpwrvgnd_1
XFILLER_72_536 VGND VGND VPWR VPWR sky130_fd_sc_hd__decap_3
XFILLER_26_931 VGND VGND VPWR VPWR sky130_fd_sc_hd__fill_1
XFILLER_77_1130 VGND VGND VPWR VPWR sky130_fd_sc_hd__decap_3
XFILLER_37_290 VGND VGND VPWR VPWR sky130_fd_sc_hd__decap_3
XTAP_TAPCELL_ROW_49_1462 VGND VPWR sky130_fd_sc_hd__tapvpwrvgnd_1
XFILLER_53_750 VGND VGND VPWR VPWR sky130_fd_sc_hd__decap_3
XFILLER_77_1163 VGND VGND VPWR VPWR sky130_fd_sc_hd__decap_3
XFILLER_13_603 VGND VGND VPWR VPWR sky130_fd_sc_hd__decap_3
XTAP_TAPCELL_ROW_49_1473 VGND VPWR sky130_fd_sc_hd__tapvpwrvgnd_1
XFILLER_16_65 VGND VGND VPWR VPWR sky130_fd_sc_hd__decap_3
XFILLER_41_923 VGND VGND VPWR VPWR sky130_fd_sc_hd__fill_2
XTAP_TAPCELL_ROW_49_1484 VGND VPWR sky130_fd_sc_hd__tapvpwrvgnd_1
XFILLER_53_783 VGND VGND VPWR VPWR sky130_fd_sc_hd__fill_1
XFILLER_16_98 VGND VGND VPWR VPWR sky130_fd_sc_hd__fill_1
XFILLER_41_956 VGND VGND VPWR VPWR sky130_fd_sc_hd__decap_3
XTAP_TAPCELL_ROW_45_1359 VGND VPWR sky130_fd_sc_hd__tapvpwrvgnd_1
XFILLER_13_658 VGND VGND VPWR VPWR sky130_fd_sc_hd__decap_3
XFILLER_52_293 VGND VGND VPWR VPWR sky130_fd_sc_hd__decap_3
XFILLER_16_1412 VGND VGND VPWR VPWR sky130_fd_sc_hd__decap_3
XFILLER_40_466 VGND VGND VPWR VPWR sky130_fd_sc_hd__decap_3
XFILLER_40_477 VGND VGND VPWR VPWR sky130_fd_sc_hd__decap_3
XFILLER_51_1325 VGND VGND VPWR VPWR sky130_fd_sc_hd__decap_3
XFILLER_8_128 VGND VGND VPWR VPWR sky130_fd_sc_hd__decap_3
XFILLER_16_1456 VGND VGND VPWR VPWR sky130_fd_sc_hd__decap_3
XFILLER_12_1309 VGND VGND VPWR VPWR sky130_fd_sc_hd__decap_3
XFILLER_51_1369 VGND VGND VPWR VPWR sky130_fd_sc_hd__decap_3
XTAP_TAPCELL_ROW_58_1709 VGND VPWR sky130_fd_sc_hd__tapvpwrvgnd_1
XFILLER_10_1011 VGND VGND VPWR VPWR sky130_fd_sc_hd__fill_2
XFILLER_49_1210 VGND VGND VPWR VPWR sky130_fd_sc_hd__fill_1
XFILLER_4_345 VGND VGND VPWR VPWR sky130_fd_sc_hd__decap_3
XPHY_EDGE_ROW_26_Left_107 VGND VGND VPWR VPWR sky130_fd_sc_hd__decap_3
XFILLER_10_1077 VGND VGND VPWR VPWR sky130_fd_sc_hd__fill_1
XFILLER_49_1254 VGND VGND VPWR VPWR sky130_fd_sc_hd__decap_3
XFILLER_79_113 VGND VGND VPWR VPWR sky130_fd_sc_hd__decap_3
XFILLER_10_1099 VGND VGND VPWR VPWR sky130_fd_sc_hd__decap_3
XFILLER_45_1118 VGND VGND VPWR VPWR sky130_fd_sc_hd__fill_2
XFILLER_49_1287 VGND VGND VPWR VPWR sky130_fd_sc_hd__fill_1
XFILLER_49_1298 VGND VGND VPWR VPWR sky130_fd_sc_hd__decap_3
XFILLER_62_1421 VGND VGND VPWR VPWR sky130_fd_sc_hd__decap_3
XFILLER_0_551 VGND VGND VPWR VPWR sky130_fd_sc_hd__decap_3
XFILLER_62_1432 VGND VGND VPWR VPWR sky130_fd_sc_hd__decap_3
XFILLER_0_573 VGND VGND VPWR VPWR sky130_fd_sc_hd__decap_3
XFILLER_23_1416 VGND VGND VPWR VPWR sky130_fd_sc_hd__decap_3
XFILLER_62_1465 VGND VGND VPWR VPWR sky130_fd_sc_hd__decap_3
XFILLER_0_595 VGND VGND VPWR VPWR sky130_fd_sc_hd__decap_3
XFILLER_48_533 VGND VGND VPWR VPWR sky130_fd_sc_hd__decap_3
XFILLER_23_1449 VGND VGND VPWR VPWR sky130_fd_sc_hd__decap_3
XFILLER_76_875 VGND VGND VPWR VPWR sky130_fd_sc_hd__decap_3
XFILLER_1_1201 VGND VGND VPWR VPWR sky130_fd_sc_hd__decap_3
XFILLER_35_205 VGND VGND VPWR VPWR sky130_fd_sc_hd__decap_3
XFILLER_63_514 VGND VGND VPWR VPWR sky130_fd_sc_hd__decap_3
XFILLER_5_1381 VGND VGND VPWR VPWR sky130_fd_sc_hd__decap_3
XFILLER_75_396 VGND VGND VPWR VPWR sky130_fd_sc_hd__decap_3
XFILLER_29_791 VGND VGND VPWR VPWR sky130_fd_sc_hd__decap_3
XPHY_EDGE_ROW_35_Left_116 VGND VGND VPWR VPWR sky130_fd_sc_hd__decap_3
XFILLER_1_1245 VGND VGND VPWR VPWR sky130_fd_sc_hd__decap_3
XFILLER_17_953 VGND VGND VPWR VPWR sky130_fd_sc_hd__decap_3
XFILLER_35_249 VGND VGND VPWR VPWR sky130_fd_sc_hd__decap_3
XFILLER_63_558 VGND VGND VPWR VPWR sky130_fd_sc_hd__fill_2
XFILLER_16_441 VGND VGND VPWR VPWR sky130_fd_sc_hd__fill_1
XFILLER_63_569 VGND VGND VPWR VPWR sky130_fd_sc_hd__decap_3
XFILLER_32_901 VGND VGND VPWR VPWR sky130_fd_sc_hd__decap_3
XFILLER_73_60 VGND VGND VPWR VPWR sky130_fd_sc_hd__decap_3
XFILLER_1_1278 VGND VGND VPWR VPWR sky130_fd_sc_hd__decap_3
XFILLER_17_986 VGND VGND VPWR VPWR sky130_fd_sc_hd__decap_3
XFILLER_1_1289 VGND VGND VPWR VPWR sky130_fd_sc_hd__decap_3
XFILLER_31_411 VGND VGND VPWR VPWR sky130_fd_sc_hd__decap_3
XFILLER_32_934 VGND VGND VPWR VPWR sky130_fd_sc_hd__decap_3
XFILLER_56_1247 VGND VGND VPWR VPWR sky130_fd_sc_hd__decap_3
XFILLER_43_293 VGND VGND VPWR VPWR sky130_fd_sc_hd__decap_3
XFILLER_31_455 VGND VGND VPWR VPWR sky130_fd_sc_hd__fill_1
XFILLER_32_978 VGND VGND VPWR VPWR sky130_fd_sc_hd__fill_2
XFILLER_30_1409 VGND VGND VPWR VPWR sky130_fd_sc_hd__decap_3
X_4510_ _4783_/A _4608_/B _4300_/X _4487_/X _6523_/Q VGND VGND VPWR VPWR _4510_/X
+ sky130_fd_sc_hd__a32o_2
X_5490_ _3039_/Y _7086_/Q _3078_/A _5519_/A2 VGND VGND VPWR VPWR _5490_/X sky130_fd_sc_hd__o211a_2
XFILLER_8_673 VGND VGND VPWR VPWR sky130_fd_sc_hd__decap_3
XPHY_EDGE_ROW_44_Left_125 VGND VGND VPWR VPWR sky130_fd_sc_hd__decap_3
XFILLER_32_1291 VGND VGND VPWR VPWR sky130_fd_sc_hd__decap_3
X_4441_ _6329_/Q _4743_/A2 _3308_/X _4854_/B2 VGND VGND VPWR VPWR _4441_/X sky130_fd_sc_hd__a22o_2
XPHY_EDGE_ROW_9_Right_9 VGND VGND VPWR VPWR sky130_fd_sc_hd__decap_3
XFILLER_67_1310 VGND VGND VPWR VPWR sky130_fd_sc_hd__decap_3
X_4372_ _6505_/Q _4396_/A _4756_/A1 VGND VGND VPWR VPWR _4372_/X sky130_fd_sc_hd__a21bo_2
XFILLER_67_1343 VGND VGND VPWR VPWR sky130_fd_sc_hd__fill_1
XFILLER_67_1354 VGND VGND VPWR VPWR sky130_fd_sc_hd__decap_3
X_6111_ _7034_/CLK _6111_/D fanout675/X VGND VGND VPWR VPWR _6111_/Q sky130_fd_sc_hd__dfrtp_2
XFILLER_28_1338 VGND VGND VPWR VPWR sky130_fd_sc_hd__decap_3
X_3323_ _5982_/A0 _3322_/X _3435_/S VGND VGND VPWR VPWR _6135_/D sky130_fd_sc_hd__mux2_1
XFILLER_63_1218 VGND VGND VPWR VPWR sky130_fd_sc_hd__decap_3
X_7091_ _7096_/CLK _7091_/D load_slew677/X VGND VGND VPWR VPWR _7091_/Q sky130_fd_sc_hd__dfrtp_2
XFILLER_67_1387 VGND VGND VPWR VPWR sky130_fd_sc_hd__decap_3
Xfanout619 input5/X VGND VGND VPWR VPWR _5793_/C sky130_fd_sc_hd__clkdlybuf4s25_1
X_6042_ hold932/X hold993/X _6050_/S VGND VGND VPWR VPWR _7046_/D sky130_fd_sc_hd__mux2_1
X_3254_ _6262_/Q _6358_/Q VGND VGND VPWR VPWR _3254_/X sky130_fd_sc_hd__xor2_2
XFILLER_6_1123 VGND VGND VPWR VPWR sky130_fd_sc_hd__decap_3
XFILLER_26_1073 VGND VGND VPWR VPWR sky130_fd_sc_hd__decap_3
XFILLER_67_853 VGND VGND VPWR VPWR sky130_fd_sc_hd__decap_3
X_3185_ _3193_/A1 _3183_/X _3184_/X _3220_/C1 VGND VGND VPWR VPWR _3185_/X sky130_fd_sc_hd__a211o_2
XFILLER_6_1167 VGND VGND VPWR VPWR sky130_fd_sc_hd__decap_3
XPHY_EDGE_ROW_53_Left_134 VGND VGND VPWR VPWR sky130_fd_sc_hd__decap_3
XFILLER_39_588 VGND VGND VPWR VPWR sky130_fd_sc_hd__decap_3
XFILLER_67_897 VGND VGND VPWR VPWR sky130_fd_sc_hd__decap_3
XFILLER_66_385 VGND VGND VPWR VPWR sky130_fd_sc_hd__decap_3
XFILLER_54_536 VGND VGND VPWR VPWR sky130_fd_sc_hd__decap_3
XFILLER_78_1450 VGND VGND VPWR VPWR sky130_fd_sc_hd__decap_3
XFILLER_39_1401 VGND VGND VPWR VPWR sky130_fd_sc_hd__decap_3
X_6944_ _7073_/CLK _6944_/D load_slew674/X VGND VGND VPWR VPWR _6944_/Q sky130_fd_sc_hd__dfrtp_2
XFILLER_54_569 VGND VGND VPWR VPWR sky130_fd_sc_hd__decap_3
XFILLER_74_1303 VGND VGND VPWR VPWR sky130_fd_sc_hd__decap_3
XFILLER_35_750 VGND VGND VPWR VPWR sky130_fd_sc_hd__decap_3
XFILLER_39_1434 VGND VGND VPWR VPWR sky130_fd_sc_hd__decap_3
XFILLER_23_923 VGND VGND VPWR VPWR sky130_fd_sc_hd__decap_3
XFILLER_74_1347 VGND VGND VPWR VPWR sky130_fd_sc_hd__decap_3
XFILLER_35_794 VGND VGND VPWR VPWR sky130_fd_sc_hd__decap_3
X_6875_ _7036_/CLK _6875_/D fanout823/X VGND VGND VPWR VPWR _6875_/Q sky130_fd_sc_hd__dfrtp_2
XFILLER_34_282 VGND VGND VPWR VPWR sky130_fd_sc_hd__decap_3
XFILLER_23_967 VGND VGND VPWR VPWR sky130_fd_sc_hd__decap_3
X_5826_ _5826_/A0 _5826_/A1 _5831_/S VGND VGND VPWR VPWR _6844_/D sky130_fd_sc_hd__mux2_1
XFILLER_22_477 VGND VGND VPWR VPWR sky130_fd_sc_hd__decap_3
XFILLER_37_1180 VGND VGND VPWR VPWR sky130_fd_sc_hd__decap_3
XFILLER_50_797 VGND VGND VPWR VPWR sky130_fd_sc_hd__decap_3
X_5757_ _5923_/A1 _5757_/A1 _5757_/S VGND VGND VPWR VPWR _6801_/D sky130_fd_sc_hd__mux2_1
XFILLER_33_1044 VGND VGND VPWR VPWR sky130_fd_sc_hd__decap_3
XTAP_TAPCELL_ROW_40_1234 VGND VPWR sky130_fd_sc_hd__tapvpwrvgnd_1
XTAP_TAPCELL_ROW_40_1245 VGND VPWR sky130_fd_sc_hd__tapvpwrvgnd_1
XPHY_EDGE_ROW_62_Left_143 VGND VGND VPWR VPWR sky130_fd_sc_hd__decap_3
X_4708_ _6317_/Q wire60/X _4705_/X _4707_/X VGND VGND VPWR VPWR _6317_/D sky130_fd_sc_hd__o22a_2
X_5688_ _5688_/A0 _5688_/A1 _5693_/S VGND VGND VPWR VPWR _6740_/D sky130_fd_sc_hd__mux2_1
XFILLER_11_1331 VGND VGND VPWR VPWR sky130_fd_sc_hd__decap_3
XFILLER_50_1391 VGND VGND VPWR VPWR sky130_fd_sc_hd__decap_3
X_4639_ _6548_/Q _4696_/B _4817_/A1 VGND VGND VPWR VPWR _4639_/X sky130_fd_sc_hd__a21bo_2
XFILLER_11_1375 VGND VGND VPWR VPWR sky130_fd_sc_hd__decap_3
XFILLER_2_816 VGND VGND VPWR VPWR sky130_fd_sc_hd__decap_3
XTAP_TAPCELL_ROW_9_426 VGND VPWR sky130_fd_sc_hd__tapvpwrvgnd_1
XFILLER_78_27 VGND VGND VPWR VPWR sky130_fd_sc_hd__fill_1
XTAP_TAPCELL_ROW_9_437 VGND VPWR sky130_fd_sc_hd__tapvpwrvgnd_1
XFILLER_78_38 VGND VGND VPWR VPWR sky130_fd_sc_hd__decap_3
XFILLER_2_849 VGND VGND VPWR VPWR sky130_fd_sc_hd__decap_3
XFILLER_46_1427 VGND VGND VPWR VPWR sky130_fd_sc_hd__fill_1
XFILLER_1_337 VGND VGND VPWR VPWR sky130_fd_sc_hd__decap_3
X_6309_ _7015_/CLK _6309_/D fanout793/X VGND VGND VPWR VPWR _6309_/Q sky130_fd_sc_hd__dfrtp_2
XFILLER_46_1438 VGND VGND VPWR VPWR sky130_fd_sc_hd__decap_3
XTAP_TAPCELL_ROW_38_1185 VGND VPWR sky130_fd_sc_hd__tapvpwrvgnd_1
XTAP_TAPCELL_ROW_38_1196 VGND VPWR sky130_fd_sc_hd__tapvpwrvgnd_1
XFILLER_58_831 VGND VGND VPWR VPWR sky130_fd_sc_hd__fill_1
XPHY_EDGE_ROW_71_Left_152 VGND VGND VPWR VPWR sky130_fd_sc_hd__decap_3
XFILLER_69_190 VGND VGND VPWR VPWR sky130_fd_sc_hd__fill_2
Xhold1340 _6923_/Q VGND VGND VPWR VPWR _5917_/A0 sky130_fd_sc_hd__dlygate4sd3_1
XFILLER_40_1026 VGND VGND VPWR VPWR sky130_fd_sc_hd__decap_3
XFILLER_57_352 VGND VGND VPWR VPWR sky130_fd_sc_hd__decap_3
XFILLER_58_875 VGND VGND VPWR VPWR sky130_fd_sc_hd__decap_3
XFILLER_45_503 VGND VGND VPWR VPWR sky130_fd_sc_hd__fill_1
Xhold1351 _6505_/Q VGND VGND VPWR VPWR _5393_/A1 sky130_fd_sc_hd__dlygate4sd3_1
XFILLER_79_1225 VGND VGND VPWR VPWR sky130_fd_sc_hd__decap_3
Xhold1362 _6622_/Q VGND VGND VPWR VPWR _5539_/B1 sky130_fd_sc_hd__dlygate4sd3_1
XFILLER_57_374 VGND VGND VPWR VPWR sky130_fd_sc_hd__fill_2
XFILLER_58_897 VGND VGND VPWR VPWR sky130_fd_sc_hd__decap_3
XFILLER_79_1236 VGND VGND VPWR VPWR sky130_fd_sc_hd__decap_3
XFILLER_18_739 VGND VGND VPWR VPWR sky130_fd_sc_hd__fill_1
Xhold1373 _6629_/Q VGND VGND VPWR VPWR _5546_/B1 sky130_fd_sc_hd__dlygate4sd3_1
Xhold1384 _6482_/Q VGND VGND VPWR VPWR _5370_/A1 sky130_fd_sc_hd__dlygate4sd3_1
XFILLER_57_385 VGND VGND VPWR VPWR sky130_fd_sc_hd__decap_3
Xhold1395 _6206_/Q VGND VGND VPWR VPWR _3465_/A0 sky130_fd_sc_hd__dlygate4sd3_1
XFILLER_79_1269 VGND VGND VPWR VPWR sky130_fd_sc_hd__decap_3
XFILLER_32_208 VGND VGND VPWR VPWR sky130_fd_sc_hd__decap_3
XFILLER_32_219 VGND VGND VPWR VPWR sky130_fd_sc_hd__fill_1
XFILLER_26_783 VGND VGND VPWR VPWR sky130_fd_sc_hd__decap_3
XFILLER_13_422 VGND VGND VPWR VPWR sky130_fd_sc_hd__decap_3
XFILLER_43_41 VGND VGND VPWR VPWR sky130_fd_sc_hd__decap_3
XFILLER_40_241 VGND VGND VPWR VPWR sky130_fd_sc_hd__fill_1
XFILLER_43_63 VGND VGND VPWR VPWR sky130_fd_sc_hd__fill_2
XFILLER_13_477 VGND VGND VPWR VPWR sky130_fd_sc_hd__decap_3
XFILLER_9_426 VGND VGND VPWR VPWR sky130_fd_sc_hd__decap_3
XFILLER_16_1220 VGND VGND VPWR VPWR sky130_fd_sc_hd__decap_3
XFILLER_43_74 VGND VGND VPWR VPWR sky130_fd_sc_hd__decap_3
XPHY_EDGE_ROW_80_Left_161 VGND VGND VPWR VPWR sky130_fd_sc_hd__decap_3
XFILLER_51_1111 VGND VGND VPWR VPWR sky130_fd_sc_hd__decap_3
XFILLER_40_285 VGND VGND VPWR VPWR sky130_fd_sc_hd__fill_1
XFILLER_16_1253 VGND VGND VPWR VPWR sky130_fd_sc_hd__decap_3
XFILLER_16_1264 VGND VGND VPWR VPWR sky130_fd_sc_hd__decap_3
XFILLER_16_1297 VGND VGND VPWR VPWR sky130_fd_sc_hd__decap_3
XFILLER_51_1199 VGND VGND VPWR VPWR sky130_fd_sc_hd__decap_3
XFILLER_5_632 VGND VGND VPWR VPWR sky130_fd_sc_hd__decap_3
XFILLER_5_654 VGND VGND VPWR VPWR sky130_fd_sc_hd__decap_3
XFILLER_4_131 VGND VGND VPWR VPWR sky130_fd_sc_hd__decap_3
XFILLER_57_9 VGND VGND VPWR VPWR sky130_fd_sc_hd__decap_3
XFILLER_5_676 VGND VGND VPWR VPWR sky130_fd_sc_hd__decap_3
XFILLER_4_24 VGND VGND VPWR VPWR sky130_fd_sc_hd__decap_3
XFILLER_4_35 VGND VGND VPWR VPWR sky130_fd_sc_hd__decap_3
XFILLER_49_1073 VGND VGND VPWR VPWR sky130_fd_sc_hd__decap_3
XFILLER_4_68 VGND VGND VPWR VPWR sky130_fd_sc_hd__decap_3
XFILLER_7_1410 VGND VGND VPWR VPWR sky130_fd_sc_hd__decap_3
XFILLER_1_871 VGND VGND VPWR VPWR sky130_fd_sc_hd__decap_3
XFILLER_68_71 VGND VGND VPWR VPWR sky130_fd_sc_hd__fill_1
XFILLER_27_1360 VGND VGND VPWR VPWR sky130_fd_sc_hd__decap_3
XFILLER_67_116 VGND VGND VPWR VPWR sky130_fd_sc_hd__decap_3
XFILLER_7_1443 VGND VGND VPWR VPWR sky130_fd_sc_hd__decap_3
XFILLER_27_1393 VGND VGND VPWR VPWR sky130_fd_sc_hd__decap_3
XFILLER_62_1273 VGND VGND VPWR VPWR sky130_fd_sc_hd__decap_3
XFILLER_3_1307 VGND VGND VPWR VPWR sky130_fd_sc_hd__decap_3
XFILLER_23_1257 VGND VGND VPWR VPWR sky130_fd_sc_hd__decap_3
XFILLER_36_503 VGND VGND VPWR VPWR sky130_fd_sc_hd__decap_3
XTAP_TAPCELL_ROW_19_701 VGND VPWR sky130_fd_sc_hd__tapvpwrvgnd_1
XFILLER_48_363 VGND VGND VPWR VPWR sky130_fd_sc_hd__fill_1
XFILLER_64_845 VGND VGND VPWR VPWR sky130_fd_sc_hd__decap_3
XFILLER_58_1309 VGND VGND VPWR VPWR sky130_fd_sc_hd__decap_3
XFILLER_75_193 VGND VGND VPWR VPWR sky130_fd_sc_hd__decap_3
XFILLER_1_1042 VGND VGND VPWR VPWR sky130_fd_sc_hd__decap_3
XFILLER_64_878 VGND VGND VPWR VPWR sky130_fd_sc_hd__decap_3
X_4990_ _4988_/X _4989_/Y wire112/X VGND VGND VPWR VPWR _4992_/S sky130_fd_sc_hd__a21oi_2
XFILLER_17_761 VGND VGND VPWR VPWR sky130_fd_sc_hd__decap_3
XFILLER_56_1000 VGND VGND VPWR VPWR sky130_fd_sc_hd__decap_3
XFILLER_51_528 VGND VGND VPWR VPWR sky130_fd_sc_hd__decap_3
XFILLER_63_388 VGND VGND VPWR VPWR sky130_fd_sc_hd__decap_3
XFILLER_1_1086 VGND VGND VPWR VPWR sky130_fd_sc_hd__decap_3
XFILLER_17_794 VGND VGND VPWR VPWR sky130_fd_sc_hd__decap_3
X_3941_ _6230_/Q _3948_/A2 _3948_/B1 _6222_/Q _3948_/C1 VGND VGND VPWR VPWR _3941_/X
+ sky130_fd_sc_hd__a221o_2
XFILLER_44_580 VGND VGND VPWR VPWR sky130_fd_sc_hd__decap_3
XFILLER_56_1033 VGND VGND VPWR VPWR sky130_fd_sc_hd__decap_3
XTAP_TAPCELL_ROW_80_2271 VGND VPWR sky130_fd_sc_hd__tapvpwrvgnd_1
XFILLER_20_904 VGND VGND VPWR VPWR sky130_fd_sc_hd__decap_3
X_3872_ _4316_/B _4326_/B VGND VGND VPWR VPWR _4240_/A sky130_fd_sc_hd__xnor2_2
X_6660_ _7007_/CLK _6660_/D load_slew822/X VGND VGND VPWR VPWR _6660_/Q sky130_fd_sc_hd__dfrtp_2
XTAP_TAPCELL_ROW_80_2282 VGND VPWR sky130_fd_sc_hd__tapvpwrvgnd_1
XTAP_TAPCELL_ROW_80_2293 VGND VPWR sky130_fd_sc_hd__tapvpwrvgnd_1
XFILLER_32_786 VGND VGND VPWR VPWR sky130_fd_sc_hd__decap_3
XFILLER_34_1320 VGND VGND VPWR VPWR sky130_fd_sc_hd__decap_3
X_5611_ _7095_/Q _7095_/D VGND VGND VPWR VPWR _5769_/A sky130_fd_sc_hd__and2b_2
X_6591_ _6897_/CLK _6591_/D wire712/X VGND VGND VPWR VPWR _6591_/Q sky130_fd_sc_hd__dfrtp_2
XFILLER_34_1353 VGND VGND VPWR VPWR sky130_fd_sc_hd__decap_3
X_5542_ _6375_/Q _5566_/A2 _5542_/B1 _5566_/B2 VGND VGND VPWR VPWR _6625_/D sky130_fd_sc_hd__a22o_2
XTAP_TAPCELL_ROW_30_976 VGND VPWR sky130_fd_sc_hd__tapvpwrvgnd_1
XFILLER_34_1397 VGND VGND VPWR VPWR sky130_fd_sc_hd__decap_3
XTAP_TAPCELL_ROW_30_987 VGND VPWR sky130_fd_sc_hd__tapvpwrvgnd_1
XFILLER_69_1416 VGND VGND VPWR VPWR sky130_fd_sc_hd__decap_3
X_5473_ _5473_/A1 _5476_/A2 _4853_/X VGND VGND VPWR VPWR _6585_/D sky130_fd_sc_hd__a21o_2
XFILLER_69_1449 VGND VGND VPWR VPWR sky130_fd_sc_hd__decap_3
X_4424_ _3098_/A _4421_/X _4422_/Y _4423_/X _4772_/C1 VGND VGND VPWR VPWR _4424_/X
+ sky130_fd_sc_hd__o221a_2
X_4355_ _4355_/A _4723_/C VGND VGND VPWR VPWR _4356_/B sky130_fd_sc_hd__nand2_2
Xfanout405 _4881_/A VGND VGND VPWR VPWR _4683_/A sky130_fd_sc_hd__clkdlybuf4s25_1
XFILLER_28_1135 VGND VGND VPWR VPWR sky130_fd_sc_hd__decap_3
Xfanout416 _3107_/X VGND VGND VPWR VPWR _3207_/B2 sky130_fd_sc_hd__clkdlybuf4s25_1
XFILLER_67_1195 VGND VGND VPWR VPWR sky130_fd_sc_hd__decap_3
Xfanout427 _3090_/X VGND VGND VPWR VPWR _3902_/B1 sky130_fd_sc_hd__clkdlybuf4s25_1
XFILLER_8_1229 VGND VGND VPWR VPWR sky130_fd_sc_hd__decap_3
X_3306_ _6280_/Q _6384_/Q VGND VGND VPWR VPWR _3306_/X sky130_fd_sc_hd__xor2_2
Xfanout438 _5107_/A VGND VGND VPWR VPWR _5083_/A sky130_fd_sc_hd__clkdlybuf4s25_1
XFILLER_58_105 VGND VGND VPWR VPWR sky130_fd_sc_hd__decap_3
X_7074_ _7076_/CLK _7074_/D load_slew679/X VGND VGND VPWR VPWR _7074_/Q sky130_fd_sc_hd__dfrtp_2
X_4286_ _6337_/Q _4765_/A2 _3260_/X _4861_/B2 VGND VGND VPWR VPWR _4286_/X sky130_fd_sc_hd__a22o_2
Xfanout449 _3043_/Y VGND VGND VPWR VPWR _4420_/C sky130_fd_sc_hd__clkdlybuf4s25_1
XFILLER_45_1460 VGND VGND VPWR VPWR sky130_fd_sc_hd__decap_3
XFILLER_80_1351 VGND VGND VPWR VPWR sky130_fd_sc_hd__decap_3
XFILLER_58_138 VGND VGND VPWR VPWR sky130_fd_sc_hd__fill_2
XFILLER_41_1313 VGND VGND VPWR VPWR sky130_fd_sc_hd__decap_3
XFILLER_80_1373 VGND VGND VPWR VPWR sky130_fd_sc_hd__decap_3
X_3237_ hold951/X _3236_/X _3429_/S VGND VGND VPWR VPWR _6092_/D sky130_fd_sc_hd__mux2_1
X_6025_ hold896/X _7029_/Q _6033_/S VGND VGND VPWR VPWR _6025_/X sky130_fd_sc_hd__mux2_1
XTAP_TAPCELL_ROW_33_1060 VGND VPWR sky130_fd_sc_hd__tapvpwrvgnd_1
XTAP_TAPCELL_ROW_33_1071 VGND VPWR sky130_fd_sc_hd__tapvpwrvgnd_1
XFILLER_27_503 VGND VGND VPWR VPWR sky130_fd_sc_hd__fill_1
XFILLER_41_1357 VGND VGND VPWR VPWR sky130_fd_sc_hd__decap_3
XFILLER_73_119 VGND VGND VPWR VPWR sky130_fd_sc_hd__decap_3
X_3168_ _7061_/Q _3167_/X _3225_/S VGND VGND VPWR VPWR uo_out[3] sky130_fd_sc_hd__mux2_1
XFILLER_64_18 VGND VGND VPWR VPWR sky130_fd_sc_hd__decap_3
XFILLER_64_29 VGND VGND VPWR VPWR sky130_fd_sc_hd__decap_3
XFILLER_76_1409 VGND VGND VPWR VPWR sky130_fd_sc_hd__decap_3
XFILLER_27_547 VGND VGND VPWR VPWR sky130_fd_sc_hd__fill_1
X_3099_ _3489_/A _3077_/B _4338_/A VGND VGND VPWR VPWR _7082_/D sky130_fd_sc_hd__a21o_2
XFILLER_70_826 VGND VGND VPWR VPWR sky130_fd_sc_hd__decap_3
XFILLER_42_517 VGND VGND VPWR VPWR sky130_fd_sc_hd__decap_3
XFILLER_74_1111 VGND VGND VPWR VPWR sky130_fd_sc_hd__decap_3
X_6927_ _7054_/CLK _6927_/D load_slew757/X VGND VGND VPWR VPWR _6927_/Q sky130_fd_sc_hd__dfrtp_2
XFILLER_78_1291 VGND VGND VPWR VPWR sky130_fd_sc_hd__decap_3
XFILLER_70_859 VGND VGND VPWR VPWR sky130_fd_sc_hd__decap_3
XFILLER_39_1242 VGND VGND VPWR VPWR sky130_fd_sc_hd__decap_3
XFILLER_74_1144 VGND VGND VPWR VPWR sky130_fd_sc_hd__decap_3
XFILLER_74_1155 VGND VGND VPWR VPWR sky130_fd_sc_hd__decap_3
XFILLER_39_1275 VGND VGND VPWR VPWR sky130_fd_sc_hd__decap_3
Xfanout34 _4891_/B1 VGND VGND VPWR VPWR _4833_/B1 sky130_fd_sc_hd__clkdlybuf4s25_1
X_6858_ _6858_/CLK _6858_/D wire652/X VGND VGND VPWR VPWR _6858_/Q sky130_fd_sc_hd__dfrtp_2
Xfanout45 fanout47/X VGND VGND VPWR VPWR _4758_/B1 sky130_fd_sc_hd__clkdlybuf4s25_1
XFILLER_74_1188 VGND VGND VPWR VPWR sky130_fd_sc_hd__decap_3
XFILLER_11_926 VGND VGND VPWR VPWR sky130_fd_sc_hd__fill_1
Xfanout67 _4106_/Y VGND VGND VPWR VPWR _4664_/S sky130_fd_sc_hd__clkdlybuf4s25_1
XFILLER_10_414 VGND VGND VPWR VPWR sky130_fd_sc_hd__decap_3
XFILLER_23_797 VGND VGND VPWR VPWR sky130_fd_sc_hd__fill_2
Xfanout78 fanout78/A VGND VGND VPWR VPWR _4069_/A2 sky130_fd_sc_hd__clkdlybuf4s25_1
X_5809_ _5793_/C _5809_/A1 _5813_/S VGND VGND VPWR VPWR _6829_/D sky130_fd_sc_hd__mux2_1
XFILLER_13_33 VGND VGND VPWR VPWR sky130_fd_sc_hd__decap_3
XFILLER_22_285 VGND VGND VPWR VPWR sky130_fd_sc_hd__decap_3
XFILLER_13_1404 VGND VGND VPWR VPWR sky130_fd_sc_hd__decap_3
X_6789_ clkload7/A _6789_/D wire639/X VGND VGND VPWR VPWR _6789_/Q sky130_fd_sc_hd__dfrtp_2
XFILLER_52_1453 VGND VGND VPWR VPWR sky130_fd_sc_hd__decap_3
XFILLER_6_407 VGND VGND VPWR VPWR sky130_fd_sc_hd__decap_3
XFILLER_10_469 VGND VGND VPWR VPWR sky130_fd_sc_hd__decap_3
XFILLER_13_1437 VGND VGND VPWR VPWR sky130_fd_sc_hd__decap_3
Xclkbuf_4_4__f_clk clkbuf_3_2_0_clk/X VGND VGND VPWR VPWR clkbuf_4_4__f_clk/X sky130_fd_sc_hd__clkbuf_16
XFILLER_2_613 VGND VGND VPWR VPWR sky130_fd_sc_hd__decap_3
XFILLER_11_1183 VGND VGND VPWR VPWR sky130_fd_sc_hd__decap_3
XFILLER_1_134 VGND VGND VPWR VPWR sky130_fd_sc_hd__decap_3
XFILLER_2_657 VGND VGND VPWR VPWR sky130_fd_sc_hd__decap_3
XFILLER_78_915 VGND VGND VPWR VPWR sky130_fd_sc_hd__decap_3
XFILLER_46_1235 VGND VGND VPWR VPWR sky130_fd_sc_hd__decap_3
XFILLER_77_414 VGND VGND VPWR VPWR sky130_fd_sc_hd__decap_3
XFILLER_1_167 VGND VGND VPWR VPWR sky130_fd_sc_hd__fill_1
XFILLER_1_178 VGND VGND VPWR VPWR sky130_fd_sc_hd__decap_3
XFILLER_46_1279 VGND VGND VPWR VPWR sky130_fd_sc_hd__decap_3
XFILLER_46_834 VGND VGND VPWR VPWR sky130_fd_sc_hd__decap_3
XFILLER_73_620 VGND VGND VPWR VPWR sky130_fd_sc_hd__decap_3
Xhold1170 _6782_/Q VGND VGND VPWR VPWR _5736_/A1 sky130_fd_sc_hd__dlygate4sd3_1
Xhold1181 _5976_/X VGND VGND VPWR VPWR _6980_/D sky130_fd_sc_hd__dlygate4sd3_1
XFILLER_18_558 VGND VGND VPWR VPWR sky130_fd_sc_hd__decap_3
Xhold1192 _6793_/Q VGND VGND VPWR VPWR _5748_/A1 sky130_fd_sc_hd__dlygate4sd3_1
XFILLER_46_867 VGND VGND VPWR VPWR sky130_fd_sc_hd__fill_1
XFILLER_46_878 VGND VGND VPWR VPWR sky130_fd_sc_hd__fill_1
XFILLER_72_141 VGND VGND VPWR VPWR sky130_fd_sc_hd__decap_3
XFILLER_2_1362 VGND VGND VPWR VPWR sky130_fd_sc_hd__decap_3
XFILLER_79_1088 VGND VGND VPWR VPWR sky130_fd_sc_hd__decap_3
XFILLER_2_1373 VGND VGND VPWR VPWR sky130_fd_sc_hd__decap_3
XFILLER_33_517 VGND VGND VPWR VPWR sky130_fd_sc_hd__decap_3
XFILLER_57_1331 VGND VGND VPWR VPWR sky130_fd_sc_hd__decap_3
XFILLER_45_399 VGND VGND VPWR VPWR sky130_fd_sc_hd__decap_3
XFILLER_60_336 VGND VGND VPWR VPWR sky130_fd_sc_hd__fill_2
XFILLER_18_1315 VGND VGND VPWR VPWR sky130_fd_sc_hd__fill_1
XFILLER_18_1326 VGND VGND VPWR VPWR sky130_fd_sc_hd__decap_3
XFILLER_57_1375 VGND VGND VPWR VPWR sky130_fd_sc_hd__decap_3
XFILLER_41_561 VGND VGND VPWR VPWR sky130_fd_sc_hd__decap_3
XFILLER_53_1239 VGND VGND VPWR VPWR sky130_fd_sc_hd__decap_3
XFILLER_18_1359 VGND VGND VPWR VPWR sky130_fd_sc_hd__decap_3
XFILLER_9_234 VGND VGND VPWR VPWR sky130_fd_sc_hd__decap_3
XFILLER_70_50 VGND VGND VPWR VPWR sky130_fd_sc_hd__decap_3
XFILLER_9_267 VGND VGND VPWR VPWR sky130_fd_sc_hd__fill_2
XFILLER_9_278 VGND VGND VPWR VPWR sky130_fd_sc_hd__fill_2
Xclkload15 _7016_/CLK VGND VGND VPWR VPWR clkload15/X sky130_fd_sc_hd__clkbuf_4
Xclkload26 _7096_/CLK VGND VGND VPWR VPWR clkload26/X sky130_fd_sc_hd__clkbuf_8
XTAP_TAPCELL_ROW_11_475 VGND VPWR sky130_fd_sc_hd__tapvpwrvgnd_1
Xclkload37 _6982_/CLK VGND VGND VPWR VPWR clkload37/X sky130_fd_sc_hd__clkbuf_8
XTAP_TAPCELL_ROW_11_486 VGND VPWR sky130_fd_sc_hd__tapvpwrvgnd_1
XTAP_TAPCELL_ROW_11_497 VGND VPWR sky130_fd_sc_hd__tapvpwrvgnd_1
Xclkload48 _6923_/CLK VGND VGND VPWR VPWR clkload48/X sky130_fd_sc_hd__clkbuf_8
Xclkload59 _7007_/CLK VGND VGND VPWR VPWR clkload59/X sky130_fd_sc_hd__clkbuf_4
XFILLER_6_974 VGND VGND VPWR VPWR sky130_fd_sc_hd__decap_3
XFILLER_55_6 VGND VGND VPWR VPWR sky130_fd_sc_hd__decap_3
XFILLER_5_473 VGND VGND VPWR VPWR sky130_fd_sc_hd__decap_3
XFILLER_29_1422 VGND VGND VPWR VPWR sky130_fd_sc_hd__decap_3
XFILLER_79_81 VGND VGND VPWR VPWR sky130_fd_sc_hd__decap_3
XFILLER_29_1455 VGND VGND VPWR VPWR sky130_fd_sc_hd__fill_1
XFILLER_64_1335 VGND VGND VPWR VPWR sky130_fd_sc_hd__decap_3
XFILLER_29_1466 VGND VGND VPWR VPWR sky130_fd_sc_hd__decap_3
X_4140_ _4140_/A _4220_/B VGND VGND VPWR VPWR _4222_/B sky130_fd_sc_hd__xnor2_2
XFILLER_25_1319 VGND VGND VPWR VPWR sky130_fd_sc_hd__decap_3
XFILLER_64_1368 VGND VGND VPWR VPWR sky130_fd_sc_hd__decap_3
XFILLER_69_959 VGND VGND VPWR VPWR sky130_fd_sc_hd__decap_3
XFILLER_64_1379 VGND VGND VPWR VPWR sky130_fd_sc_hd__decap_3
X_4071_ _4732_/A _4071_/B VGND VGND VPWR VPWR _4071_/Y sky130_fd_sc_hd__nor2_2
XFILLER_7_1251 VGND VGND VPWR VPWR sky130_fd_sc_hd__decap_3
XFILLER_3_1104 VGND VGND VPWR VPWR sky130_fd_sc_hd__decap_3
XFILLER_7_1284 VGND VGND VPWR VPWR sky130_fd_sc_hd__decap_3
XFILLER_55_119 VGND VGND VPWR VPWR sky130_fd_sc_hd__decap_3
XFILLER_7_1295 VGND VGND VPWR VPWR sky130_fd_sc_hd__decap_3
XFILLER_37_823 VGND VGND VPWR VPWR sky130_fd_sc_hd__decap_3
XFILLER_23_1065 VGND VGND VPWR VPWR sky130_fd_sc_hd__decap_3
XFILLER_3_1148 VGND VGND VPWR VPWR sky130_fd_sc_hd__decap_3
XFILLER_37_867 VGND VGND VPWR VPWR sky130_fd_sc_hd__decap_3
XFILLER_48_193 VGND VGND VPWR VPWR sky130_fd_sc_hd__decap_3
XFILLER_37_889 VGND VGND VPWR VPWR sky130_fd_sc_hd__decap_3
XFILLER_36_388 VGND VGND VPWR VPWR sky130_fd_sc_hd__decap_3
XFILLER_75_1431 VGND VGND VPWR VPWR sky130_fd_sc_hd__decap_3
X_4973_ _6418_/Q _4973_/B VGND VGND VPWR VPWR _5228_/B sky130_fd_sc_hd__xnor2_2
XFILLER_63_196 VGND VGND VPWR VPWR sky130_fd_sc_hd__decap_3
X_6712_ _7095_/CLK _6712_/D fanout697/X VGND VGND VPWR VPWR _6712_/Q sky130_fd_sc_hd__dfrtp_2
XFILLER_36_1415 VGND VGND VPWR VPWR sky130_fd_sc_hd__decap_3
X_3924_ _3722_/A _6318_/Q VGND VGND VPWR VPWR _3924_/X sky130_fd_sc_hd__and2b_2
XFILLER_51_369 VGND VGND VPWR VPWR sky130_fd_sc_hd__decap_3
XFILLER_71_1328 VGND VGND VPWR VPWR sky130_fd_sc_hd__decap_3
XFILLER_32_561 VGND VGND VPWR VPWR sky130_fd_sc_hd__decap_3
XFILLER_36_1459 VGND VGND VPWR VPWR sky130_fd_sc_hd__decap_3
XFILLER_20_734 VGND VGND VPWR VPWR sky130_fd_sc_hd__decap_3
X_6643_ _7011_/CLK _6643_/D fanout802/X VGND VGND VPWR VPWR _6643_/Q sky130_fd_sc_hd__dfrtp_2
X_3855_ _3855_/A _3855_/B _3855_/C VGND VGND VPWR VPWR _3913_/B sky130_fd_sc_hd__nand3_2
Xclkload9 clkload9/A VGND VGND VPWR VPWR clkload9/X sky130_fd_sc_hd__clkbuf_4
X_3786_ _3786_/A _3786_/B _3786_/C VGND VGND VPWR VPWR _3787_/B sky130_fd_sc_hd__and3_2
X_6574_ _6912_/CLK _6574_/D wire715/X VGND VGND VPWR VPWR _6574_/Q sky130_fd_sc_hd__dfrtp_2
XFILLER_69_1213 VGND VGND VPWR VPWR sky130_fd_sc_hd__decap_3
X_5525_ _6612_/Q _6617_/Q VGND VGND VPWR VPWR _5525_/Y sky130_fd_sc_hd__nand2_2
XFILLER_69_1257 VGND VGND VPWR VPWR sky130_fd_sc_hd__decap_3
X_5456_ _5456_/A1 _5456_/A2 _4727_/X VGND VGND VPWR VPWR _6568_/D sky130_fd_sc_hd__a21o_2
X_4407_ _4403_/Y _4404_/X _4406_/Y _4558_/A VGND VGND VPWR VPWR _4407_/X sky130_fd_sc_hd__o211a_2
XTAP_TAPCELL_ROW_35_1100 VGND VPWR sky130_fd_sc_hd__tapvpwrvgnd_1
XTAP_TAPCELL_ROW_35_1111 VGND VPWR sky130_fd_sc_hd__tapvpwrvgnd_1
X_5387_ _5387_/A1 _5480_/A2 _3851_/X VGND VGND VPWR VPWR _6499_/D sky130_fd_sc_hd__a21o_2
Xfanout202 _3413_/S VGND VGND VPWR VPWR _3421_/S sky130_fd_sc_hd__clkdlybuf4s25_1
XTAP_TAPCELL_ROW_35_1122 VGND VPWR sky130_fd_sc_hd__tapvpwrvgnd_1
Xfanout213 _6061_/S VGND VGND VPWR VPWR _6060_/S sky130_fd_sc_hd__clkdlybuf4s25_1
Xfanout224 _5955_/S VGND VGND VPWR VPWR _5975_/S sky130_fd_sc_hd__clkdlybuf4s25_1
X_4338_ _4338_/A _4710_/B VGND VGND VPWR VPWR _4338_/Y sky130_fd_sc_hd__nand2_2
XFILLER_43_1419 VGND VGND VPWR VPWR sky130_fd_sc_hd__decap_3
XFILLER_8_1037 VGND VGND VPWR VPWR sky130_fd_sc_hd__decap_3
Xfanout246 _5465_/A2 VGND VGND VPWR VPWR _5474_/A2 sky130_fd_sc_hd__clkdlybuf4s25_1
XTAP_TAPCELL_ROW_31_1008 VGND VPWR sky130_fd_sc_hd__tapvpwrvgnd_1
XTAP_TAPCELL_ROW_31_1019 VGND VPWR sky130_fd_sc_hd__tapvpwrvgnd_1
Xfanout268 _4541_/A VGND VGND VPWR VPWR _4431_/B sky130_fd_sc_hd__clkdlybuf4s25_1
XFILLER_59_458 VGND VGND VPWR VPWR sky130_fd_sc_hd__decap_3
X_4269_ _4269_/A _4303_/A VGND VGND VPWR VPWR _4270_/B sky130_fd_sc_hd__xor2_2
X_7057_ _7057_/CLK _7057_/D fanout708/X VGND VGND VPWR VPWR _7057_/Q sky130_fd_sc_hd__dfrtp_2
Xfanout279 _4396_/A VGND VGND VPWR VPWR _4405_/B sky130_fd_sc_hd__clkdlybuf4s25_1
XFILLER_80_1170 VGND VGND VPWR VPWR sky130_fd_sc_hd__decap_3
XFILLER_75_39 VGND VGND VPWR VPWR sky130_fd_sc_hd__fill_2
XFILLER_74_417 VGND VGND VPWR VPWR sky130_fd_sc_hd__decap_3
XFILLER_41_1132 VGND VGND VPWR VPWR sky130_fd_sc_hd__decap_3
XFILLER_80_1192 VGND VGND VPWR VPWR sky130_fd_sc_hd__decap_3
X_6008_ hold909/X _6008_/A1 _6047_/S VGND VGND VPWR VPWR _7012_/D sky130_fd_sc_hd__mux2_1
XFILLER_28_823 VGND VGND VPWR VPWR sky130_fd_sc_hd__decap_3
XFILLER_68_992 VGND VGND VPWR VPWR sky130_fd_sc_hd__decap_3
XFILLER_28_834 VGND VGND VPWR VPWR sky130_fd_sc_hd__decap_3
Xclkbuf_4_12__f_clk clkbuf_3_6_0_clk/X VGND VGND VPWR VPWR clkbuf_leaf_56_clk/A sky130_fd_sc_hd__clkbuf_16
XFILLER_67_491 VGND VGND VPWR VPWR sky130_fd_sc_hd__decap_3
XFILLER_28_878 VGND VGND VPWR VPWR sky130_fd_sc_hd__decap_3
XFILLER_76_1217 VGND VGND VPWR VPWR sky130_fd_sc_hd__decap_3
XFILLER_54_141 VGND VGND VPWR VPWR sky130_fd_sc_hd__decap_3
XFILLER_15_528 VGND VGND VPWR VPWR sky130_fd_sc_hd__decap_3
XFILLER_27_399 VGND VGND VPWR VPWR sky130_fd_sc_hd__decap_3
XFILLER_70_645 VGND VGND VPWR VPWR sky130_fd_sc_hd__fill_1
XTAP_TAPCELL_ROW_65_1885 VGND VPWR sky130_fd_sc_hd__tapvpwrvgnd_1
XFILLER_23_561 VGND VGND VPWR VPWR sky130_fd_sc_hd__decap_3
XTAP_TAPCELL_ROW_65_1896 VGND VPWR sky130_fd_sc_hd__tapvpwrvgnd_1
XFILLER_11_712 VGND VGND VPWR VPWR sky130_fd_sc_hd__decap_3
XFILLER_39_1094 VGND VGND VPWR VPWR sky130_fd_sc_hd__fill_2
XFILLER_23_583 VGND VGND VPWR VPWR sky130_fd_sc_hd__decap_3
XFILLER_10_200 VGND VGND VPWR VPWR sky130_fd_sc_hd__fill_2
XFILLER_11_745 VGND VGND VPWR VPWR sky130_fd_sc_hd__decap_3
XTAP_TAPCELL_ROW_21_740 VGND VPWR sky130_fd_sc_hd__tapvpwrvgnd_1
XFILLER_13_1212 VGND VGND VPWR VPWR sky130_fd_sc_hd__decap_3
XFILLER_17_1381 VGND VGND VPWR VPWR sky130_fd_sc_hd__decap_3
XFILLER_52_1261 VGND VGND VPWR VPWR sky130_fd_sc_hd__decap_3
XTAP_TAPCELL_ROW_21_751 VGND VPWR sky130_fd_sc_hd__tapvpwrvgnd_1
XFILLER_13_1245 VGND VGND VPWR VPWR sky130_fd_sc_hd__decap_3
XFILLER_52_1294 VGND VGND VPWR VPWR sky130_fd_sc_hd__decap_3
XFILLER_13_1278 VGND VGND VPWR VPWR sky130_fd_sc_hd__decap_3
XFILLER_6_259 VGND VGND VPWR VPWR sky130_fd_sc_hd__decap_3
XFILLER_40_53 VGND VGND VPWR VPWR sky130_fd_sc_hd__decap_3
XFILLER_13_1289 VGND VGND VPWR VPWR sky130_fd_sc_hd__decap_3
XFILLER_3_900 VGND VGND VPWR VPWR sky130_fd_sc_hd__decap_3
XFILLER_2_410 VGND VGND VPWR VPWR sky130_fd_sc_hd__decap_3
XFILLER_3_977 VGND VGND VPWR VPWR sky130_fd_sc_hd__decap_3
XFILLER_2_454 VGND VGND VPWR VPWR sky130_fd_sc_hd__fill_1
XFILLER_78_701 VGND VGND VPWR VPWR sky130_fd_sc_hd__decap_3
XFILLER_3_999 VGND VGND VPWR VPWR sky130_fd_sc_hd__decap_3
XFILLER_78_745 VGND VGND VPWR VPWR sky130_fd_sc_hd__decap_3
XFILLER_66_907 VGND VGND VPWR VPWR sky130_fd_sc_hd__decap_3
XFILLER_49_95 VGND VGND VPWR VPWR sky130_fd_sc_hd__decap_3
XFILLER_19_801 VGND VGND VPWR VPWR sky130_fd_sc_hd__decap_3
XFILLER_24_1341 VGND VGND VPWR VPWR sky130_fd_sc_hd__decap_3
XFILLER_59_970 VGND VGND VPWR VPWR sky130_fd_sc_hd__fill_2
XFILLER_63_1390 VGND VGND VPWR VPWR sky130_fd_sc_hd__decap_3
Xfanout791 fanout791/A VGND VGND VPWR VPWR fanout791/X sky130_fd_sc_hd__clkdlybuf4s25_1
XFILLER_4_1424 VGND VGND VPWR VPWR sky130_fd_sc_hd__decap_3
XFILLER_1_36 VGND VGND VPWR VPWR sky130_fd_sc_hd__decap_3
XFILLER_4_1435 VGND VGND VPWR VPWR sky130_fd_sc_hd__decap_3
XFILLER_65_439 VGND VGND VPWR VPWR sky130_fd_sc_hd__fill_1
XFILLER_1_69 VGND VGND VPWR VPWR sky130_fd_sc_hd__decap_3
XFILLER_24_1385 VGND VGND VPWR VPWR sky130_fd_sc_hd__decap_3
XFILLER_4_1468 VGND VGND VPWR VPWR sky130_fd_sc_hd__fill_1
XFILLER_18_333 VGND VGND VPWR VPWR sky130_fd_sc_hd__fill_1
XFILLER_59_1404 VGND VGND VPWR VPWR sky130_fd_sc_hd__decap_3
XFILLER_80_409 VGND VGND VPWR VPWR sky130_fd_sc_hd__decap_3
XFILLER_20_1249 VGND VGND VPWR VPWR sky130_fd_sc_hd__decap_3
XFILLER_74_973 VGND VGND VPWR VPWR sky130_fd_sc_hd__decap_3
XFILLER_65_72 VGND VGND VPWR VPWR sky130_fd_sc_hd__decap_3
XFILLER_46_675 VGND VGND VPWR VPWR sky130_fd_sc_hd__fill_1
XFILLER_59_1437 VGND VGND VPWR VPWR sky130_fd_sc_hd__decap_3
XFILLER_2_1170 VGND VGND VPWR VPWR sky130_fd_sc_hd__decap_3
XFILLER_33_325 VGND VGND VPWR VPWR sky130_fd_sc_hd__decap_3
XFILLER_60_155 VGND VGND VPWR VPWR sky130_fd_sc_hd__fill_1
XFILLER_14_561 VGND VGND VPWR VPWR sky130_fd_sc_hd__decap_3
XFILLER_57_1172 VGND VGND VPWR VPWR sky130_fd_sc_hd__decap_3
XFILLER_57_1183 VGND VGND VPWR VPWR sky130_fd_sc_hd__decap_3
XFILLER_60_188 VGND VGND VPWR VPWR sky130_fd_sc_hd__decap_3
XFILLER_70_1350 VGND VGND VPWR VPWR sky130_fd_sc_hd__decap_3
X_3640_ _3663_/A _3640_/B VGND VGND VPWR VPWR _3879_/A sky130_fd_sc_hd__xor2_2
XFILLER_31_1301 VGND VGND VPWR VPWR sky130_fd_sc_hd__decap_3
XFILLER_31_1334 VGND VGND VPWR VPWR sky130_fd_sc_hd__decap_3
XFILLER_70_1394 VGND VGND VPWR VPWR sky130_fd_sc_hd__decap_3
XFILLER_31_1345 VGND VGND VPWR VPWR sky130_fd_sc_hd__decap_3
X_3571_ _6274_/Q _6282_/Q _6290_/Q _6226_/Q _3496_/B _3566_/A VGND VGND VPWR VPWR
+ _3571_/X sky130_fd_sc_hd__mux4_2
XFILLER_31_1378 VGND VGND VPWR VPWR sky130_fd_sc_hd__decap_3
X_5310_ _6786_/Q _4959_/B _5326_/S VGND VGND VPWR VPWR _5310_/X sky130_fd_sc_hd__mux2_1
X_6290_ _7015_/CLK _6290_/D fanout797/X VGND VGND VPWR VPWR _6290_/Q sky130_fd_sc_hd__dfrtp_2
XFILLER_53_3 VGND VGND VPWR VPWR sky130_fd_sc_hd__decap_3
XTAP_TAPCELL_ROW_71_2034 VGND VPWR sky130_fd_sc_hd__tapvpwrvgnd_1
X_5241_ _6760_/Q _5322_/S _5333_/S _5240_/Y VGND VGND VPWR VPWR _5241_/X sky130_fd_sc_hd__o211a_2
XFILLER_5_292 VGND VGND VPWR VPWR sky130_fd_sc_hd__decap_3
XTAP_TAPCELL_ROW_71_2045 VGND VPWR sky130_fd_sc_hd__tapvpwrvgnd_1
XTAP_TAPCELL_ROW_71_2056 VGND VPWR sky130_fd_sc_hd__tapvpwrvgnd_1
XFILLER_9_1313 VGND VGND VPWR VPWR sky130_fd_sc_hd__decap_3
XFILLER_64_1132 VGND VGND VPWR VPWR sky130_fd_sc_hd__decap_3
XFILLER_69_723 VGND VGND VPWR VPWR sky130_fd_sc_hd__decap_3
X_5172_ _6733_/Q _5332_/S VGND VGND VPWR VPWR _5172_/X sky130_fd_sc_hd__or2_2
XFILLER_29_1263 VGND VGND VPWR VPWR sky130_fd_sc_hd__decap_3
XFILLER_68_200 VGND VGND VPWR VPWR sky130_fd_sc_hd__fill_1
XFILLER_9_1357 VGND VGND VPWR VPWR sky130_fd_sc_hd__decap_3
XFILLER_64_1176 VGND VGND VPWR VPWR sky130_fd_sc_hd__decap_3
X_4123_ _4283_/A _4732_/B _4118_/X _4123_/B2 VGND VGND VPWR VPWR _4123_/X sky130_fd_sc_hd__o2bb2a_2
XFILLER_42_1441 VGND VGND VPWR VPWR sky130_fd_sc_hd__decap_3
Xinput2 ui_in[0] VGND VGND VPWR VPWR input2/X sky130_fd_sc_hd__clkdlybuf4s25_1
X_4054_ _6567_/Q _4602_/B _4779_/A1 VGND VGND VPWR VPWR _4054_/X sky130_fd_sc_hd__a21bo_2
XFILLER_37_620 VGND VGND VPWR VPWR sky130_fd_sc_hd__decap_3
XFILLER_7_1092 VGND VGND VPWR VPWR sky130_fd_sc_hd__decap_3
XFILLER_36_130 VGND VGND VPWR VPWR sky130_fd_sc_hd__decap_3
XFILLER_52_612 VGND VGND VPWR VPWR sky130_fd_sc_hd__decap_3
XFILLER_64_472 VGND VGND VPWR VPWR sky130_fd_sc_hd__decap_3
XFILLER_36_174 VGND VGND VPWR VPWR sky130_fd_sc_hd__decap_3
XFILLER_24_325 VGND VGND VPWR VPWR sky130_fd_sc_hd__decap_3
XFILLER_51_111 VGND VGND VPWR VPWR sky130_fd_sc_hd__fill_1
XFILLER_36_1201 VGND VGND VPWR VPWR sky130_fd_sc_hd__decap_3
XFILLER_12_509 VGND VGND VPWR VPWR sky130_fd_sc_hd__decap_3
XFILLER_75_1272 VGND VGND VPWR VPWR sky130_fd_sc_hd__decap_3
XFILLER_51_166 VGND VGND VPWR VPWR sky130_fd_sc_hd__fill_2
X_4956_ _6689_/Q _3055_/Y _5219_/A VGND VGND VPWR VPWR _4956_/X sky130_fd_sc_hd__mux2_1
XFILLER_33_881 VGND VGND VPWR VPWR sky130_fd_sc_hd__decap_3
XFILLER_36_1234 VGND VGND VPWR VPWR sky130_fd_sc_hd__decap_3
X_3907_ _4170_/A _3907_/B VGND VGND VPWR VPWR wire69/A sky130_fd_sc_hd__xnor2_2
XFILLER_71_1147 VGND VGND VPWR VPWR sky130_fd_sc_hd__decap_3
XFILLER_36_1267 VGND VGND VPWR VPWR sky130_fd_sc_hd__decap_3
X_4887_ _6590_/Q _4887_/B VGND VGND VPWR VPWR _4887_/Y sky130_fd_sc_hd__nand2_2
XFILLER_20_542 VGND VGND VPWR VPWR sky130_fd_sc_hd__fill_1
X_6626_ _6954_/CLK _6626_/D fanout649/X VGND VGND VPWR VPWR _6626_/Q sky130_fd_sc_hd__dfrtp_2
XTAP_TAPCELL_ROW_60_1760 VGND VPWR sky130_fd_sc_hd__tapvpwrvgnd_1
X_3838_ _4347_/A _4293_/A VGND VGND VPWR VPWR _3839_/B sky130_fd_sc_hd__xnor2_2
XTAP_TAPCELL_ROW_60_1771 VGND VPWR sky130_fd_sc_hd__tapvpwrvgnd_1
Xtt_um_aes128_optimized_850 VGND VGND VPWR VPWR tt_um_aes128_optimized_850/HI uio_oe[2]
+ sky130_fd_sc_hd__conb_1
XFILLER_20_597 VGND VGND VPWR VPWR sky130_fd_sc_hd__decap_3
X_6557_ _6926_/CLK _6557_/D fanout755/X VGND VGND VPWR VPWR _6557_/Q sky130_fd_sc_hd__dfrtp_2
XFILLER_10_1418 VGND VGND VPWR VPWR sky130_fd_sc_hd__decap_3
X_3769_ _6281_/Q _3928_/A2 _3928_/B1 _6257_/Q _3928_/C1 VGND VGND VPWR VPWR _3769_/X
+ sky130_fd_sc_hd__a221o_2
XFILLER_10_1429 VGND VGND VPWR VPWR sky130_fd_sc_hd__decap_3
XFILLER_10_12 VGND VGND VPWR VPWR sky130_fd_sc_hd__decap_3
X_5508_ _5508_/A _5508_/B VGND VGND VPWR VPWR _5508_/Y sky130_fd_sc_hd__nand2_2
XFILLER_69_1054 VGND VGND VPWR VPWR sky130_fd_sc_hd__decap_3
X_6488_ _6888_/CLK _6488_/D load_slew705/X VGND VGND VPWR VPWR _6488_/Q sky130_fd_sc_hd__dfrtp_2
XFILLER_69_1065 VGND VGND VPWR VPWR sky130_fd_sc_hd__decap_3
X_5439_ _5439_/A1 _5479_/A2 _4661_/X VGND VGND VPWR VPWR _6551_/D sky130_fd_sc_hd__a21o_2
XFILLER_0_903 VGND VGND VPWR VPWR sky130_fd_sc_hd__decap_3
XFILLER_0_925 VGND VGND VPWR VPWR sky130_fd_sc_hd__decap_3
XFILLER_47_1363 VGND VGND VPWR VPWR sky130_fd_sc_hd__decap_3
XFILLER_59_222 VGND VGND VPWR VPWR sky130_fd_sc_hd__fill_2
XFILLER_47_1396 VGND VGND VPWR VPWR sky130_fd_sc_hd__decap_3
XTAP_TAPCELL_ROW_54_1597 VGND VPWR sky130_fd_sc_hd__tapvpwrvgnd_1
XFILLER_75_726 VGND VGND VPWR VPWR sky130_fd_sc_hd__fill_2
XFILLER_59_277 VGND VGND VPWR VPWR sky130_fd_sc_hd__decap_3
XTAP_TAPCELL_ROW_2_240 VGND VPWR sky130_fd_sc_hd__tapvpwrvgnd_1
XTAP_TAPCELL_ROW_2_251 VGND VPWR sky130_fd_sc_hd__tapvpwrvgnd_1
XTAP_TAPCELL_ROW_2_262 VGND VPWR sky130_fd_sc_hd__tapvpwrvgnd_1
XTAP_TAPCELL_ROW_67_1936 VGND VPWR sky130_fd_sc_hd__tapvpwrvgnd_1
XFILLER_28_686 VGND VGND VPWR VPWR sky130_fd_sc_hd__decap_3
XTAP_TAPCELL_ROW_67_1947 VGND VPWR sky130_fd_sc_hd__tapvpwrvgnd_1
XFILLER_35_42 VGND VGND VPWR VPWR sky130_fd_sc_hd__decap_3
XFILLER_43_656 VGND VGND VPWR VPWR sky130_fd_sc_hd__decap_3
XFILLER_19_1410 VGND VGND VPWR VPWR sky130_fd_sc_hd__decap_3
XFILLER_15_369 VGND VGND VPWR VPWR sky130_fd_sc_hd__fill_2
XTAP_TAPCELL_ROW_26_865 VGND VPWR sky130_fd_sc_hd__tapvpwrvgnd_1
XTAP_TAPCELL_ROW_26_876 VGND VPWR sky130_fd_sc_hd__tapvpwrvgnd_1
XFILLER_54_1312 VGND VGND VPWR VPWR sky130_fd_sc_hd__decap_3
XFILLER_19_1443 VGND VGND VPWR VPWR sky130_fd_sc_hd__decap_3
XTAP_TAPCELL_ROW_26_887 VGND VPWR sky130_fd_sc_hd__tapvpwrvgnd_1
XFILLER_54_1323 VGND VGND VPWR VPWR sky130_fd_sc_hd__decap_3
XTAP_TAPCELL_ROW_13_526 VGND VPWR sky130_fd_sc_hd__tapvpwrvgnd_1
XTAP_TAPCELL_ROW_13_537 VGND VPWR sky130_fd_sc_hd__tapvpwrvgnd_1
XFILLER_15_1307 VGND VGND VPWR VPWR sky130_fd_sc_hd__decap_3
XFILLER_54_1356 VGND VGND VPWR VPWR sky130_fd_sc_hd__decap_3
XTAP_TAPCELL_ROW_13_548 VGND VPWR sky130_fd_sc_hd__tapvpwrvgnd_1
XFILLER_11_586 VGND VGND VPWR VPWR sky130_fd_sc_hd__decap_3
XFILLER_3_741 VGND VGND VPWR VPWR sky130_fd_sc_hd__fill_2
XFILLER_48_1149 VGND VGND VPWR VPWR sky130_fd_sc_hd__decap_3
XFILLER_2_251 VGND VGND VPWR VPWR sky130_fd_sc_hd__fill_1
XFILLER_3_785 VGND VGND VPWR VPWR sky130_fd_sc_hd__decap_3
XFILLER_26_1403 VGND VGND VPWR VPWR sky130_fd_sc_hd__decap_3
XFILLER_65_1452 VGND VGND VPWR VPWR sky130_fd_sc_hd__decap_3
XFILLER_2_273 VGND VGND VPWR VPWR sky130_fd_sc_hd__decap_3
XFILLER_65_1463 VGND VGND VPWR VPWR sky130_fd_sc_hd__decap_3
XFILLER_78_531 VGND VGND VPWR VPWR sky130_fd_sc_hd__fill_1
XFILLER_61_1316 VGND VGND VPWR VPWR sky130_fd_sc_hd__decap_3
XFILLER_26_1447 VGND VGND VPWR VPWR sky130_fd_sc_hd__decap_3
XFILLER_38_406 VGND VGND VPWR VPWR sky130_fd_sc_hd__fill_1
XFILLER_76_71 VGND VGND VPWR VPWR sky130_fd_sc_hd__decap_3
XFILLER_18_6 VGND VGND VPWR VPWR sky130_fd_sc_hd__decap_3
XFILLER_65_225 VGND VGND VPWR VPWR sky130_fd_sc_hd__fill_1
XFILLER_4_1232 VGND VGND VPWR VPWR sky130_fd_sc_hd__decap_3
XFILLER_65_247 VGND VGND VPWR VPWR sky130_fd_sc_hd__decap_3
XFILLER_20_1024 VGND VGND VPWR VPWR sky130_fd_sc_hd__decap_3
XFILLER_4_1276 VGND VGND VPWR VPWR sky130_fd_sc_hd__decap_3
XFILLER_34_623 VGND VGND VPWR VPWR sky130_fd_sc_hd__decap_3
XFILLER_59_1245 VGND VGND VPWR VPWR sky130_fd_sc_hd__decap_3
XFILLER_34_645 VGND VGND VPWR VPWR sky130_fd_sc_hd__decap_3
XFILLER_61_431 VGND VGND VPWR VPWR sky130_fd_sc_hd__fill_1
XFILLER_33_133 VGND VGND VPWR VPWR sky130_fd_sc_hd__decap_3
XFILLER_34_656 VGND VGND VPWR VPWR sky130_fd_sc_hd__decap_3
XFILLER_59_1278 VGND VGND VPWR VPWR sky130_fd_sc_hd__decap_3
X_4810_ _4831_/A1 _4807_/X _4808_/Y _4809_/X _4831_/C1 VGND VGND VPWR VPWR _4810_/X
+ sky130_fd_sc_hd__o221a_2
XFILLER_34_678 VGND VGND VPWR VPWR sky130_fd_sc_hd__decap_3
XFILLER_59_1289 VGND VGND VPWR VPWR sky130_fd_sc_hd__decap_3
XFILLER_22_829 VGND VGND VPWR VPWR sky130_fd_sc_hd__decap_3
XFILLER_72_1412 VGND VGND VPWR VPWR sky130_fd_sc_hd__decap_3
X_5790_ _6819_/Q _5783_/X _5841_/C _5789_/X VGND VGND VPWR VPWR _6819_/D sky130_fd_sc_hd__a22o_2
XFILLER_33_177 VGND VGND VPWR VPWR sky130_fd_sc_hd__decap_3
XFILLER_61_486 VGND VGND VPWR VPWR sky130_fd_sc_hd__decap_3
XFILLER_15_892 VGND VGND VPWR VPWR sky130_fd_sc_hd__decap_3
XFILLER_14_380 VGND VGND VPWR VPWR sky130_fd_sc_hd__decap_3
X_4741_ _4740_/B _4133_/B _4740_/Y _4741_/C1 VGND VGND VPWR VPWR _4741_/Y sky130_fd_sc_hd__o211ai_2
XFILLER_72_1456 VGND VGND VPWR VPWR sky130_fd_sc_hd__decap_3
XFILLER_33_1407 VGND VGND VPWR VPWR sky130_fd_sc_hd__decap_3
XTAP_TAPCELL_ROW_77_2210 VGND VPWR sky130_fd_sc_hd__tapvpwrvgnd_1
X_4672_ _6312_/Q _4671_/X _4849_/S VGND VGND VPWR VPWR _6312_/D sky130_fd_sc_hd__mux2_1
X_6411_ _7076_/CLK _6411_/D load_slew681/X VGND VGND VPWR VPWR _6411_/Q sky130_fd_sc_hd__dfrtp_2
XFILLER_70_1191 VGND VGND VPWR VPWR sky130_fd_sc_hd__decap_3
X_3623_ _6248_/Q _3630_/C1 _5603_/A1 _6256_/Q VGND VGND VPWR VPWR _3623_/X sky130_fd_sc_hd__a22o_2
XTAP_TAPCELL_ROW_73_2107 VGND VPWR sky130_fd_sc_hd__tapvpwrvgnd_1
XFILLER_31_1175 VGND VGND VPWR VPWR sky130_fd_sc_hd__fill_1
X_6342_ _7024_/CLK _6342_/D load_slew700/X VGND VGND VPWR VPWR _6342_/Q sky130_fd_sc_hd__dfrtp_2
X_3554_ _6273_/Q _6281_/Q _6289_/Q _6225_/Q _3496_/B _3601_/A VGND VGND VPWR VPWR
+ _3554_/X sky130_fd_sc_hd__mux4_2
XFILLER_66_1205 VGND VGND VPWR VPWR sky130_fd_sc_hd__decap_3
XFILLER_66_1238 VGND VGND VPWR VPWR sky130_fd_sc_hd__decap_3
X_6273_ _7036_/CLK _6273_/D fanout835/X VGND VGND VPWR VPWR _6273_/Q sky130_fd_sc_hd__dfrtp_2
X_3485_ _5506_/A _3485_/B VGND VGND VPWR VPWR _4796_/A sky130_fd_sc_hd__nor2_4
XFILLER_9_1121 VGND VGND VPWR VPWR sky130_fd_sc_hd__decap_3
X_5224_ _6416_/Q _5248_/A2 _5223_/X VGND VGND VPWR VPWR _6416_/D sky130_fd_sc_hd__a21o_2
XFILLER_9_1154 VGND VGND VPWR VPWR sky130_fd_sc_hd__decap_3
X_5155_ _6386_/Q _5254_/A2 _4978_/S _5154_/X VGND VGND VPWR VPWR _6386_/D sky130_fd_sc_hd__a22o_2
XFILLER_69_564 VGND VGND VPWR VPWR sky130_fd_sc_hd__decap_3
XFILLER_9_1198 VGND VGND VPWR VPWR sky130_fd_sc_hd__decap_3
X_4106_ _3743_/B _3490_/C _3490_/B VGND VGND VPWR VPWR _4106_/Y sky130_fd_sc_hd__a21oi_2
X_5086_ _6612_/Q _6652_/Q VGND VGND VPWR VPWR _5087_/B sky130_fd_sc_hd__xnor2_2
XFILLER_42_1282 VGND VGND VPWR VPWR sky130_fd_sc_hd__decap_3
X_4037_ _4381_/C1 _4034_/X _4035_/Y _4036_/X _4582_/A VGND VGND VPWR VPWR _4037_/X
+ sky130_fd_sc_hd__o221a_2
XFILLER_77_1301 VGND VGND VPWR VPWR sky130_fd_sc_hd__decap_3
XFILLER_56_269 VGND VGND VPWR VPWR sky130_fd_sc_hd__decap_3
XFILLER_37_461 VGND VGND VPWR VPWR sky130_fd_sc_hd__decap_3
XFILLER_65_770 VGND VGND VPWR VPWR sky130_fd_sc_hd__decap_3
XFILLER_38_995 VGND VGND VPWR VPWR sky130_fd_sc_hd__decap_3
XFILLER_77_1334 VGND VGND VPWR VPWR sky130_fd_sc_hd__decap_3
XFILLER_77_1345 VGND VGND VPWR VPWR sky130_fd_sc_hd__decap_3
XFILLER_24_111 VGND VGND VPWR VPWR sky130_fd_sc_hd__fill_1
XFILLER_72_18 VGND VGND VPWR VPWR sky130_fd_sc_hd__decap_3
XFILLER_72_29 VGND VGND VPWR VPWR sky130_fd_sc_hd__decap_3
XFILLER_77_1378 VGND VGND VPWR VPWR sky130_fd_sc_hd__decap_3
XFILLER_38_1329 VGND VGND VPWR VPWR sky130_fd_sc_hd__decap_3
XFILLER_13_818 VGND VGND VPWR VPWR sky130_fd_sc_hd__decap_3
XFILLER_52_464 VGND VGND VPWR VPWR sky130_fd_sc_hd__decap_3
XTAP_TAPCELL_ROW_62_1800 VGND VPWR sky130_fd_sc_hd__tapvpwrvgnd_1
XFILLER_13_829 VGND VGND VPWR VPWR sky130_fd_sc_hd__decap_3
XTAP_TAPCELL_ROW_23_802 VGND VPWR sky130_fd_sc_hd__tapvpwrvgnd_1
XFILLER_24_166 VGND VGND VPWR VPWR sky130_fd_sc_hd__fill_1
XTAP_TAPCELL_ROW_62_1811 VGND VPWR sky130_fd_sc_hd__tapvpwrvgnd_1
XFILLER_12_317 VGND VGND VPWR VPWR sky130_fd_sc_hd__fill_2
X_5988_ _5988_/A0 _5988_/A1 _6044_/S VGND VGND VPWR VPWR _6992_/D sky130_fd_sc_hd__mux2_1
XTAP_TAPCELL_ROW_62_1822 VGND VPWR sky130_fd_sc_hd__tapvpwrvgnd_1
X_4939_ _6381_/Q _5213_/B VGND VGND VPWR VPWR _4939_/X sky130_fd_sc_hd__or2_2
XFILLER_21_862 VGND VGND VPWR VPWR sky130_fd_sc_hd__decap_3
XANTENNA_40 _5914_/S VGND VGND VPWR VPWR sky130_fd_sc_hd__diode_2
XANTENNA_51 fanout121/X VGND VGND VPWR VPWR sky130_fd_sc_hd__diode_2
XANTENNA_62 _3205_/B1 VGND VGND VPWR VPWR sky130_fd_sc_hd__diode_2
XANTENNA_73 _5502_/C VGND VGND VPWR VPWR sky130_fd_sc_hd__diode_2
XANTENNA_84 input9/X VGND VGND VPWR VPWR sky130_fd_sc_hd__diode_2
X_6609_ _7057_/CLK _6609_/D fanout725/X VGND VGND VPWR VPWR _6609_/Q sky130_fd_sc_hd__dfrtp_2
XFILLER_14_1362 VGND VGND VPWR VPWR sky130_fd_sc_hd__decap_3
XFILLER_14_1373 VGND VGND VPWR VPWR sky130_fd_sc_hd__decap_3
XFILLER_10_1226 VGND VGND VPWR VPWR sky130_fd_sc_hd__decap_3
XFILLER_21_66 VGND VGND VPWR VPWR sky130_fd_sc_hd__decap_3
XFILLER_49_1425 VGND VGND VPWR VPWR sky130_fd_sc_hd__decap_3
XFILLER_10_1259 VGND VGND VPWR VPWR sky130_fd_sc_hd__fill_1
XTAP_TAPCELL_ROW_56_1648 VGND VPWR sky130_fd_sc_hd__tapvpwrvgnd_1
XTAP_TAPCELL_ROW_56_1659 VGND VPWR sky130_fd_sc_hd__tapvpwrvgnd_1
XFILLER_0_722 VGND VGND VPWR VPWR sky130_fd_sc_hd__decap_3
XFILLER_0_744 VGND VGND VPWR VPWR sky130_fd_sc_hd__decap_3
XTAP_TAPCELL_ROW_7_376 VGND VPWR sky130_fd_sc_hd__tapvpwrvgnd_1
XFILLER_0_766 VGND VGND VPWR VPWR sky130_fd_sc_hd__decap_3
XFILLER_48_704 VGND VGND VPWR VPWR sky130_fd_sc_hd__fill_1
XTAP_TAPCELL_ROW_7_387 VGND VPWR sky130_fd_sc_hd__tapvpwrvgnd_1
XFILLER_0_788 VGND VGND VPWR VPWR sky130_fd_sc_hd__decap_3
XFILLER_43_1046 VGND VGND VPWR VPWR sky130_fd_sc_hd__fill_1
XFILLER_75_523 VGND VGND VPWR VPWR sky130_fd_sc_hd__decap_3
XFILLER_43_1079 VGND VGND VPWR VPWR sky130_fd_sc_hd__decap_3
XFILLER_47_225 VGND VGND VPWR VPWR sky130_fd_sc_hd__decap_3
XFILLER_29_940 VGND VGND VPWR VPWR sky130_fd_sc_hd__fill_2
XFILLER_75_556 VGND VGND VPWR VPWR sky130_fd_sc_hd__decap_3
XFILLER_21_1322 VGND VGND VPWR VPWR sky130_fd_sc_hd__decap_3
XFILLER_60_1371 VGND VGND VPWR VPWR sky130_fd_sc_hd__fill_1
XFILLER_60_1382 VGND VGND VPWR VPWR sky130_fd_sc_hd__decap_3
XFILLER_1_1416 VGND VGND VPWR VPWR sky130_fd_sc_hd__decap_3
XFILLER_63_729 VGND VGND VPWR VPWR sky130_fd_sc_hd__decap_3
XFILLER_16_601 VGND VGND VPWR VPWR sky130_fd_sc_hd__decap_3
XFILLER_44_910 VGND VGND VPWR VPWR sky130_fd_sc_hd__decap_3
XFILLER_21_1366 VGND VGND VPWR VPWR sky130_fd_sc_hd__decap_3
XFILLER_1_1449 VGND VGND VPWR VPWR sky130_fd_sc_hd__decap_3
XFILLER_46_85 VGND VGND VPWR VPWR sky130_fd_sc_hd__decap_3
XFILLER_21_1399 VGND VGND VPWR VPWR sky130_fd_sc_hd__fill_1
Xmax_cap86 _5747_/S VGND VGND VPWR VPWR _5748_/S sky130_fd_sc_hd__buf_8
XFILLER_56_1418 VGND VGND VPWR VPWR sky130_fd_sc_hd__decap_3
XFILLER_44_976 VGND VGND VPWR VPWR sky130_fd_sc_hd__decap_3
XFILLER_56_1429 VGND VGND VPWR VPWR sky130_fd_sc_hd__decap_3
XFILLER_16_678 VGND VGND VPWR VPWR sky130_fd_sc_hd__decap_3
XFILLER_31_604 VGND VGND VPWR VPWR sky130_fd_sc_hd__decap_3
XFILLER_44_987 VGND VGND VPWR VPWR sky130_fd_sc_hd__decap_3
XFILLER_70_250 VGND VGND VPWR VPWR sky130_fd_sc_hd__fill_2
XFILLER_15_188 VGND VGND VPWR VPWR sky130_fd_sc_hd__decap_3
XFILLER_19_1251 VGND VGND VPWR VPWR sky130_fd_sc_hd__decap_3
XFILLER_19_1284 VGND VGND VPWR VPWR sky130_fd_sc_hd__decap_3
XFILLER_19_1295 VGND VGND VPWR VPWR sky130_fd_sc_hd__decap_3
XFILLER_7_24 VGND VGND VPWR VPWR sky130_fd_sc_hd__decap_3
XFILLER_8_866 VGND VGND VPWR VPWR sky130_fd_sc_hd__fill_2
XFILLER_32_1462 VGND VGND VPWR VPWR sky130_fd_sc_hd__decap_3
XFILLER_7_68 VGND VGND VPWR VPWR sky130_fd_sc_hd__decap_3
X_3270_ _6270_/Q _6366_/Q VGND VGND VPWR VPWR _3270_/X sky130_fd_sc_hd__xor2_2
XFILLER_26_1200 VGND VGND VPWR VPWR sky130_fd_sc_hd__decap_3
XFILLER_65_1260 VGND VGND VPWR VPWR sky130_fd_sc_hd__decap_3
Xload_slew235 fanout234/X VGND VGND VPWR VPWR _6059_/S sky130_fd_sc_hd__buf_4
XFILLER_26_1244 VGND VGND VPWR VPWR sky130_fd_sc_hd__decap_3
XFILLER_61_1124 VGND VGND VPWR VPWR sky130_fd_sc_hd__decap_3
XFILLER_6_1338 VGND VGND VPWR VPWR sky130_fd_sc_hd__decap_3
XFILLER_38_203 VGND VGND VPWR VPWR sky130_fd_sc_hd__fill_2
XFILLER_26_1288 VGND VGND VPWR VPWR sky130_fd_sc_hd__decap_3
XFILLER_16_3 VGND VGND VPWR VPWR sky130_fd_sc_hd__decap_3
XFILLER_4_1040 VGND VGND VPWR VPWR sky130_fd_sc_hd__decap_3
XFILLER_66_578 VGND VGND VPWR VPWR sky130_fd_sc_hd__fill_2
X_6960_ clkload8/A _6960_/D wire639/X VGND VGND VPWR VPWR _6960_/Q sky130_fd_sc_hd__dfrtp_2
XFILLER_4_1073 VGND VGND VPWR VPWR sky130_fd_sc_hd__decap_3
XFILLER_53_228 VGND VGND VPWR VPWR sky130_fd_sc_hd__decap_3
X_5911_ _5911_/A0 _5911_/A1 _5914_/S VGND VGND VPWR VPWR _6918_/D sky130_fd_sc_hd__mux2_1
XFILLER_35_943 VGND VGND VPWR VPWR sky130_fd_sc_hd__decap_3
X_6891_ _7051_/CLK _6891_/D load_slew810/X VGND VGND VPWR VPWR _6891_/Q sky130_fd_sc_hd__dfrtp_2
XFILLER_34_442 VGND VGND VPWR VPWR sky130_fd_sc_hd__decap_3
XFILLER_35_965 VGND VGND VPWR VPWR sky130_fd_sc_hd__decap_3
XFILLER_62_751 VGND VGND VPWR VPWR sky130_fd_sc_hd__decap_3
XTAP_TAPCELL_ROW_17_640 VGND VPWR sky130_fd_sc_hd__tapvpwrvgnd_1
XTAP_TAPCELL_ROW_17_651 VGND VPWR sky130_fd_sc_hd__tapvpwrvgnd_1
X_5842_ _5842_/A0 _5784_/C _5845_/S VGND VGND VPWR VPWR _6858_/D sky130_fd_sc_hd__mux2_1
XFILLER_62_773 VGND VGND VPWR VPWR sky130_fd_sc_hd__decap_3
XFILLER_72_1220 VGND VGND VPWR VPWR sky130_fd_sc_hd__decap_3
XFILLER_37_1340 VGND VGND VPWR VPWR sky130_fd_sc_hd__decap_3
XFILLER_37_1351 VGND VGND VPWR VPWR sky130_fd_sc_hd__decap_3
X_5773_ _5859_/C VGND VGND VPWR VPWR _5773_/Y sky130_fd_sc_hd__inv_2
XFILLER_72_1253 VGND VGND VPWR VPWR sky130_fd_sc_hd__decap_3
XFILLER_72_1264 VGND VGND VPWR VPWR sky130_fd_sc_hd__decap_3
XFILLER_37_1384 VGND VGND VPWR VPWR sky130_fd_sc_hd__decap_3
XFILLER_21_169 VGND VGND VPWR VPWR sky130_fd_sc_hd__fill_1
X_4724_ _4738_/A _4359_/Y _4723_/X _6568_/Q VGND VGND VPWR VPWR _4724_/X sky130_fd_sc_hd__a2bb2o_2
XFILLER_72_1297 VGND VGND VPWR VPWR sky130_fd_sc_hd__decap_3
XFILLER_33_1248 VGND VGND VPWR VPWR sky130_fd_sc_hd__decap_3
X_4655_ _6262_/Q _4832_/A2 _3382_/X _4832_/B2 VGND VGND VPWR VPWR _4655_/X sky130_fd_sc_hd__a22o_2
X_3606_ _3607_/B _3607_/C _3640_/B VGND VGND VPWR VPWR _3644_/B sky130_fd_sc_hd__a21o_2
X_4586_ _4586_/A _4586_/B _4586_/C _4586_/D VGND VGND VPWR VPWR _4586_/X sky130_fd_sc_hd__and4_2
XFILLER_66_1002 VGND VGND VPWR VPWR sky130_fd_sc_hd__decap_3
X_6325_ _6943_/CLK _6325_/D load_slew819/X VGND VGND VPWR VPWR _6325_/Q sky130_fd_sc_hd__dfrtp_2
XFILLER_1_508 VGND VGND VPWR VPWR sky130_fd_sc_hd__decap_3
X_3537_ _6629_/Q _5594_/A1 _5603_/A1 _6637_/Q _3630_/C1 VGND VGND VPWR VPWR _3537_/X
+ sky130_fd_sc_hd__a221o_2
Xhold866 _6165_/Q VGND VGND VPWR VPWR hold866/X sky130_fd_sc_hd__dlygate4sd3_1
XFILLER_66_1046 VGND VGND VPWR VPWR sky130_fd_sc_hd__decap_3
Xhold877 _6687_/Q VGND VGND VPWR VPWR hold877/X sky130_fd_sc_hd__dlygate4sd3_1
Xhold888 _6685_/Q VGND VGND VPWR VPWR hold888/X sky130_fd_sc_hd__dlygate4sd3_1
Xhold899 _6728_/Q VGND VGND VPWR VPWR hold899/X sky130_fd_sc_hd__dlygate4sd3_1
X_6256_ _6882_/CLK _6256_/D fanout665/X VGND VGND VPWR VPWR _6256_/Q sky130_fd_sc_hd__dfrtp_2
XFILLER_44_1300 VGND VGND VPWR VPWR sky130_fd_sc_hd__decap_3
X_3468_ _6241_/Q _6465_/Q VGND VGND VPWR VPWR _3468_/X sky130_fd_sc_hd__xor2_2
XFILLER_67_18 VGND VGND VPWR VPWR sky130_fd_sc_hd__decap_3
XTAP_TAPCELL_ROW_51_1523 VGND VPWR sky130_fd_sc_hd__tapvpwrvgnd_1
X_5207_ _5306_/S _5207_/B VGND VGND VPWR VPWR _5207_/Y sky130_fd_sc_hd__nand2_2
XTAP_TAPCELL_ROW_4_302 VGND VPWR sky130_fd_sc_hd__tapvpwrvgnd_1
XFILLER_44_1344 VGND VGND VPWR VPWR sky130_fd_sc_hd__decap_3
XTAP_TAPCELL_ROW_4_313 VGND VPWR sky130_fd_sc_hd__tapvpwrvgnd_1
XTAP_TAPCELL_ROW_51_1534 VGND VPWR sky130_fd_sc_hd__tapvpwrvgnd_1
X_6187_ _7088_/CLK _6187_/D load_slew773/X VGND VGND VPWR VPWR _6187_/Q sky130_fd_sc_hd__dfrtp_2
X_3399_ _6020_/A0 _3398_/X _3463_/S VGND VGND VPWR VPWR _6173_/D sky130_fd_sc_hd__mux2_1
Xhold1500 _6110_/Q VGND VGND VPWR VPWR _3273_/A0 sky130_fd_sc_hd__dlygate4sd3_1
Xhold1511 _6915_/Q VGND VGND VPWR VPWR _5908_/A1 sky130_fd_sc_hd__dlygate4sd3_1
Xhold1522 _6522_/Q VGND VGND VPWR VPWR _5410_/A1 sky130_fd_sc_hd__dlygate4sd3_1
Xload_slew780 fanout779/X VGND VGND VPWR VPWR load_slew780/X sky130_fd_sc_hd__buf_4
XFILLER_69_383 VGND VGND VPWR VPWR sky130_fd_sc_hd__decap_3
Xhold1533 _6525_/Q VGND VGND VPWR VPWR _5413_/A1 sky130_fd_sc_hd__dlygate4sd3_1
XFILLER_29_225 VGND VGND VPWR VPWR sky130_fd_sc_hd__fill_2
XFILLER_44_1388 VGND VGND VPWR VPWR sky130_fd_sc_hd__decap_3
X_5138_ _6716_/Q _5213_/A VGND VGND VPWR VPWR _5138_/X sky130_fd_sc_hd__or2_2
Xhold1544 _6656_/Q VGND VGND VPWR VPWR _5580_/B2 sky130_fd_sc_hd__dlygate4sd3_1
XFILLER_79_1407 VGND VGND VPWR VPWR sky130_fd_sc_hd__decap_3
Xhold1555 _6601_/Q VGND VGND VPWR VPWR _5492_/B1 sky130_fd_sc_hd__dlygate4sd3_1
XFILLER_57_567 VGND VGND VPWR VPWR sky130_fd_sc_hd__decap_3
XFILLER_17_409 VGND VGND VPWR VPWR sky130_fd_sc_hd__decap_3
Xhold1566 _6661_/Q VGND VGND VPWR VPWR _5588_/B2 sky130_fd_sc_hd__dlygate4sd3_1
XTAP_TAPCELL_ROW_28_916 VGND VPWR sky130_fd_sc_hd__tapvpwrvgnd_1
X_5069_ _6367_/Q _5068_/X _5069_/S VGND VGND VPWR VPWR _6367_/D sky130_fd_sc_hd__mux2_1
XFILLER_38_770 VGND VGND VPWR VPWR sky130_fd_sc_hd__decap_3
XFILLER_44_206 VGND VGND VPWR VPWR sky130_fd_sc_hd__decap_3
XFILLER_45_729 VGND VGND VPWR VPWR sky130_fd_sc_hd__decap_3
XTAP_TAPCELL_ROW_28_927 VGND VPWR sky130_fd_sc_hd__tapvpwrvgnd_1
XTAP_TAPCELL_ROW_28_938 VGND VPWR sky130_fd_sc_hd__tapvpwrvgnd_1
XFILLER_72_548 VGND VGND VPWR VPWR sky130_fd_sc_hd__decap_3
XFILLER_44_239 VGND VGND VPWR VPWR sky130_fd_sc_hd__decap_3
XFILLER_77_1142 VGND VGND VPWR VPWR sky130_fd_sc_hd__decap_3
XFILLER_38_1104 VGND VGND VPWR VPWR sky130_fd_sc_hd__fill_1
XFILLER_25_442 VGND VGND VPWR VPWR sky130_fd_sc_hd__decap_3
XTAP_TAPCELL_ROW_49_1463 VGND VPWR sky130_fd_sc_hd__tapvpwrvgnd_1
XTAP_TAPCELL_ROW_49_1474 VGND VPWR sky130_fd_sc_hd__tapvpwrvgnd_1
XFILLER_77_1175 VGND VGND VPWR VPWR sky130_fd_sc_hd__fill_1
XFILLER_0_1460 VGND VGND VPWR VPWR sky130_fd_sc_hd__decap_3
XTAP_TAPCELL_ROW_49_1485 VGND VPWR sky130_fd_sc_hd__tapvpwrvgnd_1
XFILLER_77_1186 VGND VGND VPWR VPWR sky130_fd_sc_hd__decap_3
XFILLER_13_615 VGND VGND VPWR VPWR sky130_fd_sc_hd__fill_1
XFILLER_38_1137 VGND VGND VPWR VPWR sky130_fd_sc_hd__fill_2
XFILLER_16_88 VGND VGND VPWR VPWR sky130_fd_sc_hd__fill_1
XFILLER_80_592 VGND VGND VPWR VPWR sky130_fd_sc_hd__decap_3
XFILLER_41_946 VGND VGND VPWR VPWR sky130_fd_sc_hd__decap_3
XFILLER_55_1440 VGND VGND VPWR VPWR sky130_fd_sc_hd__decap_3
XFILLER_12_147 VGND VGND VPWR VPWR sky130_fd_sc_hd__fill_1
XFILLER_16_1424 VGND VGND VPWR VPWR sky130_fd_sc_hd__decap_3
XFILLER_51_1304 VGND VGND VPWR VPWR sky130_fd_sc_hd__decap_3
XFILLER_16_1435 VGND VGND VPWR VPWR sky130_fd_sc_hd__decap_3
XFILLER_51_1337 VGND VGND VPWR VPWR sky130_fd_sc_hd__decap_3
XFILLER_16_1468 VGND VGND VPWR VPWR sky130_fd_sc_hd__fill_1
XFILLER_51_1348 VGND VGND VPWR VPWR sky130_fd_sc_hd__decap_3
XFILLER_5_847 VGND VGND VPWR VPWR sky130_fd_sc_hd__decap_3
XFILLER_4_357 VGND VGND VPWR VPWR sky130_fd_sc_hd__decap_3
XFILLER_49_1233 VGND VGND VPWR VPWR sky130_fd_sc_hd__decap_3
XFILLER_79_103 VGND VGND VPWR VPWR sky130_fd_sc_hd__decap_3
XFILLER_49_1266 VGND VGND VPWR VPWR sky130_fd_sc_hd__decap_3
XFILLER_62_1400 VGND VGND VPWR VPWR sky130_fd_sc_hd__decap_3
XFILLER_79_169 VGND VGND VPWR VPWR sky130_fd_sc_hd__decap_3
XFILLER_62_1444 VGND VGND VPWR VPWR sky130_fd_sc_hd__decap_3
XFILLER_0_585 VGND VGND VPWR VPWR sky130_fd_sc_hd__decap_3
XFILLER_23_1428 VGND VGND VPWR VPWR sky130_fd_sc_hd__decap_3
XFILLER_57_51 VGND VGND VPWR VPWR sky130_fd_sc_hd__decap_3
XFILLER_76_854 VGND VGND VPWR VPWR sky130_fd_sc_hd__decap_3
XFILLER_36_707 VGND VGND VPWR VPWR sky130_fd_sc_hd__decap_3
XFILLER_48_567 VGND VGND VPWR VPWR sky130_fd_sc_hd__decap_3
XFILLER_57_84 VGND VGND VPWR VPWR sky130_fd_sc_hd__fill_2
XFILLER_5_1360 VGND VGND VPWR VPWR sky130_fd_sc_hd__decap_3
XFILLER_48_589 VGND VGND VPWR VPWR sky130_fd_sc_hd__decap_3
XFILLER_1_1213 VGND VGND VPWR VPWR sky130_fd_sc_hd__decap_3
XFILLER_21_1141 VGND VGND VPWR VPWR sky130_fd_sc_hd__decap_3
XFILLER_5_1393 VGND VGND VPWR VPWR sky130_fd_sc_hd__decap_3
XFILLER_17_932 VGND VGND VPWR VPWR sky130_fd_sc_hd__decap_3
XFILLER_35_228 VGND VGND VPWR VPWR sky130_fd_sc_hd__decap_3
XFILLER_1_1257 VGND VGND VPWR VPWR sky130_fd_sc_hd__decap_3
XFILLER_21_1185 VGND VGND VPWR VPWR sky130_fd_sc_hd__fill_1
XFILLER_28_291 VGND VGND VPWR VPWR sky130_fd_sc_hd__fill_1
XFILLER_17_965 VGND VGND VPWR VPWR sky130_fd_sc_hd__decap_3
XFILLER_16_464 VGND VGND VPWR VPWR sky130_fd_sc_hd__decap_3
XFILLER_32_913 VGND VGND VPWR VPWR sky130_fd_sc_hd__decap_3
XFILLER_44_773 VGND VGND VPWR VPWR sky130_fd_sc_hd__decap_3
XFILLER_73_72 VGND VGND VPWR VPWR sky130_fd_sc_hd__decap_3
XFILLER_56_1226 VGND VGND VPWR VPWR sky130_fd_sc_hd__decap_3
XFILLER_16_486 VGND VGND VPWR VPWR sky130_fd_sc_hd__decap_3
XFILLER_56_1259 VGND VGND VPWR VPWR sky130_fd_sc_hd__fill_1
XFILLER_8_641 VGND VGND VPWR VPWR sky130_fd_sc_hd__decap_3
XFILLER_32_1270 VGND VGND VPWR VPWR sky130_fd_sc_hd__decap_3
X_4440_ _4619_/A1 _4437_/X _4438_/Y _4439_/X _4881_/A VGND VGND VPWR VPWR _4440_/X
+ sky130_fd_sc_hd__o221a_2
XFILLER_67_1322 VGND VGND VPWR VPWR sky130_fd_sc_hd__decap_3
X_4371_ _4396_/A _4732_/B VGND VGND VPWR VPWR _4371_/Y sky130_fd_sc_hd__nor2_2
XFILLER_28_1306 VGND VGND VPWR VPWR sky130_fd_sc_hd__decap_3
X_6110_ _6993_/CLK _6110_/D load_slew710/X VGND VGND VPWR VPWR _6110_/Q sky130_fd_sc_hd__dfrtp_2
XFILLER_28_1317 VGND VGND VPWR VPWR sky130_fd_sc_hd__decap_3
XFILLER_67_1366 VGND VGND VPWR VPWR sky130_fd_sc_hd__decap_3
XFILLER_4_891 VGND VGND VPWR VPWR sky130_fd_sc_hd__decap_3
X_3322_ _6288_/Q _6392_/Q VGND VGND VPWR VPWR _3322_/X sky130_fd_sc_hd__xor2_2
Xfanout609 wire613/X VGND VGND VPWR VPWR _5930_/A0 sky130_fd_sc_hd__clkdlybuf4s25_1
X_7090_ _7090_/CLK _7090_/D wire734/X VGND VGND VPWR VPWR _7090_/Q sky130_fd_sc_hd__dfrtp_2
XFILLER_67_1399 VGND VGND VPWR VPWR sky130_fd_sc_hd__fill_1
X_6041_ _6041_/A0 _7045_/Q _6049_/S VGND VGND VPWR VPWR _6041_/X sky130_fd_sc_hd__mux2_1
XFILLER_58_309 VGND VGND VPWR VPWR sky130_fd_sc_hd__decap_3
XFILLER_6_1102 VGND VGND VPWR VPWR sky130_fd_sc_hd__decap_3
X_3253_ hold904/X _3252_/X _3269_/S VGND VGND VPWR VPWR _6100_/D sky130_fd_sc_hd__mux2_1
XFILLER_67_810 VGND VGND VPWR VPWR sky130_fd_sc_hd__decap_3
XFILLER_67_832 VGND VGND VPWR VPWR sky130_fd_sc_hd__decap_3
XFILLER_6_1135 VGND VGND VPWR VPWR sky130_fd_sc_hd__decap_3
X_3184_ _3212_/A1 _6967_/Q _6975_/Q _3136_/A VGND VGND VPWR VPWR _3184_/X sky130_fd_sc_hd__a22o_2
XFILLER_26_1085 VGND VGND VPWR VPWR sky130_fd_sc_hd__decap_3
XFILLER_26_1096 VGND VGND VPWR VPWR sky130_fd_sc_hd__fill_2
XFILLER_39_556 VGND VGND VPWR VPWR sky130_fd_sc_hd__decap_3
XFILLER_27_707 VGND VGND VPWR VPWR sky130_fd_sc_hd__decap_3
XFILLER_6_1179 VGND VGND VPWR VPWR sky130_fd_sc_hd__decap_3
XFILLER_26_206 VGND VGND VPWR VPWR sky130_fd_sc_hd__decap_3
XFILLER_54_515 VGND VGND VPWR VPWR sky130_fd_sc_hd__fill_1
X_6943_ _6943_/CLK _6943_/D fanout818/X VGND VGND VPWR VPWR _6943_/Q sky130_fd_sc_hd__dfrtp_2
XFILLER_78_1462 VGND VGND VPWR VPWR sky130_fd_sc_hd__decap_3
XFILLER_39_1413 VGND VGND VPWR VPWR sky130_fd_sc_hd__decap_3
XFILLER_35_762 VGND VGND VPWR VPWR sky130_fd_sc_hd__fill_1
XFILLER_74_1315 VGND VGND VPWR VPWR sky130_fd_sc_hd__fill_1
XFILLER_74_1326 VGND VGND VPWR VPWR sky130_fd_sc_hd__decap_3
XFILLER_39_1446 VGND VGND VPWR VPWR sky130_fd_sc_hd__decap_3
X_6874_ _7072_/CLK _6874_/D load_slew684/X VGND VGND VPWR VPWR _6874_/Q sky130_fd_sc_hd__dfrtp_2
XFILLER_50_710 VGND VGND VPWR VPWR sky130_fd_sc_hd__decap_3
XFILLER_39_1457 VGND VGND VPWR VPWR sky130_fd_sc_hd__decap_3
XFILLER_74_1359 VGND VGND VPWR VPWR sky130_fd_sc_hd__decap_3
XFILLER_50_743 VGND VGND VPWR VPWR sky130_fd_sc_hd__decap_3
X_5825_ _5825_/A0 _5825_/A1 _5831_/S VGND VGND VPWR VPWR _6843_/D sky130_fd_sc_hd__mux2_1
XFILLER_50_776 VGND VGND VPWR VPWR sky130_fd_sc_hd__decap_3
XFILLER_10_629 VGND VGND VPWR VPWR sky130_fd_sc_hd__fill_2
X_5756_ _5913_/A0 _5756_/A1 _5757_/S VGND VGND VPWR VPWR _6800_/D sky130_fd_sc_hd__mux2_1
XTAP_TAPCELL_ROW_40_1235 VGND VPWR sky130_fd_sc_hd__tapvpwrvgnd_1
X_4707_ _6895_/Q wire295/X _4876_/B1 _4706_/X VGND VGND VPWR VPWR _4707_/X sky130_fd_sc_hd__a211o_2
XTAP_TAPCELL_ROW_40_1246 VGND VPWR sky130_fd_sc_hd__tapvpwrvgnd_1
X_5687_ _5687_/A0 _5899_/A0 _5693_/S VGND VGND VPWR VPWR _6739_/D sky130_fd_sc_hd__mux2_1
XFILLER_11_1310 VGND VGND VPWR VPWR sky130_fd_sc_hd__decap_3
XFILLER_33_1089 VGND VGND VPWR VPWR sky130_fd_sc_hd__decap_3
X_4638_ _4696_/B _4815_/B VGND VGND VPWR VPWR _4638_/Y sky130_fd_sc_hd__nor2_2
XFILLER_11_1343 VGND VGND VPWR VPWR sky130_fd_sc_hd__fill_1
XFILLER_11_1354 VGND VGND VPWR VPWR sky130_fd_sc_hd__decap_3
XFILLER_2_806 VGND VGND VPWR VPWR sky130_fd_sc_hd__decap_3
XTAP_TAPCELL_ROW_9_427 VGND VPWR sky130_fd_sc_hd__tapvpwrvgnd_1
XFILLER_11_1387 VGND VGND VPWR VPWR sky130_fd_sc_hd__decap_3
XFILLER_2_828 VGND VGND VPWR VPWR sky130_fd_sc_hd__decap_3
X_4569_ _6298_/Q _4745_/A2 _4566_/X _4568_/X VGND VGND VPWR VPWR _6298_/D sky130_fd_sc_hd__o22a_2
XTAP_TAPCELL_ROW_9_438 VGND VPWR sky130_fd_sc_hd__tapvpwrvgnd_1
XFILLER_1_305 VGND VGND VPWR VPWR sky130_fd_sc_hd__decap_3
XFILLER_46_1406 VGND VGND VPWR VPWR sky130_fd_sc_hd__decap_3
X_6308_ _7022_/CLK _6308_/D fanout750/X VGND VGND VPWR VPWR _6308_/Q sky130_fd_sc_hd__dfrtp_2
XFILLER_1_349 VGND VGND VPWR VPWR sky130_fd_sc_hd__decap_3
XTAP_TAPCELL_ROW_38_1186 VGND VPWR sky130_fd_sc_hd__tapvpwrvgnd_1
XTAP_TAPCELL_ROW_38_1197 VGND VPWR sky130_fd_sc_hd__tapvpwrvgnd_1
X_6239_ _6905_/CLK _6239_/D wire738/X VGND VGND VPWR VPWR _6239_/Q sky130_fd_sc_hd__dfrtp_2
XFILLER_44_1152 VGND VGND VPWR VPWR sky130_fd_sc_hd__fill_1
Xhold1330 _6832_/Q VGND VGND VPWR VPWR _5812_/A1 sky130_fd_sc_hd__dlygate4sd3_1
XFILLER_44_1185 VGND VGND VPWR VPWR sky130_fd_sc_hd__decap_3
XFILLER_58_865 VGND VGND VPWR VPWR sky130_fd_sc_hd__decap_3
XFILLER_79_1204 VGND VGND VPWR VPWR sky130_fd_sc_hd__decap_3
Xhold1341 _6921_/Q VGND VGND VPWR VPWR _5914_/A1 sky130_fd_sc_hd__dlygate4sd3_1
Xhold1352 _6795_/Q VGND VGND VPWR VPWR _5751_/A1 sky130_fd_sc_hd__dlygate4sd3_1
Xhold1363 _6581_/Q VGND VGND VPWR VPWR _5469_/A1 sky130_fd_sc_hd__dlygate4sd3_1
XFILLER_40_1049 VGND VGND VPWR VPWR sky130_fd_sc_hd__decap_3
XFILLER_57_364 VGND VGND VPWR VPWR sky130_fd_sc_hd__decap_3
XFILLER_22_1450 VGND VGND VPWR VPWR sky130_fd_sc_hd__decap_3
Xhold1374 _6842_/Q VGND VGND VPWR VPWR _5824_/A1 sky130_fd_sc_hd__dlygate4sd3_1
XFILLER_79_1248 VGND VGND VPWR VPWR sky130_fd_sc_hd__decap_3
XFILLER_72_312 VGND VGND VPWR VPWR sky130_fd_sc_hd__decap_3
Xhold1385 _6580_/Q VGND VGND VPWR VPWR _5468_/A1 sky130_fd_sc_hd__dlygate4sd3_1
XFILLER_17_228 VGND VGND VPWR VPWR sky130_fd_sc_hd__decap_3
Xhold1396 _6831_/Q VGND VGND VPWR VPWR _5811_/A1 sky130_fd_sc_hd__dlygate4sd3_1
XFILLER_26_751 VGND VGND VPWR VPWR sky130_fd_sc_hd__decap_3
XFILLER_26_795 VGND VGND VPWR VPWR sky130_fd_sc_hd__decap_3
XFILLER_13_434 VGND VGND VPWR VPWR sky130_fd_sc_hd__decap_3
XFILLER_41_765 VGND VGND VPWR VPWR sky130_fd_sc_hd__decap_3
XFILLER_43_53 VGND VGND VPWR VPWR sky130_fd_sc_hd__decap_3
XFILLER_9_405 VGND VGND VPWR VPWR sky130_fd_sc_hd__decap_3
XFILLER_40_253 VGND VGND VPWR VPWR sky130_fd_sc_hd__decap_3
XFILLER_9_438 VGND VGND VPWR VPWR sky130_fd_sc_hd__fill_1
XFILLER_16_1232 VGND VGND VPWR VPWR sky130_fd_sc_hd__decap_3
XFILLER_43_86 VGND VGND VPWR VPWR sky130_fd_sc_hd__decap_3
XFILLER_55_1281 VGND VGND VPWR VPWR sky130_fd_sc_hd__decap_3
XFILLER_9_449 VGND VGND VPWR VPWR sky130_fd_sc_hd__decap_3
XFILLER_55_1292 VGND VGND VPWR VPWR sky130_fd_sc_hd__decap_3
XFILLER_22_990 VGND VGND VPWR VPWR sky130_fd_sc_hd__decap_3
XFILLER_16_1276 VGND VGND VPWR VPWR sky130_fd_sc_hd__decap_3
XFILLER_51_1167 VGND VGND VPWR VPWR sky130_fd_sc_hd__fill_2
XFILLER_5_611 VGND VGND VPWR VPWR sky130_fd_sc_hd__decap_3
XFILLER_5_666 VGND VGND VPWR VPWR sky130_fd_sc_hd__decap_3
XFILLER_4_165 VGND VGND VPWR VPWR sky130_fd_sc_hd__decap_3
XFILLER_4_187 VGND VGND VPWR VPWR sky130_fd_sc_hd__decap_3
XFILLER_4_47 VGND VGND VPWR VPWR sky130_fd_sc_hd__decap_3
XFILLER_68_607 VGND VGND VPWR VPWR sky130_fd_sc_hd__decap_3
XFILLER_1_850 VGND VGND VPWR VPWR sky130_fd_sc_hd__decap_3
XFILLER_68_50 VGND VGND VPWR VPWR sky130_fd_sc_hd__decap_3
XFILLER_7_1422 VGND VGND VPWR VPWR sky130_fd_sc_hd__decap_3
XFILLER_1_883 VGND VGND VPWR VPWR sky130_fd_sc_hd__decap_3
XFILLER_62_1241 VGND VGND VPWR VPWR sky130_fd_sc_hd__decap_3
XFILLER_68_83 VGND VGND VPWR VPWR sky130_fd_sc_hd__fill_1
XFILLER_0_371 VGND VGND VPWR VPWR sky130_fd_sc_hd__decap_3
XFILLER_27_1372 VGND VGND VPWR VPWR sky130_fd_sc_hd__decap_3
XFILLER_67_128 VGND VGND VPWR VPWR sky130_fd_sc_hd__decap_3
XFILLER_7_1455 VGND VGND VPWR VPWR sky130_fd_sc_hd__fill_1
XFILLER_0_393 VGND VGND VPWR VPWR sky130_fd_sc_hd__decap_3
XFILLER_7_1466 VGND VGND VPWR VPWR sky130_fd_sc_hd__decap_3
XFILLER_23_1236 VGND VGND VPWR VPWR sky130_fd_sc_hd__decap_3
XFILLER_49_865 VGND VGND VPWR VPWR sky130_fd_sc_hd__decap_3
XFILLER_62_1285 VGND VGND VPWR VPWR sky130_fd_sc_hd__decap_3
XFILLER_3_1319 VGND VGND VPWR VPWR sky130_fd_sc_hd__decap_3
XFILLER_64_813 VGND VGND VPWR VPWR sky130_fd_sc_hd__fill_1
XTAP_TAPCELL_ROW_19_702 VGND VPWR sky130_fd_sc_hd__tapvpwrvgnd_1
XFILLER_23_1269 VGND VGND VPWR VPWR sky130_fd_sc_hd__decap_3
XFILLER_36_515 VGND VGND VPWR VPWR sky130_fd_sc_hd__decap_3
XFILLER_1_1021 VGND VGND VPWR VPWR sky130_fd_sc_hd__decap_3
XFILLER_36_559 VGND VGND VPWR VPWR sky130_fd_sc_hd__decap_3
XFILLER_1_1054 VGND VGND VPWR VPWR sky130_fd_sc_hd__decap_3
XFILLER_1_1065 VGND VGND VPWR VPWR sky130_fd_sc_hd__decap_3
XFILLER_23_209 VGND VGND VPWR VPWR sky130_fd_sc_hd__decap_3
XFILLER_63_378 VGND VGND VPWR VPWR sky130_fd_sc_hd__fill_1
XFILLER_16_250 VGND VGND VPWR VPWR sky130_fd_sc_hd__fill_2
X_3940_ _3722_/A _6238_/Q VGND VGND VPWR VPWR _3940_/X sky130_fd_sc_hd__and2b_2
XFILLER_56_1012 VGND VGND VPWR VPWR sky130_fd_sc_hd__decap_3
XFILLER_1_1098 VGND VGND VPWR VPWR sky130_fd_sc_hd__decap_3
XFILLER_32_732 VGND VGND VPWR VPWR sky130_fd_sc_hd__fill_2
XFILLER_17_1007 VGND VGND VPWR VPWR sky130_fd_sc_hd__fill_1
XTAP_TAPCELL_ROW_80_2272 VGND VPWR sky130_fd_sc_hd__tapvpwrvgnd_1
X_3871_ _6332_/Q _4083_/A _3869_/X _3870_/X VGND VGND VPWR VPWR _4326_/B sky130_fd_sc_hd__o22a_2
XTAP_TAPCELL_ROW_80_2283 VGND VPWR sky130_fd_sc_hd__tapvpwrvgnd_1
XFILLER_20_916 VGND VGND VPWR VPWR sky130_fd_sc_hd__decap_3
XTAP_TAPCELL_ROW_80_2294 VGND VPWR sky130_fd_sc_hd__tapvpwrvgnd_1
X_5610_ _5610_/A1 _5582_/Y _5610_/B1 _5610_/B2 VGND VGND VPWR VPWR _6681_/D sky130_fd_sc_hd__a22o_2
XFILLER_32_798 VGND VGND VPWR VPWR sky130_fd_sc_hd__decap_3
XFILLER_73_1381 VGND VGND VPWR VPWR sky130_fd_sc_hd__decap_3
X_6590_ _7024_/CLK _6590_/D fanout703/X VGND VGND VPWR VPWR _6590_/Q sky130_fd_sc_hd__dfrtp_2
XFILLER_34_1332 VGND VGND VPWR VPWR sky130_fd_sc_hd__decap_3
XFILLER_34_1365 VGND VGND VPWR VPWR sky130_fd_sc_hd__decap_3
X_5541_ _6374_/Q _5565_/A2 _5541_/B1 _5562_/B2 VGND VGND VPWR VPWR _6624_/D sky130_fd_sc_hd__a22o_2
XFILLER_34_1376 VGND VGND VPWR VPWR sky130_fd_sc_hd__decap_3
XFILLER_8_460 VGND VGND VPWR VPWR sky130_fd_sc_hd__decap_3
XTAP_TAPCELL_ROW_30_977 VGND VPWR sky130_fd_sc_hd__tapvpwrvgnd_1
XFILLER_30_1229 VGND VGND VPWR VPWR sky130_fd_sc_hd__decap_3
XTAP_TAPCELL_ROW_30_988 VGND VPWR sky130_fd_sc_hd__tapvpwrvgnd_1
X_5472_ _5472_/A1 _5478_/A2 _4846_/X VGND VGND VPWR VPWR _6584_/D sky130_fd_sc_hd__a21o_2
XFILLER_69_1428 VGND VGND VPWR VPWR sky130_fd_sc_hd__decap_3
X_4423_ _6511_/Q _4422_/A _3098_/A VGND VGND VPWR VPWR _4423_/X sky130_fd_sc_hd__a21bo_2
XFILLER_67_1163 VGND VGND VPWR VPWR sky130_fd_sc_hd__decap_3
X_4354_ _6271_/Q _4899_/S _4351_/X _4353_/X VGND VGND VPWR VPWR _6271_/D sky130_fd_sc_hd__o22a_2
XFILLER_63_1005 VGND VGND VPWR VPWR sky130_fd_sc_hd__decap_3
XFILLER_8_1208 VGND VGND VPWR VPWR sky130_fd_sc_hd__decap_3
Xfanout406 _4853_/C1 VGND VGND VPWR VPWR _4881_/A sky130_fd_sc_hd__clkdlybuf4s25_1
XFILLER_28_1147 VGND VGND VPWR VPWR sky130_fd_sc_hd__fill_1
Xfanout417 _3219_/B2 VGND VGND VPWR VPWR _3136_/A sky130_fd_sc_hd__clkdlybuf4s25_1
XPHY_EDGE_ROW_18_Left_99 VGND VGND VPWR VPWR sky130_fd_sc_hd__decap_3
Xfanout428 _5591_/A2 VGND VGND VPWR VPWR _3631_/A2 sky130_fd_sc_hd__clkdlybuf4s25_1
X_3305_ hold902/X _3304_/X _3385_/S VGND VGND VPWR VPWR _6126_/D sky130_fd_sc_hd__mux2_1
X_7073_ _7073_/CLK _7073_/D wire687/X VGND VGND VPWR VPWR _7073_/Q sky130_fd_sc_hd__dfrtp_2
X_4285_ _4793_/A _4278_/X _4284_/X VGND VGND VPWR VPWR _4285_/X sky130_fd_sc_hd__o21a_2
XFILLER_80_1341 VGND VGND VPWR VPWR sky130_fd_sc_hd__decap_3
XFILLER_58_128 VGND VGND VPWR VPWR sky130_fd_sc_hd__decap_3
X_6024_ _6024_/A0 _6024_/A1 _6031_/S VGND VGND VPWR VPWR _7028_/D sky130_fd_sc_hd__mux2_1
XFILLER_80_1363 VGND VGND VPWR VPWR sky130_fd_sc_hd__decap_3
XTAP_TAPCELL_ROW_33_1050 VGND VPWR sky130_fd_sc_hd__tapvpwrvgnd_1
XFILLER_39_320 VGND VGND VPWR VPWR sky130_fd_sc_hd__decap_3
X_3236_ _6253_/Q _6349_/Q VGND VGND VPWR VPWR _3236_/X sky130_fd_sc_hd__xor2_2
XFILLER_41_1325 VGND VGND VPWR VPWR sky130_fd_sc_hd__decap_3
XFILLER_80_1385 VGND VGND VPWR VPWR sky130_fd_sc_hd__decap_3
XTAP_TAPCELL_ROW_33_1061 VGND VPWR sky130_fd_sc_hd__tapvpwrvgnd_1
XFILLER_73_109 VGND VGND VPWR VPWR sky130_fd_sc_hd__decap_3
XFILLER_41_1369 VGND VGND VPWR VPWR sky130_fd_sc_hd__decap_3
XFILLER_54_301 VGND VGND VPWR VPWR sky130_fd_sc_hd__decap_3
X_3167_ _3202_/A _3163_/X _3166_/X _3160_/X VGND VGND VPWR VPWR _3167_/X sky130_fd_sc_hd__a31o_2
XFILLER_27_559 VGND VGND VPWR VPWR sky130_fd_sc_hd__fill_1
X_3098_ _3098_/A _3722_/A _6608_/Q VGND VGND VPWR VPWR _3098_/X sky130_fd_sc_hd__and3_2
XTAP_TAPCELL_ROW_46_1400 VGND VPWR sky130_fd_sc_hd__tapvpwrvgnd_1
XFILLER_78_1270 VGND VGND VPWR VPWR sky130_fd_sc_hd__decap_3
X_6926_ _6926_/CLK _6926_/D fanout755/X VGND VGND VPWR VPWR _6926_/Q sky130_fd_sc_hd__dfrtp_2
XFILLER_42_529 VGND VGND VPWR VPWR sky130_fd_sc_hd__decap_3
XFILLER_74_1123 VGND VGND VPWR VPWR sky130_fd_sc_hd__decap_3
XFILLER_23_732 VGND VGND VPWR VPWR sky130_fd_sc_hd__decap_3
XFILLER_39_1254 VGND VGND VPWR VPWR sky130_fd_sc_hd__decap_3
Xfanout24 _5581_/B VGND VGND VPWR VPWR _4344_/B sky130_fd_sc_hd__clkdlybuf4s25_1
XFILLER_80_18 VGND VGND VPWR VPWR sky130_fd_sc_hd__decap_3
X_6857_ _6993_/CLK _6857_/D load_slew710/X VGND VGND VPWR VPWR _6857_/Q sky130_fd_sc_hd__dfrtp_2
Xfanout35 _4891_/B1 VGND VGND VPWR VPWR wire36/A sky130_fd_sc_hd__clkdlybuf4s25_1
XFILLER_74_1167 VGND VGND VPWR VPWR sky130_fd_sc_hd__decap_3
XFILLER_39_1287 VGND VGND VPWR VPWR sky130_fd_sc_hd__fill_1
XFILLER_80_29 VGND VGND VPWR VPWR sky130_fd_sc_hd__decap_3
XFILLER_39_1298 VGND VGND VPWR VPWR sky130_fd_sc_hd__decap_3
XFILLER_22_253 VGND VGND VPWR VPWR sky130_fd_sc_hd__decap_3
Xfanout57 _4106_/Y VGND VGND VPWR VPWR _4782_/S sky130_fd_sc_hd__clkdlybuf4s25_1
X_5808_ _5918_/A1 _5808_/A1 _5813_/S VGND VGND VPWR VPWR _6828_/D sky130_fd_sc_hd__mux2_1
XFILLER_52_1421 VGND VGND VPWR VPWR sky130_fd_sc_hd__decap_3
XFILLER_13_12 VGND VGND VPWR VPWR sky130_fd_sc_hd__decap_3
XFILLER_11_949 VGND VGND VPWR VPWR sky130_fd_sc_hd__decap_3
X_6788_ _7020_/CLK _6788_/D load_slew808/X VGND VGND VPWR VPWR _6788_/Q sky130_fd_sc_hd__dfrtp_2
XFILLER_52_1432 VGND VGND VPWR VPWR sky130_fd_sc_hd__decap_3
XFILLER_13_1416 VGND VGND VPWR VPWR sky130_fd_sc_hd__decap_3
XFILLER_52_1465 VGND VGND VPWR VPWR sky130_fd_sc_hd__decap_3
X_5739_ _5932_/A0 _5739_/A1 _5739_/S VGND VGND VPWR VPWR _6785_/D sky130_fd_sc_hd__mux2_1
XFILLER_6_419 VGND VGND VPWR VPWR sky130_fd_sc_hd__fill_1
XFILLER_13_1449 VGND VGND VPWR VPWR sky130_fd_sc_hd__decap_3
XFILLER_11_1162 VGND VGND VPWR VPWR sky130_fd_sc_hd__decap_3
XFILLER_1_102 VGND VGND VPWR VPWR sky130_fd_sc_hd__decap_3
XFILLER_11_1195 VGND VGND VPWR VPWR sky130_fd_sc_hd__decap_3
XFILLER_1_113 VGND VGND VPWR VPWR sky130_fd_sc_hd__decap_3
XFILLER_1_146 VGND VGND VPWR VPWR sky130_fd_sc_hd__decap_3
XFILLER_2_669 VGND VGND VPWR VPWR sky130_fd_sc_hd__decap_3
XFILLER_46_1247 VGND VGND VPWR VPWR sky130_fd_sc_hd__decap_3
XFILLER_38_53 VGND VGND VPWR VPWR sky130_fd_sc_hd__decap_3
XFILLER_58_651 VGND VGND VPWR VPWR sky130_fd_sc_hd__decap_3
XFILLER_20_1409 VGND VGND VPWR VPWR sky130_fd_sc_hd__decap_3
XFILLER_46_813 VGND VGND VPWR VPWR sky130_fd_sc_hd__decap_3
XFILLER_79_1012 VGND VGND VPWR VPWR sky130_fd_sc_hd__fill_1
XFILLER_45_301 VGND VGND VPWR VPWR sky130_fd_sc_hd__decap_3
Xhold1160 _6746_/Q VGND VGND VPWR VPWR _5695_/A0 sky130_fd_sc_hd__dlygate4sd3_1
XFILLER_58_695 VGND VGND VPWR VPWR sky130_fd_sc_hd__decap_3
XFILLER_79_1034 VGND VGND VPWR VPWR sky130_fd_sc_hd__decap_3
Xhold1171 _6875_/Q VGND VGND VPWR VPWR _5861_/A0 sky130_fd_sc_hd__dlygate4sd3_1
Xhold1182 _6796_/Q VGND VGND VPWR VPWR _5752_/A1 sky130_fd_sc_hd__dlygate4sd3_1
XFILLER_79_1045 VGND VGND VPWR VPWR sky130_fd_sc_hd__decap_3
XFILLER_2_1341 VGND VGND VPWR VPWR sky130_fd_sc_hd__decap_3
XFILLER_45_345 VGND VGND VPWR VPWR sky130_fd_sc_hd__decap_3
Xhold1193 _7037_/Q VGND VGND VPWR VPWR _6033_/A1 sky130_fd_sc_hd__dlygate4sd3_1
XFILLER_22_1291 VGND VGND VPWR VPWR sky130_fd_sc_hd__decap_3
XFILLER_73_676 VGND VGND VPWR VPWR sky130_fd_sc_hd__fill_2
XFILLER_72_153 VGND VGND VPWR VPWR sky130_fd_sc_hd__decap_3
XFILLER_57_1310 VGND VGND VPWR VPWR sky130_fd_sc_hd__decap_3
XFILLER_60_304 VGND VGND VPWR VPWR sky130_fd_sc_hd__decap_3
XFILLER_2_1385 VGND VGND VPWR VPWR sky130_fd_sc_hd__decap_3
XFILLER_45_389 VGND VGND VPWR VPWR sky130_fd_sc_hd__decap_3
XFILLER_54_52 VGND VGND VPWR VPWR sky130_fd_sc_hd__decap_3
XFILLER_61_838 VGND VGND VPWR VPWR sky130_fd_sc_hd__fill_2
XFILLER_14_721 VGND VGND VPWR VPWR sky130_fd_sc_hd__decap_3
XFILLER_57_1343 VGND VGND VPWR VPWR sky130_fd_sc_hd__fill_1
XFILLER_72_197 VGND VGND VPWR VPWR sky130_fd_sc_hd__fill_2
XTAP_TAPCELL_ROW_0_190 VGND VPWR sky130_fd_sc_hd__tapvpwrvgnd_1
XFILLER_26_592 VGND VGND VPWR VPWR sky130_fd_sc_hd__fill_1
XFILLER_57_1354 VGND VGND VPWR VPWR sky130_fd_sc_hd__decap_3
XFILLER_54_85 VGND VGND VPWR VPWR sky130_fd_sc_hd__fill_2
XFILLER_54_96 VGND VGND VPWR VPWR sky130_fd_sc_hd__decap_3
XFILLER_18_1338 VGND VGND VPWR VPWR sky130_fd_sc_hd__decap_3
XFILLER_57_1387 VGND VGND VPWR VPWR sky130_fd_sc_hd__decap_3
XFILLER_16_1073 VGND VGND VPWR VPWR sky130_fd_sc_hd__decap_3
Xclkload16 _6929_/CLK VGND VGND VPWR VPWR clkload16/X sky130_fd_sc_hd__clkbuf_4
Xclkload27 _7092_/CLK VGND VGND VPWR VPWR clkload27/X sky130_fd_sc_hd__clkbuf_4
XTAP_TAPCELL_ROW_11_476 VGND VPWR sky130_fd_sc_hd__tapvpwrvgnd_1
XTAP_TAPCELL_ROW_11_487 VGND VPWR sky130_fd_sc_hd__tapvpwrvgnd_1
Xclkload38 _6958_/CLK VGND VGND VPWR VPWR clkload38/X sky130_fd_sc_hd__clkbuf_8
Xclkload49 _7011_/CLK VGND VGND VPWR VPWR clkload49/X sky130_fd_sc_hd__clkbuf_8
XTAP_TAPCELL_ROW_11_498 VGND VPWR sky130_fd_sc_hd__tapvpwrvgnd_1
XFILLER_5_452 VGND VGND VPWR VPWR sky130_fd_sc_hd__decap_3
XFILLER_29_1401 VGND VGND VPWR VPWR sky130_fd_sc_hd__decap_3
XFILLER_68_1450 VGND VGND VPWR VPWR sky130_fd_sc_hd__decap_3
XFILLER_5_485 VGND VGND VPWR VPWR sky130_fd_sc_hd__decap_3
XFILLER_79_60 VGND VGND VPWR VPWR sky130_fd_sc_hd__decap_3
XFILLER_48_6 VGND VGND VPWR VPWR sky130_fd_sc_hd__decap_3
XFILLER_64_1303 VGND VGND VPWR VPWR sky130_fd_sc_hd__decap_3
XFILLER_29_1434 VGND VGND VPWR VPWR sky130_fd_sc_hd__decap_3
XFILLER_64_1347 VGND VGND VPWR VPWR sky130_fd_sc_hd__decap_3
XFILLER_68_404 VGND VGND VPWR VPWR sky130_fd_sc_hd__decap_3
XFILLER_69_938 VGND VGND VPWR VPWR sky130_fd_sc_hd__decap_3
XFILLER_1_691 VGND VGND VPWR VPWR sky130_fd_sc_hd__decap_3
X_4070_ _4088_/A1 _4694_/B _5605_/A3 _5515_/A1 _6594_/Q VGND VGND VPWR VPWR _4070_/X
+ sky130_fd_sc_hd__a32o_2
XFILLER_7_1263 VGND VGND VPWR VPWR sky130_fd_sc_hd__decap_3
XFILLER_0_190 VGND VGND VPWR VPWR sky130_fd_sc_hd__decap_3
XFILLER_49_673 VGND VGND VPWR VPWR sky130_fd_sc_hd__decap_3
XFILLER_3_1116 VGND VGND VPWR VPWR sky130_fd_sc_hd__decap_3
XFILLER_48_150 VGND VGND VPWR VPWR sky130_fd_sc_hd__fill_2
XFILLER_3_1127 VGND VGND VPWR VPWR sky130_fd_sc_hd__decap_3
XFILLER_36_312 VGND VGND VPWR VPWR sky130_fd_sc_hd__decap_3
XFILLER_36_345 VGND VGND VPWR VPWR sky130_fd_sc_hd__decap_3
XFILLER_52_805 VGND VGND VPWR VPWR sky130_fd_sc_hd__decap_3
XFILLER_40_1391 VGND VGND VPWR VPWR sky130_fd_sc_hd__decap_3
XFILLER_52_816 VGND VGND VPWR VPWR sky130_fd_sc_hd__decap_3
XFILLER_58_1129 VGND VGND VPWR VPWR sky130_fd_sc_hd__decap_3
XFILLER_75_1410 VGND VGND VPWR VPWR sky130_fd_sc_hd__decap_3
X_4972_ _6450_/Q _6668_/Q VGND VGND VPWR VPWR _4973_/B sky130_fd_sc_hd__xor2_2
XFILLER_75_1443 VGND VGND VPWR VPWR sky130_fd_sc_hd__decap_3
X_6711_ _6772_/CLK _6711_/D load_slew825/X VGND VGND VPWR VPWR _6711_/Q sky130_fd_sc_hd__dfrtp_2
X_3923_ _4249_/B _4348_/A VGND VGND VPWR VPWR _4258_/A sky130_fd_sc_hd__xnor2_2
XFILLER_71_1307 VGND VGND VPWR VPWR sky130_fd_sc_hd__decap_3
XFILLER_36_1427 VGND VGND VPWR VPWR sky130_fd_sc_hd__fill_1
XFILLER_36_1438 VGND VGND VPWR VPWR sky130_fd_sc_hd__decap_3
X_6642_ _6954_/CLK _6642_/D load_slew650/X VGND VGND VPWR VPWR _6642_/Q sky130_fd_sc_hd__dfrtp_2
X_3854_ _3855_/B _3855_/C _3855_/A VGND VGND VPWR VPWR _3913_/A sky130_fd_sc_hd__a21o_2
XFILLER_32_595 VGND VGND VPWR VPWR sky130_fd_sc_hd__decap_3
XFILLER_20_757 VGND VGND VPWR VPWR sky130_fd_sc_hd__decap_3
X_6573_ _6819_/CLK _6573_/D load_slew780/X VGND VGND VPWR VPWR _6573_/Q sky130_fd_sc_hd__dfrtp_2
X_3785_ _6217_/Q wire77/X _3783_/X _3784_/X VGND VGND VPWR VPWR _6217_/D sky130_fd_sc_hd__o22a_2
X_5524_ _6611_/Q _3097_/B _5534_/B1 _6612_/Q VGND VGND VPWR VPWR _6612_/D sky130_fd_sc_hd__a22o_2
XFILLER_30_1037 VGND VGND VPWR VPWR sky130_fd_sc_hd__fill_1
XFILLER_69_1225 VGND VGND VPWR VPWR sky130_fd_sc_hd__decap_3
XFILLER_69_1236 VGND VGND VPWR VPWR sky130_fd_sc_hd__decap_3
X_5455_ _5455_/A1 _5487_/A2 _4055_/X VGND VGND VPWR VPWR _6567_/D sky130_fd_sc_hd__a21o_2
XFILLER_69_1269 VGND VGND VPWR VPWR sky130_fd_sc_hd__decap_3
X_4406_ _4405_/B _4163_/B _4405_/Y _4763_/C1 VGND VGND VPWR VPWR _4406_/Y sky130_fd_sc_hd__o211ai_2
XTAP_TAPCELL_ROW_35_1101 VGND VPWR sky130_fd_sc_hd__tapvpwrvgnd_1
X_5386_ _5386_/A1 _5485_/A2 _3816_/X VGND VGND VPWR VPWR _6498_/D sky130_fd_sc_hd__a21o_2
XTAP_TAPCELL_ROW_35_1112 VGND VPWR sky130_fd_sc_hd__tapvpwrvgnd_1
Xfanout203 _3078_/Y VGND VGND VPWR VPWR _3413_/S sky130_fd_sc_hd__clkdlybuf4s25_1
XTAP_TAPCELL_ROW_35_1123 VGND VPWR sky130_fd_sc_hd__tapvpwrvgnd_1
X_4337_ _4337_/A _4337_/B VGND VGND VPWR VPWR _4710_/B sky130_fd_sc_hd__xnor2_2
XFILLER_8_1049 VGND VGND VPWR VPWR sky130_fd_sc_hd__decap_3
Xfanout247 _5476_/A2 VGND VGND VPWR VPWR _5465_/A2 sky130_fd_sc_hd__clkdlybuf4s25_1
XTAP_TAPCELL_ROW_31_1009 VGND VPWR sky130_fd_sc_hd__tapvpwrvgnd_1
Xfanout258 _4602_/B VGND VGND VPWR VPWR _4717_/A sky130_fd_sc_hd__clkdlybuf4s25_1
X_7056_ _7056_/CLK _7056_/D fanout657/A VGND VGND VPWR VPWR _7056_/Q sky130_fd_sc_hd__dfrtp_2
XFILLER_75_919 VGND VGND VPWR VPWR sky130_fd_sc_hd__decap_3
X_4268_ _4783_/B _4335_/A2 _4266_/Y _4267_/X _6488_/Q VGND VGND VPWR VPWR _4268_/X
+ sky130_fd_sc_hd__a32o_2
XFILLER_75_18 VGND VGND VPWR VPWR sky130_fd_sc_hd__decap_3
XFILLER_28_813 VGND VGND VPWR VPWR sky130_fd_sc_hd__fill_1
X_6007_ _6007_/A0 _7011_/Q _6047_/S VGND VGND VPWR VPWR _6007_/X sky130_fd_sc_hd__mux2_1
X_3219_ _7076_/Q _6969_/Q _6977_/Q _3219_/B2 VGND VGND VPWR VPWR _3219_/X sky130_fd_sc_hd__a22o_2
XFILLER_67_470 VGND VGND VPWR VPWR sky130_fd_sc_hd__decap_3
X_4199_ _4277_/B _6481_/Q _4257_/S VGND VGND VPWR VPWR _4199_/X sky130_fd_sc_hd__mux2_1
XFILLER_28_846 VGND VGND VPWR VPWR sky130_fd_sc_hd__decap_3
XFILLER_39_183 VGND VGND VPWR VPWR sky130_fd_sc_hd__decap_3
XFILLER_41_1177 VGND VGND VPWR VPWR sky130_fd_sc_hd__decap_3
XFILLER_27_367 VGND VGND VPWR VPWR sky130_fd_sc_hd__fill_2
XFILLER_76_1229 VGND VGND VPWR VPWR sky130_fd_sc_hd__decap_3
XFILLER_43_827 VGND VGND VPWR VPWR sky130_fd_sc_hd__decap_3
XFILLER_42_315 VGND VGND VPWR VPWR sky130_fd_sc_hd__decap_3
XFILLER_54_175 VGND VGND VPWR VPWR sky130_fd_sc_hd__decap_3
XFILLER_39_1051 VGND VGND VPWR VPWR sky130_fd_sc_hd__decap_3
X_6909_ _7037_/CLK _6909_/D fanout688/X VGND VGND VPWR VPWR _6909_/Q sky130_fd_sc_hd__dfrtp_2
XTAP_TAPCELL_ROW_65_1886 VGND VPWR sky130_fd_sc_hd__tapvpwrvgnd_1
XFILLER_24_55 VGND VGND VPWR VPWR sky130_fd_sc_hd__decap_3
XTAP_TAPCELL_ROW_65_1897 VGND VPWR sky130_fd_sc_hd__tapvpwrvgnd_1
XFILLER_11_724 VGND VGND VPWR VPWR sky130_fd_sc_hd__decap_3
XFILLER_11_757 VGND VGND VPWR VPWR sky130_fd_sc_hd__decap_3
XFILLER_10_223 VGND VGND VPWR VPWR sky130_fd_sc_hd__decap_3
XFILLER_17_1360 VGND VGND VPWR VPWR sky130_fd_sc_hd__decap_3
XFILLER_52_1240 VGND VGND VPWR VPWR sky130_fd_sc_hd__decap_3
XFILLER_7_717 VGND VGND VPWR VPWR sky130_fd_sc_hd__fill_1
XTAP_TAPCELL_ROW_21_741 VGND VPWR sky130_fd_sc_hd__tapvpwrvgnd_1
XTAP_TAPCELL_ROW_21_752 VGND VPWR sky130_fd_sc_hd__tapvpwrvgnd_1
XFILLER_13_1224 VGND VGND VPWR VPWR sky130_fd_sc_hd__decap_3
XFILLER_17_1393 VGND VGND VPWR VPWR sky130_fd_sc_hd__decap_3
XFILLER_52_1273 VGND VGND VPWR VPWR sky130_fd_sc_hd__decap_3
XFILLER_40_21 VGND VGND VPWR VPWR sky130_fd_sc_hd__decap_3
XFILLER_13_1257 VGND VGND VPWR VPWR sky130_fd_sc_hd__decap_3
XFILLER_3_912 VGND VGND VPWR VPWR sky130_fd_sc_hd__decap_3
XFILLER_48_1309 VGND VGND VPWR VPWR sky130_fd_sc_hd__decap_3
XFILLER_3_945 VGND VGND VPWR VPWR sky130_fd_sc_hd__decap_3
XFILLER_3_956 VGND VGND VPWR VPWR sky130_fd_sc_hd__decap_3
XFILLER_49_52 VGND VGND VPWR VPWR sky130_fd_sc_hd__decap_3
XFILLER_2_488 VGND VGND VPWR VPWR sky130_fd_sc_hd__decap_3
XFILLER_77_223 VGND VGND VPWR VPWR sky130_fd_sc_hd__fill_1
XFILLER_78_757 VGND VGND VPWR VPWR sky130_fd_sc_hd__decap_3
XFILLER_24_1320 VGND VGND VPWR VPWR sky130_fd_sc_hd__decap_3
XFILLER_66_919 VGND VGND VPWR VPWR sky130_fd_sc_hd__decap_3
Xfanout770 fanout776/X VGND VGND VPWR VPWR fanout770/X sky130_fd_sc_hd__clkdlybuf4s25_1
XFILLER_4_1403 VGND VGND VPWR VPWR sky130_fd_sc_hd__decap_3
XFILLER_1_15 VGND VGND VPWR VPWR sky130_fd_sc_hd__decap_3
Xfanout781 fanout783/X VGND VGND VPWR VPWR fanout781/X sky130_fd_sc_hd__clkdlybuf4s25_1
XFILLER_24_1353 VGND VGND VPWR VPWR sky130_fd_sc_hd__decap_3
XFILLER_59_993 VGND VGND VPWR VPWR sky130_fd_sc_hd__decap_3
XFILLER_1_48 VGND VGND VPWR VPWR sky130_fd_sc_hd__decap_3
XFILLER_18_312 VGND VGND VPWR VPWR sky130_fd_sc_hd__decap_3
XFILLER_4_1447 VGND VGND VPWR VPWR sky130_fd_sc_hd__decap_3
XFILLER_19_857 VGND VGND VPWR VPWR sky130_fd_sc_hd__decap_3
XFILLER_20_1228 VGND VGND VPWR VPWR sky130_fd_sc_hd__decap_3
XFILLER_24_1397 VGND VGND VPWR VPWR sky130_fd_sc_hd__decap_3
XFILLER_59_1416 VGND VGND VPWR VPWR sky130_fd_sc_hd__decap_3
XFILLER_65_84 VGND VGND VPWR VPWR sky130_fd_sc_hd__fill_1
XFILLER_59_1449 VGND VGND VPWR VPWR sky130_fd_sc_hd__decap_3
XFILLER_2_1182 VGND VGND VPWR VPWR sky130_fd_sc_hd__decap_3
XFILLER_45_186 VGND VGND VPWR VPWR sky130_fd_sc_hd__fill_2
XFILLER_33_337 VGND VGND VPWR VPWR sky130_fd_sc_hd__fill_2
XFILLER_53_1004 VGND VGND VPWR VPWR sky130_fd_sc_hd__decap_3
XFILLER_53_1015 VGND VGND VPWR VPWR sky130_fd_sc_hd__decap_3
XFILLER_42_893 VGND VGND VPWR VPWR sky130_fd_sc_hd__decap_3
XFILLER_41_381 VGND VGND VPWR VPWR sky130_fd_sc_hd__decap_3
XFILLER_18_1179 VGND VGND VPWR VPWR sky130_fd_sc_hd__fill_2
XFILLER_35_1460 VGND VGND VPWR VPWR sky130_fd_sc_hd__decap_3
XFILLER_70_1362 VGND VGND VPWR VPWR sky130_fd_sc_hd__decap_3
XFILLER_31_1313 VGND VGND VPWR VPWR sky130_fd_sc_hd__decap_3
XFILLER_70_1373 VGND VGND VPWR VPWR sky130_fd_sc_hd__decap_3
XFILLER_31_1357 VGND VGND VPWR VPWR sky130_fd_sc_hd__decap_3
X_3570_ _6250_/Q _6258_/Q _6266_/Q _6218_/Q _3496_/B _3566_/A VGND VGND VPWR VPWR
+ _3570_/X sky130_fd_sc_hd__mux4_2
XTAP_TAPCELL_ROW_75_2160 VGND VPWR sky130_fd_sc_hd__tapvpwrvgnd_1
XFILLER_66_1409 VGND VGND VPWR VPWR sky130_fd_sc_hd__decap_3
X_5240_ _5322_/S _5240_/B VGND VGND VPWR VPWR _5240_/Y sky130_fd_sc_hd__nand2_2
XTAP_TAPCELL_ROW_71_2035 VGND VPWR sky130_fd_sc_hd__tapvpwrvgnd_1
XFILLER_46_3 VGND VGND VPWR VPWR sky130_fd_sc_hd__decap_3
XTAP_TAPCELL_ROW_71_2046 VGND VPWR sky130_fd_sc_hd__tapvpwrvgnd_1
XTAP_TAPCELL_ROW_71_2057 VGND VPWR sky130_fd_sc_hd__tapvpwrvgnd_1
XFILLER_29_1242 VGND VGND VPWR VPWR sky130_fd_sc_hd__decap_3
XFILLER_68_1291 VGND VGND VPWR VPWR sky130_fd_sc_hd__decap_3
XFILLER_9_1325 VGND VGND VPWR VPWR sky130_fd_sc_hd__decap_3
X_5171_ _6394_/Q _5254_/A2 _5034_/S _5170_/X VGND VGND VPWR VPWR _6394_/D sky130_fd_sc_hd__a22o_2
XPHY_EDGE_ROW_18_Right_18 VGND VGND VPWR VPWR sky130_fd_sc_hd__decap_3
XFILLER_29_1275 VGND VGND VPWR VPWR sky130_fd_sc_hd__decap_3
XFILLER_9_1369 VGND VGND VPWR VPWR sky130_fd_sc_hd__decap_3
X_4122_ _4122_/A _4122_/B VGND VGND VPWR VPWR _4732_/B sky130_fd_sc_hd__xnor2_2
XFILLER_68_245 VGND VGND VPWR VPWR sky130_fd_sc_hd__decap_3
XFILLER_57_919 VGND VGND VPWR VPWR sky130_fd_sc_hd__decap_3
XFILLER_68_256 VGND VGND VPWR VPWR sky130_fd_sc_hd__fill_2
XFILLER_69_779 VGND VGND VPWR VPWR sky130_fd_sc_hd__decap_3
XFILLER_56_407 VGND VGND VPWR VPWR sky130_fd_sc_hd__decap_3
XFILLER_42_1453 VGND VGND VPWR VPWR sky130_fd_sc_hd__decap_3
X_4053_ _4101_/B _4602_/B VGND VGND VPWR VPWR _4053_/Y sky130_fd_sc_hd__nor2_2
Xinput3 ui_in[1] VGND VGND VPWR VPWR input3/X sky130_fd_sc_hd__buf_1
XFILLER_49_470 VGND VGND VPWR VPWR sky130_fd_sc_hd__decap_3
XFILLER_36_120 VGND VGND VPWR VPWR sky130_fd_sc_hd__fill_2
XFILLER_80_911 VGND VGND VPWR VPWR sky130_fd_sc_hd__decap_3
XFILLER_36_186 VGND VGND VPWR VPWR sky130_fd_sc_hd__decap_3
XFILLER_36_197 VGND VGND VPWR VPWR sky130_fd_sc_hd__decap_3
XFILLER_51_123 VGND VGND VPWR VPWR sky130_fd_sc_hd__decap_3
XFILLER_80_977 VGND VGND VPWR VPWR sky130_fd_sc_hd__decap_3
XFILLER_40_808 VGND VGND VPWR VPWR sky130_fd_sc_hd__decap_3
XFILLER_75_1251 VGND VGND VPWR VPWR sky130_fd_sc_hd__decap_3
XPHY_EDGE_ROW_27_Right_27 VGND VGND VPWR VPWR sky130_fd_sc_hd__decap_3
XFILLER_40_819 VGND VGND VPWR VPWR sky130_fd_sc_hd__decap_3
X_4955_ _4953_/X _4954_/Y _5221_/A2 VGND VGND VPWR VPWR _4957_/S sky130_fd_sc_hd__a21oi_2
XFILLER_75_1284 VGND VGND VPWR VPWR sky130_fd_sc_hd__decap_3
XFILLER_75_1295 VGND VGND VPWR VPWR sky130_fd_sc_hd__decap_3
XFILLER_36_1246 VGND VGND VPWR VPWR sky130_fd_sc_hd__decap_3
X_3906_ _3906_/A _4162_/A VGND VGND VPWR VPWR _3907_/B sky130_fd_sc_hd__xor2_2
XFILLER_51_189 VGND VGND VPWR VPWR sky130_fd_sc_hd__fill_1
X_4886_ _4886_/A1 _4532_/B _4532_/C _4885_/X VGND VGND VPWR VPWR _4889_/B sky130_fd_sc_hd__a31o_2
XFILLER_71_1159 VGND VGND VPWR VPWR sky130_fd_sc_hd__decap_3
XFILLER_36_1279 VGND VGND VPWR VPWR sky130_fd_sc_hd__decap_3
XTAP_TAPCELL_ROW_15_590 VGND VPWR sky130_fd_sc_hd__tapvpwrvgnd_1
X_6625_ _6913_/CLK _6625_/D load_slew769/X VGND VGND VPWR VPWR _6625_/Q sky130_fd_sc_hd__dfrtp_2
X_3837_ _6242_/Q _4822_/A _3835_/X _3836_/X VGND VGND VPWR VPWR _4293_/A sky130_fd_sc_hd__o22a_2
XTAP_TAPCELL_ROW_60_1750 VGND VPWR sky130_fd_sc_hd__tapvpwrvgnd_1
XTAP_TAPCELL_ROW_60_1761 VGND VPWR sky130_fd_sc_hd__tapvpwrvgnd_1
Xtt_um_aes128_optimized_851 VGND VGND VPWR VPWR tt_um_aes128_optimized_851/HI uio_oe[3]
+ sky130_fd_sc_hd__conb_1
XTAP_TAPCELL_ROW_60_1772 VGND VPWR sky130_fd_sc_hd__tapvpwrvgnd_1
X_6556_ _6982_/CLK _6556_/D fanout745/X VGND VGND VPWR VPWR _6556_/Q sky130_fd_sc_hd__dfrtp_2
X_3768_ _3927_/A_N _6305_/Q VGND VGND VPWR VPWR _3768_/X sky130_fd_sc_hd__and2b_2
X_5507_ _5505_/A _5512_/B _5508_/B _5513_/A VGND VGND VPWR VPWR _6604_/D sky130_fd_sc_hd__o211a_2
X_6487_ _6889_/CLK _6487_/D fanout713/X VGND VGND VPWR VPWR _6487_/Q sky130_fd_sc_hd__dfrtp_2
XFILLER_10_24 VGND VGND VPWR VPWR sky130_fd_sc_hd__decap_3
X_3699_ _3658_/Y _3687_/B _3695_/Y _3652_/A VGND VGND VPWR VPWR _3762_/A sky130_fd_sc_hd__a211o_2
XFILLER_10_46 VGND VGND VPWR VPWR sky130_fd_sc_hd__decap_3
X_5438_ _5438_/A1 _5470_/A2 _4654_/X VGND VGND VPWR VPWR _6550_/D sky130_fd_sc_hd__a21o_2
XPHY_EDGE_ROW_36_Right_36 VGND VGND VPWR VPWR sky130_fd_sc_hd__decap_3
XFILLER_47_1331 VGND VGND VPWR VPWR sky130_fd_sc_hd__decap_3
XFILLER_0_915 VGND VGND VPWR VPWR sky130_fd_sc_hd__decap_3
XFILLER_0_937 VGND VGND VPWR VPWR sky130_fd_sc_hd__decap_3
X_5369_ _5369_/A1 _5465_/A2 _4205_/X VGND VGND VPWR VPWR _6481_/D sky130_fd_sc_hd__a21o_2
XFILLER_47_1375 VGND VGND VPWR VPWR sky130_fd_sc_hd__decap_3
XFILLER_0_959 VGND VGND VPWR VPWR sky130_fd_sc_hd__decap_3
XFILLER_59_234 VGND VGND VPWR VPWR sky130_fd_sc_hd__decap_3
XFILLER_48_908 VGND VGND VPWR VPWR sky130_fd_sc_hd__decap_3
XFILLER_43_1239 VGND VGND VPWR VPWR sky130_fd_sc_hd__decap_3
XTAP_TAPCELL_ROW_54_1598 VGND VPWR sky130_fd_sc_hd__tapvpwrvgnd_1
XFILLER_19_109 VGND VGND VPWR VPWR sky130_fd_sc_hd__decap_3
XFILLER_75_738 VGND VGND VPWR VPWR sky130_fd_sc_hd__decap_3
XFILLER_47_429 VGND VGND VPWR VPWR sky130_fd_sc_hd__decap_3
X_7039_ _7039_/CLK _7039_/D fanout820/X VGND VGND VPWR VPWR _7039_/Q sky130_fd_sc_hd__dfrtp_2
XFILLER_28_610 VGND VGND VPWR VPWR sky130_fd_sc_hd__fill_1
XTAP_TAPCELL_ROW_2_241 VGND VPWR sky130_fd_sc_hd__tapvpwrvgnd_1
XTAP_TAPCELL_ROW_2_252 VGND VPWR sky130_fd_sc_hd__tapvpwrvgnd_1
XFILLER_28_654 VGND VGND VPWR VPWR sky130_fd_sc_hd__decap_3
XFILLER_56_963 VGND VGND VPWR VPWR sky130_fd_sc_hd__decap_3
XFILLER_71_900 VGND VGND VPWR VPWR sky130_fd_sc_hd__decap_3
XTAP_TAPCELL_ROW_2_263 VGND VPWR sky130_fd_sc_hd__tapvpwrvgnd_1
XFILLER_16_816 VGND VGND VPWR VPWR sky130_fd_sc_hd__fill_1
XTAP_TAPCELL_ROW_67_1937 VGND VPWR sky130_fd_sc_hd__tapvpwrvgnd_1
XFILLER_16_838 VGND VGND VPWR VPWR sky130_fd_sc_hd__decap_3
XTAP_TAPCELL_ROW_67_1948 VGND VPWR sky130_fd_sc_hd__tapvpwrvgnd_1
XFILLER_15_315 VGND VGND VPWR VPWR sky130_fd_sc_hd__decap_3
XFILLER_76_1037 VGND VGND VPWR VPWR sky130_fd_sc_hd__decap_3
XPHY_EDGE_ROW_45_Right_45 VGND VGND VPWR VPWR sky130_fd_sc_hd__decap_3
XFILLER_70_432 VGND VGND VPWR VPWR sky130_fd_sc_hd__decap_3
XFILLER_27_197 VGND VGND VPWR VPWR sky130_fd_sc_hd__decap_3
XFILLER_35_54 VGND VGND VPWR VPWR sky130_fd_sc_hd__fill_2
XFILLER_15_348 VGND VGND VPWR VPWR sky130_fd_sc_hd__decap_3
XFILLER_43_668 VGND VGND VPWR VPWR sky130_fd_sc_hd__decap_3
XFILLER_71_988 VGND VGND VPWR VPWR sky130_fd_sc_hd__fill_1
XFILLER_19_1422 VGND VGND VPWR VPWR sky130_fd_sc_hd__decap_3
XTAP_TAPCELL_ROW_26_866 VGND VPWR sky130_fd_sc_hd__tapvpwrvgnd_1
XFILLER_43_679 VGND VGND VPWR VPWR sky130_fd_sc_hd__decap_3
XTAP_TAPCELL_ROW_26_877 VGND VPWR sky130_fd_sc_hd__tapvpwrvgnd_1
XFILLER_30_307 VGND VGND VPWR VPWR sky130_fd_sc_hd__fill_1
XTAP_TAPCELL_ROW_26_888 VGND VPWR sky130_fd_sc_hd__tapvpwrvgnd_1
XFILLER_19_1455 VGND VGND VPWR VPWR sky130_fd_sc_hd__fill_1
XFILLER_54_1335 VGND VGND VPWR VPWR sky130_fd_sc_hd__decap_3
XFILLER_19_1466 VGND VGND VPWR VPWR sky130_fd_sc_hd__decap_3
XTAP_TAPCELL_ROW_13_527 VGND VPWR sky130_fd_sc_hd__tapvpwrvgnd_1
XFILLER_11_521 VGND VGND VPWR VPWR sky130_fd_sc_hd__decap_3
XTAP_TAPCELL_ROW_13_538 VGND VPWR sky130_fd_sc_hd__tapvpwrvgnd_1
XFILLER_23_381 VGND VGND VPWR VPWR sky130_fd_sc_hd__decap_3
XTAP_TAPCELL_ROW_13_549 VGND VPWR sky130_fd_sc_hd__tapvpwrvgnd_1
XFILLER_15_1319 VGND VGND VPWR VPWR sky130_fd_sc_hd__decap_3
XFILLER_54_1368 VGND VGND VPWR VPWR sky130_fd_sc_hd__decap_3
XFILLER_54_1379 VGND VGND VPWR VPWR sky130_fd_sc_hd__decap_3
XFILLER_51_42 VGND VGND VPWR VPWR sky130_fd_sc_hd__decap_3
XFILLER_7_514 VGND VGND VPWR VPWR sky130_fd_sc_hd__decap_3
Xwire434 _5075_/A VGND VGND VPWR VPWR wire434/X sky130_fd_sc_hd__clkbuf_4
XFILLER_52_1070 VGND VGND VPWR VPWR sky130_fd_sc_hd__decap_3
XFILLER_7_547 VGND VGND VPWR VPWR sky130_fd_sc_hd__decap_3
XFILLER_13_1043 VGND VGND VPWR VPWR sky130_fd_sc_hd__decap_3
XFILLER_13_1065 VGND VGND VPWR VPWR sky130_fd_sc_hd__decap_3
XPHY_EDGE_ROW_54_Right_54 VGND VGND VPWR VPWR sky130_fd_sc_hd__decap_3
XFILLER_2_230 VGND VGND VPWR VPWR sky130_fd_sc_hd__decap_3
XFILLER_65_1431 VGND VGND VPWR VPWR sky130_fd_sc_hd__decap_3
XFILLER_3_775 VGND VGND VPWR VPWR sky130_fd_sc_hd__fill_1
XFILLER_3_797 VGND VGND VPWR VPWR sky130_fd_sc_hd__decap_3
XFILLER_26_1415 VGND VGND VPWR VPWR sky130_fd_sc_hd__decap_3
XFILLER_32_9 VGND VGND VPWR VPWR sky130_fd_sc_hd__decap_3
XFILLER_2_285 VGND VGND VPWR VPWR sky130_fd_sc_hd__decap_3
Xload_slew439 _5083_/A VGND VGND VPWR VPWR _5031_/B1 sky130_fd_sc_hd__buf_4
XFILLER_61_1328 VGND VGND VPWR VPWR sky130_fd_sc_hd__decap_3
XFILLER_39_919 VGND VGND VPWR VPWR sky130_fd_sc_hd__decap_3
XFILLER_26_1459 VGND VGND VPWR VPWR sky130_fd_sc_hd__decap_3
XFILLER_78_587 VGND VGND VPWR VPWR sky130_fd_sc_hd__fill_1
XFILLER_76_50 VGND VGND VPWR VPWR sky130_fd_sc_hd__decap_3
XFILLER_4_1200 VGND VGND VPWR VPWR sky130_fd_sc_hd__decap_3
XFILLER_65_204 VGND VGND VPWR VPWR sky130_fd_sc_hd__decap_3
XFILLER_4_1211 VGND VGND VPWR VPWR sky130_fd_sc_hd__decap_3
XFILLER_8_1391 VGND VGND VPWR VPWR sky130_fd_sc_hd__decap_3
XFILLER_4_1244 VGND VGND VPWR VPWR sky130_fd_sc_hd__decap_3
XFILLER_18_120 VGND VGND VPWR VPWR sky130_fd_sc_hd__fill_2
XPHY_EDGE_ROW_63_Right_63 VGND VGND VPWR VPWR sky130_fd_sc_hd__decap_3
XFILLER_74_760 VGND VGND VPWR VPWR sky130_fd_sc_hd__decap_3
XFILLER_0_1108 VGND VGND VPWR VPWR sky130_fd_sc_hd__decap_3
XFILLER_4_1288 VGND VGND VPWR VPWR sky130_fd_sc_hd__decap_3
XFILLER_18_153 VGND VGND VPWR VPWR sky130_fd_sc_hd__decap_3
XFILLER_46_473 VGND VGND VPWR VPWR sky130_fd_sc_hd__decap_3
XFILLER_62_933 VGND VGND VPWR VPWR sky130_fd_sc_hd__fill_1
XFILLER_73_281 VGND VGND VPWR VPWR sky130_fd_sc_hd__fill_2
XFILLER_59_1257 VGND VGND VPWR VPWR sky130_fd_sc_hd__decap_3
XFILLER_18_197 VGND VGND VPWR VPWR sky130_fd_sc_hd__decap_3
XFILLER_33_145 VGND VGND VPWR VPWR sky130_fd_sc_hd__decap_3
XFILLER_72_1424 VGND VGND VPWR VPWR sky130_fd_sc_hd__decap_3
XFILLER_72_1435 VGND VGND VPWR VPWR sky130_fd_sc_hd__decap_3
X_4740_ _6570_/Q _4740_/B VGND VGND VPWR VPWR _4740_/Y sky130_fd_sc_hd__nand2_2
XFILLER_61_498 VGND VGND VPWR VPWR sky130_fd_sc_hd__decap_3
XFILLER_72_1468 VGND VGND VPWR VPWR sky130_fd_sc_hd__fill_1
XFILLER_14_392 VGND VGND VPWR VPWR sky130_fd_sc_hd__fill_2
XFILLER_33_1419 VGND VGND VPWR VPWR sky130_fd_sc_hd__decap_3
X_4671_ _6890_/Q _4790_/A2 _4669_/X _4670_/X VGND VGND VPWR VPWR _4671_/X sky130_fd_sc_hd__a211o_2
XTAP_TAPCELL_ROW_77_2200 VGND VPWR sky130_fd_sc_hd__tapvpwrvgnd_1
XTAP_TAPCELL_ROW_77_2211 VGND VPWR sky130_fd_sc_hd__tapvpwrvgnd_1
XFILLER_70_1170 VGND VGND VPWR VPWR sky130_fd_sc_hd__decap_3
XFILLER_31_1121 VGND VGND VPWR VPWR sky130_fd_sc_hd__fill_1
X_6410_ _7019_/CLK _6410_/D load_slew837/X VGND VGND VPWR VPWR _6410_/Q sky130_fd_sc_hd__dfrtp_2
X_3622_ _3622_/A _3622_/B VGND VGND VPWR VPWR _3622_/X sky130_fd_sc_hd__or2_2
XPHY_EDGE_ROW_72_Right_72 VGND VGND VPWR VPWR sky130_fd_sc_hd__decap_3
XFILLER_31_1143 VGND VGND VPWR VPWR sky130_fd_sc_hd__decap_3
XTAP_TAPCELL_ROW_73_2108 VGND VPWR sky130_fd_sc_hd__tapvpwrvgnd_1
X_6341_ _6863_/CLK _6341_/D load_slew757/X VGND VGND VPWR VPWR _6341_/Q sky130_fd_sc_hd__dfrtp_2
X_3553_ _6249_/Q _6257_/Q _6265_/Q _6217_/Q _3550_/B _3601_/A VGND VGND VPWR VPWR
+ _3553_/X sky130_fd_sc_hd__mux4_2
XFILLER_66_1217 VGND VGND VPWR VPWR sky130_fd_sc_hd__decap_3
X_6272_ _7073_/CLK _6272_/D load_slew684/X VGND VGND VPWR VPWR _6272_/Q sky130_fd_sc_hd__dfrtp_2
X_3484_ _5506_/A _5515_/A1 _3483_/Y VGND VGND VPWR VPWR _3490_/B sky130_fd_sc_hd__a21o_2
X_5223_ _6754_/Q _5326_/S _5327_/S _5222_/Y VGND VGND VPWR VPWR _5223_/X sky130_fd_sc_hd__o211a_2
XFILLER_9_1111 VGND VGND VPWR VPWR sky130_fd_sc_hd__decap_3
XFILLER_9_1133 VGND VGND VPWR VPWR sky130_fd_sc_hd__decap_3
X_5154_ _6724_/Q _5328_/S VGND VGND VPWR VPWR _5154_/X sky130_fd_sc_hd__or2_2
XFILLER_9_1166 VGND VGND VPWR VPWR sky130_fd_sc_hd__decap_3
XFILLER_9_1177 VGND VGND VPWR VPWR sky130_fd_sc_hd__decap_3
XFILLER_69_576 VGND VGND VPWR VPWR sky130_fd_sc_hd__decap_3
X_4105_ _6247_/Q _4105_/A2 _4103_/X _4104_/X VGND VGND VPWR VPWR _6247_/D sky130_fd_sc_hd__o22a_2
X_5085_ _6369_/Q _5082_/X _5084_/X _5305_/S VGND VGND VPWR VPWR _6369_/D sky130_fd_sc_hd__a22o_2
XFILLER_56_226 VGND VGND VPWR VPWR sky130_fd_sc_hd__fill_2
XFILLER_42_1261 VGND VGND VPWR VPWR sky130_fd_sc_hd__decap_3
XFILLER_2_80 VGND VGND VPWR VPWR sky130_fd_sc_hd__decap_3
XFILLER_38_941 VGND VGND VPWR VPWR sky130_fd_sc_hd__decap_3
XFILLER_2_91 VGND VGND VPWR VPWR sky130_fd_sc_hd__decap_3
X_4036_ _6564_/Q _4696_/B _3486_/B VGND VGND VPWR VPWR _4036_/X sky130_fd_sc_hd__a21bo_2
XFILLER_42_1294 VGND VGND VPWR VPWR sky130_fd_sc_hd__decap_3
XFILLER_77_1313 VGND VGND VPWR VPWR sky130_fd_sc_hd__decap_3
XFILLER_65_782 VGND VGND VPWR VPWR sky130_fd_sc_hd__fill_2
XFILLER_52_410 VGND VGND VPWR VPWR sky130_fd_sc_hd__fill_2
XFILLER_77_1357 VGND VGND VPWR VPWR sky130_fd_sc_hd__decap_3
XFILLER_52_421 VGND VGND VPWR VPWR sky130_fd_sc_hd__decap_3
XFILLER_80_741 VGND VGND VPWR VPWR sky130_fd_sc_hd__decap_3
XFILLER_25_646 VGND VGND VPWR VPWR sky130_fd_sc_hd__decap_3
XFILLER_25_668 VGND VGND VPWR VPWR sky130_fd_sc_hd__decap_3
XFILLER_80_763 VGND VGND VPWR VPWR sky130_fd_sc_hd__decap_3
XTAP_TAPCELL_ROW_62_1801 VGND VPWR sky130_fd_sc_hd__tapvpwrvgnd_1
X_5987_ _5987_/A0 _6991_/Q _6051_/S VGND VGND VPWR VPWR _5987_/X sky130_fd_sc_hd__mux2_1
XFILLER_80_785 VGND VGND VPWR VPWR sky130_fd_sc_hd__fill_1
XTAP_TAPCELL_ROW_23_803 VGND VPWR sky130_fd_sc_hd__tapvpwrvgnd_1
XFILLER_36_1010 VGND VGND VPWR VPWR sky130_fd_sc_hd__decap_3
XFILLER_40_616 VGND VGND VPWR VPWR sky130_fd_sc_hd__fill_2
XTAP_TAPCELL_ROW_62_1812 VGND VPWR sky130_fd_sc_hd__tapvpwrvgnd_1
XTAP_TAPCELL_ROW_62_1823 VGND VPWR sky130_fd_sc_hd__tapvpwrvgnd_1
XFILLER_75_1081 VGND VGND VPWR VPWR sky130_fd_sc_hd__decap_3
XFILLER_36_1032 VGND VGND VPWR VPWR sky130_fd_sc_hd__decap_3
X_4938_ _6413_/Q _4938_/B VGND VGND VPWR VPWR _5213_/B sky130_fd_sc_hd__xnor2_2
XFILLER_21_830 VGND VGND VPWR VPWR sky130_fd_sc_hd__decap_3
XFILLER_36_1043 VGND VGND VPWR VPWR sky130_fd_sc_hd__decap_3
XFILLER_21_841 VGND VGND VPWR VPWR sky130_fd_sc_hd__decap_3
XANTENNA_30 _7076_/Q VGND VGND VPWR VPWR sky130_fd_sc_hd__diode_2
X_4869_ _6925_/Q _4869_/A2 _4869_/B1 _4868_/X VGND VGND VPWR VPWR _4869_/X sky130_fd_sc_hd__a211o_2
XANTENNA_41 _5914_/S VGND VGND VPWR VPWR sky130_fd_sc_hd__diode_2
XFILLER_36_1087 VGND VGND VPWR VPWR sky130_fd_sc_hd__decap_3
XANTENNA_52 _5627_/S VGND VGND VPWR VPWR sky130_fd_sc_hd__diode_2
XANTENNA_63 _3205_/B1 VGND VGND VPWR VPWR sky130_fd_sc_hd__diode_2
XFILLER_14_1341 VGND VGND VPWR VPWR sky130_fd_sc_hd__decap_3
XFILLER_53_1390 VGND VGND VPWR VPWR sky130_fd_sc_hd__decap_3
XANTENNA_74 _5502_/C VGND VGND VPWR VPWR sky130_fd_sc_hd__diode_2
XFILLER_21_12 VGND VGND VPWR VPWR sky130_fd_sc_hd__decap_3
X_6608_ _7057_/CLK _6608_/D fanout725/X VGND VGND VPWR VPWR _6608_/Q sky130_fd_sc_hd__dfrtp_2
XANTENNA_85 input9/X VGND VGND VPWR VPWR sky130_fd_sc_hd__diode_2
XFILLER_10_1205 VGND VGND VPWR VPWR sky130_fd_sc_hd__decap_3
XFILLER_14_1385 VGND VGND VPWR VPWR sky130_fd_sc_hd__decap_3
X_6539_ _7041_/CLK _6539_/D load_slew718/X VGND VGND VPWR VPWR _6539_/Q sky130_fd_sc_hd__dfrtp_2
XFILLER_10_1238 VGND VGND VPWR VPWR sky130_fd_sc_hd__decap_3
XFILLER_49_1404 VGND VGND VPWR VPWR sky130_fd_sc_hd__decap_3
XFILLER_4_539 VGND VGND VPWR VPWR sky130_fd_sc_hd__decap_3
XFILLER_49_1437 VGND VGND VPWR VPWR sky130_fd_sc_hd__decap_3
XTAP_TAPCELL_ROW_56_1649 VGND VPWR sky130_fd_sc_hd__tapvpwrvgnd_1
XFILLER_0_701 VGND VGND VPWR VPWR sky130_fd_sc_hd__decap_3
XFILLER_47_1172 VGND VGND VPWR VPWR sky130_fd_sc_hd__decap_3
XTAP_TAPCELL_ROW_7_377 VGND VPWR sky130_fd_sc_hd__tapvpwrvgnd_1
XFILLER_43_1025 VGND VGND VPWR VPWR sky130_fd_sc_hd__decap_3
XFILLER_0_778 VGND VGND VPWR VPWR sky130_fd_sc_hd__decap_3
XTAP_TAPCELL_ROW_7_388 VGND VPWR sky130_fd_sc_hd__tapvpwrvgnd_1
XFILLER_48_727 VGND VGND VPWR VPWR sky130_fd_sc_hd__decap_3
XFILLER_21_1301 VGND VGND VPWR VPWR sky130_fd_sc_hd__decap_3
XFILLER_60_1350 VGND VGND VPWR VPWR sky130_fd_sc_hd__decap_3
XFILLER_21_1334 VGND VGND VPWR VPWR sky130_fd_sc_hd__decap_3
XFILLER_21_1345 VGND VGND VPWR VPWR sky130_fd_sc_hd__decap_3
XFILLER_60_1394 VGND VGND VPWR VPWR sky130_fd_sc_hd__decap_3
XPHY_EDGE_ROW_6_Left_87 VGND VGND VPWR VPWR sky130_fd_sc_hd__decap_3
XFILLER_1_1428 VGND VGND VPWR VPWR sky130_fd_sc_hd__decap_3
XFILLER_56_771 VGND VGND VPWR VPWR sky130_fd_sc_hd__decap_3
XFILLER_16_613 VGND VGND VPWR VPWR sky130_fd_sc_hd__decap_3
XFILLER_21_1378 VGND VGND VPWR VPWR sky130_fd_sc_hd__decap_3
XFILLER_55_270 VGND VGND VPWR VPWR sky130_fd_sc_hd__decap_3
XFILLER_43_432 VGND VGND VPWR VPWR sky130_fd_sc_hd__fill_1
Xmax_cap87 _5738_/S VGND VGND VPWR VPWR _5739_/S sky130_fd_sc_hd__clkbuf_8
Xmax_cap98 _5839_/S VGND VGND VPWR VPWR _5840_/S sky130_fd_sc_hd__buf_6
XFILLER_71_774 VGND VGND VPWR VPWR sky130_fd_sc_hd__fill_2
XFILLER_15_167 VGND VGND VPWR VPWR sky130_fd_sc_hd__fill_1
XFILLER_44_999 VGND VGND VPWR VPWR sky130_fd_sc_hd__decap_3
XFILLER_12_830 VGND VGND VPWR VPWR sky130_fd_sc_hd__decap_3
XFILLER_31_649 VGND VGND VPWR VPWR sky130_fd_sc_hd__fill_2
XFILLER_19_1263 VGND VGND VPWR VPWR sky130_fd_sc_hd__decap_3
XFILLER_8_845 VGND VGND VPWR VPWR sky130_fd_sc_hd__decap_3
XFILLER_32_1441 VGND VGND VPWR VPWR sky130_fd_sc_hd__decap_3
XFILLER_3_561 VGND VGND VPWR VPWR sky130_fd_sc_hd__decap_3
XFILLER_79_830 VGND VGND VPWR VPWR sky130_fd_sc_hd__fill_2
Xload_slew214 _6052_/S VGND VGND VPWR VPWR _6053_/S sky130_fd_sc_hd__buf_4
XFILLER_79_841 VGND VGND VPWR VPWR sky130_fd_sc_hd__decap_3
Xload_slew225 _5975_/S VGND VGND VPWR VPWR _6048_/S sky130_fd_sc_hd__clkbuf_4
XFILLER_30_6 VGND VGND VPWR VPWR sky130_fd_sc_hd__decap_3
XFILLER_65_1272 VGND VGND VPWR VPWR sky130_fd_sc_hd__decap_3
XFILLER_6_1306 VGND VGND VPWR VPWR sky130_fd_sc_hd__decap_3
XFILLER_6_1317 VGND VGND VPWR VPWR sky130_fd_sc_hd__decap_3
XFILLER_39_705 VGND VGND VPWR VPWR sky130_fd_sc_hd__fill_2
XFILLER_26_1256 VGND VGND VPWR VPWR sky130_fd_sc_hd__decap_3
XFILLER_26_1267 VGND VGND VPWR VPWR sky130_fd_sc_hd__decap_3
XFILLER_61_1169 VGND VGND VPWR VPWR sky130_fd_sc_hd__fill_2
XFILLER_19_473 VGND VGND VPWR VPWR sky130_fd_sc_hd__decap_3
X_5910_ _5910_/A0 _5910_/A1 _5913_/S VGND VGND VPWR VPWR _6917_/D sky130_fd_sc_hd__mux2_1
XFILLER_4_1085 VGND VGND VPWR VPWR sky130_fd_sc_hd__decap_3
XFILLER_34_410 VGND VGND VPWR VPWR sky130_fd_sc_hd__decap_3
XFILLER_4_1096 VGND VGND VPWR VPWR sky130_fd_sc_hd__decap_3
XFILLER_19_495 VGND VGND VPWR VPWR sky130_fd_sc_hd__decap_3
X_6890_ _7016_/CLK _6890_/D load_slew662/X VGND VGND VPWR VPWR _6890_/Q sky130_fd_sc_hd__dfrtp_2
XFILLER_34_421 VGND VGND VPWR VPWR sky130_fd_sc_hd__fill_2
XFILLER_62_730 VGND VGND VPWR VPWR sky130_fd_sc_hd__decap_3
XTAP_TAPCELL_ROW_17_630 VGND VPWR sky130_fd_sc_hd__tapvpwrvgnd_1
XTAP_TAPCELL_ROW_17_641 VGND VPWR sky130_fd_sc_hd__tapvpwrvgnd_1
X_5841_ _5906_/B _5915_/B _5841_/C _5915_/D VGND VGND VPWR VPWR _5845_/S sky130_fd_sc_hd__and4b_2
XFILLER_34_454 VGND VGND VPWR VPWR sky130_fd_sc_hd__decap_3
XTAP_TAPCELL_ROW_17_652 VGND VPWR sky130_fd_sc_hd__tapvpwrvgnd_1
XFILLER_22_605 VGND VGND VPWR VPWR sky130_fd_sc_hd__decap_3
XFILLER_50_914 VGND VGND VPWR VPWR sky130_fd_sc_hd__decap_3
XFILLER_50_925 VGND VGND VPWR VPWR sky130_fd_sc_hd__fill_2
XFILLER_61_273 VGND VGND VPWR VPWR sky130_fd_sc_hd__decap_3
XFILLER_50_947 VGND VGND VPWR VPWR sky130_fd_sc_hd__decap_3
XFILLER_72_1232 VGND VGND VPWR VPWR sky130_fd_sc_hd__decap_3
X_5772_ _5915_/D _5906_/B _5879_/A VGND VGND VPWR VPWR _5859_/C sky130_fd_sc_hd__and3_2
XFILLER_37_1363 VGND VGND VPWR VPWR sky130_fd_sc_hd__decap_3
XFILLER_21_148 VGND VGND VPWR VPWR sky130_fd_sc_hd__decap_3
X_4723_ _4842_/A _4723_/B _4723_/C VGND VGND VPWR VPWR _4723_/X sky130_fd_sc_hd__or3_2
XFILLER_72_1276 VGND VGND VPWR VPWR sky130_fd_sc_hd__decap_3
XFILLER_33_1227 VGND VGND VPWR VPWR sky130_fd_sc_hd__decap_3
XFILLER_37_1396 VGND VGND VPWR VPWR sky130_fd_sc_hd__decap_3
XFILLER_30_682 VGND VGND VPWR VPWR sky130_fd_sc_hd__fill_2
X_4654_ _4654_/A1 _4651_/X _4652_/Y _4653_/X _4831_/C1 VGND VGND VPWR VPWR _4654_/X
+ sky130_fd_sc_hd__o221a_2
X_3605_ wire95/X _3605_/B VGND VGND VPWR VPWR _3636_/A sky130_fd_sc_hd__xor2_2
X_4585_ _6300_/Q _4759_/A2 _4582_/X _4584_/X VGND VGND VPWR VPWR _6300_/D sky130_fd_sc_hd__o22a_2
X_6324_ _6974_/CLK _6324_/D fanout779/X VGND VGND VPWR VPWR _6324_/Q sky130_fd_sc_hd__dfrtp_2
X_3536_ _5506_/A _3535_/X _3524_/X VGND VGND VPWR VPWR wire95/A sky130_fd_sc_hd__a21oi_2
Xhold867 _6012_/X VGND VGND VPWR VPWR _7016_/D sky130_fd_sc_hd__dlygate4sd3_1
Xhold878 _6169_/Q VGND VGND VPWR VPWR hold878/X sky130_fd_sc_hd__dlygate4sd3_1
Xhold889 _6684_/Q VGND VGND VPWR VPWR hold889/X sky130_fd_sc_hd__dlygate4sd3_1
X_6255_ _7057_/CLK _6255_/D fanout727/X VGND VGND VPWR VPWR _6255_/Q sky130_fd_sc_hd__dfrtp_2
XFILLER_66_1058 VGND VGND VPWR VPWR sky130_fd_sc_hd__decap_3
X_3467_ _6054_/A0 _3466_/X _3473_/S VGND VGND VPWR VPWR _6207_/D sky130_fd_sc_hd__mux2_1
XFILLER_44_1312 VGND VGND VPWR VPWR sky130_fd_sc_hd__decap_3
XFILLER_44_1323 VGND VGND VPWR VPWR sky130_fd_sc_hd__decap_3
X_5206_ _6410_/Q _5215_/A2 _5205_/X VGND VGND VPWR VPWR _6410_/D sky130_fd_sc_hd__a21o_2
XFILLER_69_340 VGND VGND VPWR VPWR sky130_fd_sc_hd__decap_3
XTAP_TAPCELL_ROW_4_303 VGND VPWR sky130_fd_sc_hd__tapvpwrvgnd_1
XTAP_TAPCELL_ROW_51_1524 VGND VPWR sky130_fd_sc_hd__tapvpwrvgnd_1
X_6186_ _7037_/CLK _6186_/D fanout683/X VGND VGND VPWR VPWR _6186_/Q sky130_fd_sc_hd__dfrtp_2
X_3398_ _6318_/Q _6430_/Q VGND VGND VPWR VPWR _3398_/X sky130_fd_sc_hd__xor2_2
XTAP_TAPCELL_ROW_4_314 VGND VPWR sky130_fd_sc_hd__tapvpwrvgnd_1
XTAP_TAPCELL_ROW_51_1535 VGND VPWR sky130_fd_sc_hd__tapvpwrvgnd_1
XFILLER_44_1356 VGND VGND VPWR VPWR sky130_fd_sc_hd__decap_3
Xhold1501 _6597_/Q VGND VGND VPWR VPWR _5485_/A1 sky130_fd_sc_hd__dlygate4sd3_1
Xhold1512 _6576_/Q VGND VGND VPWR VPWR _5464_/A1 sky130_fd_sc_hd__dlygate4sd3_1
X_5137_ _6377_/Q _5215_/A2 _4915_/S _5136_/X VGND VGND VPWR VPWR _6377_/D sky130_fd_sc_hd__a22o_2
Xhold1523 _6542_/Q VGND VGND VPWR VPWR _5430_/A1 sky130_fd_sc_hd__dlygate4sd3_1
Xload_slew792 fanout791/X VGND VGND VPWR VPWR load_slew792/X sky130_fd_sc_hd__buf_2
Xhold1534 _6174_/Q VGND VGND VPWR VPWR _3401_/A0 sky130_fd_sc_hd__dlygate4sd3_1
Xhold1545 _6665_/Q VGND VGND VPWR VPWR _5592_/B2 sky130_fd_sc_hd__dlygate4sd3_1
XFILLER_79_1419 VGND VGND VPWR VPWR sky130_fd_sc_hd__decap_3
Xhold1556 _6681_/Q VGND VGND VPWR VPWR _5610_/B2 sky130_fd_sc_hd__dlygate4sd3_1
XFILLER_45_708 VGND VGND VPWR VPWR sky130_fd_sc_hd__decap_3
Xhold1567 _7069_/Q VGND VGND VPWR VPWR _6067_/A1 sky130_fd_sc_hd__dlygate4sd3_1
X_5068_ _6705_/Q _3071_/Y _5318_/S VGND VGND VPWR VPWR _5068_/X sky130_fd_sc_hd__mux2_1
XTAP_TAPCELL_ROW_28_917 VGND VPWR sky130_fd_sc_hd__tapvpwrvgnd_1
XFILLER_72_516 VGND VGND VPWR VPWR sky130_fd_sc_hd__decap_3
XTAP_TAPCELL_ROW_28_928 VGND VPWR sky130_fd_sc_hd__tapvpwrvgnd_1
XFILLER_77_1110 VGND VGND VPWR VPWR sky130_fd_sc_hd__decap_3
XTAP_TAPCELL_ROW_28_939 VGND VPWR sky130_fd_sc_hd__tapvpwrvgnd_1
XFILLER_38_782 VGND VGND VPWR VPWR sky130_fd_sc_hd__decap_3
XFILLER_77_1121 VGND VGND VPWR VPWR sky130_fd_sc_hd__decap_3
X_4019_ _4123_/B2 _4016_/X _4017_/Y _4018_/X _4382_/C1 VGND VGND VPWR VPWR _4019_/X
+ sky130_fd_sc_hd__o221a_2
XFILLER_37_281 VGND VGND VPWR VPWR sky130_fd_sc_hd__decap_3
XFILLER_53_741 VGND VGND VPWR VPWR sky130_fd_sc_hd__decap_3
XFILLER_77_1154 VGND VGND VPWR VPWR sky130_fd_sc_hd__decap_3
XFILLER_0_1450 VGND VGND VPWR VPWR sky130_fd_sc_hd__decap_3
XTAP_TAPCELL_ROW_49_1464 VGND VPWR sky130_fd_sc_hd__tapvpwrvgnd_1
XFILLER_16_56 VGND VGND VPWR VPWR sky130_fd_sc_hd__decap_3
XTAP_TAPCELL_ROW_49_1475 VGND VPWR sky130_fd_sc_hd__tapvpwrvgnd_1
XTAP_TAPCELL_ROW_49_1486 VGND VPWR sky130_fd_sc_hd__tapvpwrvgnd_1
XPHY_EDGE_ROW_0_Right_0 VGND VGND VPWR VPWR sky130_fd_sc_hd__decap_3
XFILLER_52_262 VGND VGND VPWR VPWR sky130_fd_sc_hd__decap_3
XFILLER_77_1198 VGND VGND VPWR VPWR sky130_fd_sc_hd__decap_3
XFILLER_25_498 VGND VGND VPWR VPWR sky130_fd_sc_hd__decap_3
XFILLER_13_649 VGND VGND VPWR VPWR sky130_fd_sc_hd__decap_3
XFILLER_40_424 VGND VGND VPWR VPWR sky130_fd_sc_hd__fill_2
XFILLER_16_1403 VGND VGND VPWR VPWR sky130_fd_sc_hd__decap_3
XFILLER_55_1452 VGND VGND VPWR VPWR sky130_fd_sc_hd__decap_3
XFILLER_12_137 VGND VGND VPWR VPWR sky130_fd_sc_hd__decap_3
XFILLER_9_609 VGND VGND VPWR VPWR sky130_fd_sc_hd__decap_3
XFILLER_55_1463 VGND VGND VPWR VPWR sky130_fd_sc_hd__decap_3
XFILLER_51_1316 VGND VGND VPWR VPWR sky130_fd_sc_hd__decap_3
XFILLER_16_1447 VGND VGND VPWR VPWR sky130_fd_sc_hd__decap_3
XFILLER_21_682 VGND VGND VPWR VPWR sky130_fd_sc_hd__decap_3
XFILLER_32_88 VGND VGND VPWR VPWR sky130_fd_sc_hd__decap_3
XFILLER_49_1201 VGND VGND VPWR VPWR sky130_fd_sc_hd__decap_3
XFILLER_10_1035 VGND VGND VPWR VPWR sky130_fd_sc_hd__fill_1
XFILLER_49_1245 VGND VGND VPWR VPWR sky130_fd_sc_hd__decap_3
XFILLER_49_1278 VGND VGND VPWR VPWR sky130_fd_sc_hd__decap_3
XFILLER_49_1289 VGND VGND VPWR VPWR sky130_fd_sc_hd__decap_3
XFILLER_0_520 VGND VGND VPWR VPWR sky130_fd_sc_hd__decap_3
XFILLER_62_1412 VGND VGND VPWR VPWR sky130_fd_sc_hd__decap_3
XFILLER_0_542 VGND VGND VPWR VPWR sky130_fd_sc_hd__decap_3
XFILLER_0_564 VGND VGND VPWR VPWR sky130_fd_sc_hd__decap_3
XFILLER_48_502 VGND VGND VPWR VPWR sky130_fd_sc_hd__decap_3
XFILLER_23_1407 VGND VGND VPWR VPWR sky130_fd_sc_hd__decap_3
XFILLER_62_1456 VGND VGND VPWR VPWR sky130_fd_sc_hd__decap_3
XFILLER_76_833 VGND VGND VPWR VPWR sky130_fd_sc_hd__decap_3
XFILLER_76_866 VGND VGND VPWR VPWR sky130_fd_sc_hd__fill_2
XFILLER_17_900 VGND VGND VPWR VPWR sky130_fd_sc_hd__decap_3
XFILLER_29_760 VGND VGND VPWR VPWR sky130_fd_sc_hd__fill_2
XFILLER_63_505 VGND VGND VPWR VPWR sky130_fd_sc_hd__decap_3
XFILLER_5_1372 VGND VGND VPWR VPWR sky130_fd_sc_hd__decap_3
XFILLER_1_1225 VGND VGND VPWR VPWR sky130_fd_sc_hd__decap_3
XFILLER_29_782 VGND VGND VPWR VPWR sky130_fd_sc_hd__fill_2
XFILLER_1_1236 VGND VGND VPWR VPWR sky130_fd_sc_hd__decap_3
XFILLER_16_421 VGND VGND VPWR VPWR sky130_fd_sc_hd__decap_3
XFILLER_17_944 VGND VGND VPWR VPWR sky130_fd_sc_hd__decap_3
XFILLER_73_51 VGND VGND VPWR VPWR sky130_fd_sc_hd__decap_3
XFILLER_1_1269 VGND VGND VPWR VPWR sky130_fd_sc_hd__decap_3
XFILLER_17_977 VGND VGND VPWR VPWR sky130_fd_sc_hd__decap_3
XFILLER_43_251 VGND VGND VPWR VPWR sky130_fd_sc_hd__fill_1
XFILLER_31_402 VGND VGND VPWR VPWR sky130_fd_sc_hd__decap_3
XFILLER_32_925 VGND VGND VPWR VPWR sky130_fd_sc_hd__decap_3
XFILLER_44_785 VGND VGND VPWR VPWR sky130_fd_sc_hd__decap_3
XFILLER_56_1238 VGND VGND VPWR VPWR sky130_fd_sc_hd__decap_3
XFILLER_43_284 VGND VGND VPWR VPWR sky130_fd_sc_hd__decap_3
XFILLER_31_446 VGND VGND VPWR VPWR sky130_fd_sc_hd__fill_2
XFILLER_32_969 VGND VGND VPWR VPWR sky130_fd_sc_hd__decap_3
XFILLER_19_1060 VGND VGND VPWR VPWR sky130_fd_sc_hd__decap_3
XFILLER_12_660 VGND VGND VPWR VPWR sky130_fd_sc_hd__decap_3
XFILLER_78_6 VGND VGND VPWR VPWR sky130_fd_sc_hd__decap_3
XFILLER_8_664 VGND VGND VPWR VPWR sky130_fd_sc_hd__decap_3
XFILLER_7_152 VGND VGND VPWR VPWR sky130_fd_sc_hd__decap_3
XFILLER_32_1282 VGND VGND VPWR VPWR sky130_fd_sc_hd__decap_3
XFILLER_67_1301 VGND VGND VPWR VPWR sky130_fd_sc_hd__decap_3
XFILLER_7_196 VGND VGND VPWR VPWR sky130_fd_sc_hd__decap_3
X_4370_ _4403_/A _4369_/X _4360_/X _6505_/Q VGND VGND VPWR VPWR _4370_/X sky130_fd_sc_hd__a2bb2o_2
XFILLER_67_1334 VGND VGND VPWR VPWR sky130_fd_sc_hd__decap_3
XFILLER_67_1345 VGND VGND VPWR VPWR sky130_fd_sc_hd__decap_3
X_3321_ _5981_/A0 _3320_/X _3401_/S VGND VGND VPWR VPWR _6134_/D sky130_fd_sc_hd__mux2_1
XFILLER_63_1209 VGND VGND VPWR VPWR sky130_fd_sc_hd__decap_3
XFILLER_28_1329 VGND VGND VPWR VPWR sky130_fd_sc_hd__decap_3
XFILLER_67_1378 VGND VGND VPWR VPWR sky130_fd_sc_hd__decap_3
X_6040_ hold999/X _6040_/A1 _6048_/S VGND VGND VPWR VPWR _7044_/D sky130_fd_sc_hd__mux2_1
X_3252_ _6261_/Q _6357_/Q VGND VGND VPWR VPWR _3252_/X sky130_fd_sc_hd__xor2_2
XFILLER_39_502 VGND VGND VPWR VPWR sky130_fd_sc_hd__fill_2
XFILLER_6_1114 VGND VGND VPWR VPWR sky130_fd_sc_hd__decap_3
X_3183_ _6983_/Q _6991_/Q _3191_/S VGND VGND VPWR VPWR _3183_/X sky130_fd_sc_hd__mux2_1
XFILLER_67_844 VGND VGND VPWR VPWR sky130_fd_sc_hd__decap_3
XFILLER_6_1147 VGND VGND VPWR VPWR sky130_fd_sc_hd__fill_1
XFILLER_6_1158 VGND VGND VPWR VPWR sky130_fd_sc_hd__decap_3
XFILLER_66_354 VGND VGND VPWR VPWR sky130_fd_sc_hd__decap_3
XFILLER_27_719 VGND VGND VPWR VPWR sky130_fd_sc_hd__decap_3
XFILLER_39_579 VGND VGND VPWR VPWR sky130_fd_sc_hd__decap_3
XFILLER_67_888 VGND VGND VPWR VPWR sky130_fd_sc_hd__decap_3
XFILLER_66_376 VGND VGND VPWR VPWR sky130_fd_sc_hd__decap_3
XFILLER_78_1441 VGND VGND VPWR VPWR sky130_fd_sc_hd__decap_3
X_6942_ _7025_/CLK _6942_/D wire764/X VGND VGND VPWR VPWR _6942_/Q sky130_fd_sc_hd__dfrtp_2
XFILLER_19_281 VGND VGND VPWR VPWR sky130_fd_sc_hd__fill_2
XFILLER_39_1425 VGND VGND VPWR VPWR sky130_fd_sc_hd__decap_3
XFILLER_23_914 VGND VGND VPWR VPWR sky130_fd_sc_hd__fill_2
X_6873_ _7065_/CLK _6873_/D fanout739/X VGND VGND VPWR VPWR _6873_/Q sky130_fd_sc_hd__dfrtp_2
XFILLER_74_1338 VGND VGND VPWR VPWR sky130_fd_sc_hd__decap_3
XFILLER_34_262 VGND VGND VPWR VPWR sky130_fd_sc_hd__fill_2
XFILLER_35_785 VGND VGND VPWR VPWR sky130_fd_sc_hd__decap_3
XFILLER_22_413 VGND VGND VPWR VPWR sky130_fd_sc_hd__decap_3
X_5824_ _5784_/C _5824_/A1 _5831_/S VGND VGND VPWR VPWR _6842_/D sky130_fd_sc_hd__mux2_1
XFILLER_50_755 VGND VGND VPWR VPWR sky130_fd_sc_hd__fill_1
XFILLER_22_457 VGND VGND VPWR VPWR sky130_fd_sc_hd__decap_3
XFILLER_10_608 VGND VGND VPWR VPWR sky130_fd_sc_hd__fill_2
XTAP_TAPCELL_ROW_44_1350 VGND VPWR sky130_fd_sc_hd__tapvpwrvgnd_1
X_5755_ _5797_/C _5755_/A1 _5757_/S VGND VGND VPWR VPWR _6799_/D sky130_fd_sc_hd__mux2_1
XFILLER_50_788 VGND VGND VPWR VPWR sky130_fd_sc_hd__decap_3
X_4706_ _6293_/Q _4882_/A2 _3396_/X _4882_/B2 VGND VGND VPWR VPWR _4706_/X sky130_fd_sc_hd__a22o_2
XTAP_TAPCELL_ROW_40_1236 VGND VPWR sky130_fd_sc_hd__tapvpwrvgnd_1
X_5686_ _5686_/A0 _5889_/A0 _5693_/S VGND VGND VPWR VPWR _6738_/D sky130_fd_sc_hd__mux2_1
XTAP_TAPCELL_ROW_40_1247 VGND VPWR sky130_fd_sc_hd__tapvpwrvgnd_1
XFILLER_11_1322 VGND VGND VPWR VPWR sky130_fd_sc_hd__decap_3
X_4637_ _4312_/B _6548_/Q _4658_/S VGND VGND VPWR VPWR _4637_/X sky130_fd_sc_hd__mux2_1
XFILLER_50_1371 VGND VGND VPWR VPWR sky130_fd_sc_hd__fill_1
XFILLER_50_1382 VGND VGND VPWR VPWR sky130_fd_sc_hd__decap_3
XFILLER_11_1366 VGND VGND VPWR VPWR sky130_fd_sc_hd__decap_3
X_4568_ _6876_/Q _4744_/A2 _4744_/B1 _4567_/X VGND VGND VPWR VPWR _4568_/X sky130_fd_sc_hd__a211o_2
XFILLER_78_18 VGND VGND VPWR VPWR sky130_fd_sc_hd__decap_3
XTAP_TAPCELL_ROW_9_428 VGND VPWR sky130_fd_sc_hd__tapvpwrvgnd_1
XFILLER_78_29 VGND VGND VPWR VPWR sky130_fd_sc_hd__decap_3
XTAP_TAPCELL_ROW_9_439 VGND VPWR sky130_fd_sc_hd__tapvpwrvgnd_1
XFILLER_11_1399 VGND VGND VPWR VPWR sky130_fd_sc_hd__fill_1
XFILLER_1_317 VGND VGND VPWR VPWR sky130_fd_sc_hd__decap_3
X_6307_ clkload9/A _6307_/D fanout656/X VGND VGND VPWR VPWR _6307_/Q sky130_fd_sc_hd__dfrtp_2
X_3519_ _6622_/Q wire431/X _3518_/X VGND VGND VPWR VPWR _3519_/Y sky130_fd_sc_hd__a21oi_2
XFILLER_46_1418 VGND VGND VPWR VPWR sky130_fd_sc_hd__decap_3
XFILLER_46_1429 VGND VGND VPWR VPWR sky130_fd_sc_hd__decap_3
X_4499_ _6265_/Q _4861_/A2 _3324_/X _4854_/B2 VGND VGND VPWR VPWR _4499_/X sky130_fd_sc_hd__a22o_2
XTAP_TAPCELL_ROW_38_1176 VGND VPWR sky130_fd_sc_hd__tapvpwrvgnd_1
XTAP_TAPCELL_ROW_38_1187 VGND VPWR sky130_fd_sc_hd__tapvpwrvgnd_1
X_6238_ _7064_/CLK _6238_/D load_slew720/X VGND VGND VPWR VPWR _6238_/Q sky130_fd_sc_hd__dfrtp_2
XTAP_TAPCELL_ROW_38_1198 VGND VPWR sky130_fd_sc_hd__tapvpwrvgnd_1
XFILLER_44_1142 VGND VGND VPWR VPWR sky130_fd_sc_hd__decap_3
XFILLER_58_822 VGND VGND VPWR VPWR sky130_fd_sc_hd__decap_3
XFILLER_76_129 VGND VGND VPWR VPWR sky130_fd_sc_hd__decap_3
X_6169_ _7052_/CLK _6169_/D load_slew808/X VGND VGND VPWR VPWR _6169_/Q sky130_fd_sc_hd__dfrtp_2
Xhold1320 _6906_/Q VGND VGND VPWR VPWR _5898_/A1 sky130_fd_sc_hd__dlygate4sd3_1
Xhold1331 _6756_/Q VGND VGND VPWR VPWR _5707_/A1 sky130_fd_sc_hd__dlygate4sd3_1
XFILLER_40_1017 VGND VGND VPWR VPWR sky130_fd_sc_hd__decap_3
XFILLER_57_343 VGND VGND VPWR VPWR sky130_fd_sc_hd__decap_3
Xhold1342 _6856_/Q VGND VGND VPWR VPWR _5839_/A1 sky130_fd_sc_hd__dlygate4sd3_1
XFILLER_79_1216 VGND VGND VPWR VPWR sky130_fd_sc_hd__decap_3
XFILLER_73_814 VGND VGND VPWR VPWR sky130_fd_sc_hd__decap_3
Xhold1353 _6829_/Q VGND VGND VPWR VPWR _5809_/A1 sky130_fd_sc_hd__dlygate4sd3_1
XFILLER_45_505 VGND VGND VPWR VPWR sky130_fd_sc_hd__decap_3
Xhold1364 _6701_/Q VGND VGND VPWR VPWR _5644_/A1 sky130_fd_sc_hd__dlygate4sd3_1
Xhold1375 _6477_/Q VGND VGND VPWR VPWR _5365_/A1 sky130_fd_sc_hd__dlygate4sd3_1
Xhold1386 _6527_/Q VGND VGND VPWR VPWR _5415_/A1 sky130_fd_sc_hd__dlygate4sd3_1
XFILLER_22_1462 VGND VGND VPWR VPWR sky130_fd_sc_hd__decap_3
XFILLER_45_538 VGND VGND VPWR VPWR sky130_fd_sc_hd__fill_1
Xhold1397 _6483_/Q VGND VGND VPWR VPWR _5371_/A1 sky130_fd_sc_hd__dlygate4sd3_1
XFILLER_27_66 VGND VGND VPWR VPWR sky130_fd_sc_hd__decap_3
XFILLER_73_869 VGND VGND VPWR VPWR sky130_fd_sc_hd__decap_3
XFILLER_72_368 VGND VGND VPWR VPWR sky130_fd_sc_hd__fill_1
XFILLER_60_508 VGND VGND VPWR VPWR sky130_fd_sc_hd__decap_3
XFILLER_14_925 VGND VGND VPWR VPWR sky130_fd_sc_hd__decap_3
XFILLER_43_21 VGND VGND VPWR VPWR sky130_fd_sc_hd__decap_3
XFILLER_14_969 VGND VGND VPWR VPWR sky130_fd_sc_hd__decap_3
XFILLER_25_295 VGND VGND VPWR VPWR sky130_fd_sc_hd__decap_3
XFILLER_13_468 VGND VGND VPWR VPWR sky130_fd_sc_hd__decap_3
XFILLER_9_417 VGND VGND VPWR VPWR sky130_fd_sc_hd__decap_3
XFILLER_16_1211 VGND VGND VPWR VPWR sky130_fd_sc_hd__decap_3
XFILLER_41_777 VGND VGND VPWR VPWR sky130_fd_sc_hd__decap_3
XFILLER_55_1260 VGND VGND VPWR VPWR sky130_fd_sc_hd__decap_3
XFILLER_16_1244 VGND VGND VPWR VPWR sky130_fd_sc_hd__decap_3
XFILLER_21_490 VGND VGND VPWR VPWR sky130_fd_sc_hd__decap_3
Xclkbuf_leaf_20_clk clkbuf_4_4__f_clk/X VGND VGND VPWR VPWR _7076_/CLK sky130_fd_sc_hd__clkbuf_8
XFILLER_16_1288 VGND VGND VPWR VPWR sky130_fd_sc_hd__decap_3
XFILLER_5_623 VGND VGND VPWR VPWR sky130_fd_sc_hd__decap_3
XFILLER_4_100 VGND VGND VPWR VPWR sky130_fd_sc_hd__decap_3
XFILLER_5_645 VGND VGND VPWR VPWR sky130_fd_sc_hd__decap_3
XFILLER_4_122 VGND VGND VPWR VPWR sky130_fd_sc_hd__decap_3
XFILLER_4_144 VGND VGND VPWR VPWR sky130_fd_sc_hd__fill_2
XFILLER_4_15 VGND VGND VPWR VPWR sky130_fd_sc_hd__decap_3
XFILLER_4_59 VGND VGND VPWR VPWR sky130_fd_sc_hd__decap_3
XFILLER_7_1401 VGND VGND VPWR VPWR sky130_fd_sc_hd__decap_3
XFILLER_1_862 VGND VGND VPWR VPWR sky130_fd_sc_hd__decap_3
XFILLER_27_1340 VGND VGND VPWR VPWR sky130_fd_sc_hd__decap_3
XFILLER_62_1220 VGND VGND VPWR VPWR sky130_fd_sc_hd__decap_3
XFILLER_68_62 VGND VGND VPWR VPWR sky130_fd_sc_hd__decap_3
XFILLER_27_1351 VGND VGND VPWR VPWR sky130_fd_sc_hd__decap_3
XFILLER_0_361 VGND VGND VPWR VPWR sky130_fd_sc_hd__decap_3
XFILLER_7_1434 VGND VGND VPWR VPWR sky130_fd_sc_hd__decap_3
XFILLER_1_895 VGND VGND VPWR VPWR sky130_fd_sc_hd__fill_1
XFILLER_49_833 VGND VGND VPWR VPWR sky130_fd_sc_hd__decap_3
XFILLER_62_1253 VGND VGND VPWR VPWR sky130_fd_sc_hd__decap_3
XFILLER_0_383 VGND VGND VPWR VPWR sky130_fd_sc_hd__decap_3
XFILLER_27_1384 VGND VGND VPWR VPWR sky130_fd_sc_hd__decap_3
XFILLER_62_1264 VGND VGND VPWR VPWR sky130_fd_sc_hd__decap_3
XFILLER_76_641 VGND VGND VPWR VPWR sky130_fd_sc_hd__decap_3
XFILLER_23_1248 VGND VGND VPWR VPWR sky130_fd_sc_hd__decap_3
XFILLER_62_1297 VGND VGND VPWR VPWR sky130_fd_sc_hd__decap_3
XFILLER_48_365 VGND VGND VPWR VPWR sky130_fd_sc_hd__decap_3
XTAP_TAPCELL_ROW_19_703 VGND VPWR sky130_fd_sc_hd__tapvpwrvgnd_1
XFILLER_64_836 VGND VGND VPWR VPWR sky130_fd_sc_hd__decap_3
XFILLER_5_1180 VGND VGND VPWR VPWR sky130_fd_sc_hd__decap_3
XFILLER_1_1033 VGND VGND VPWR VPWR sky130_fd_sc_hd__decap_3
XFILLER_17_741 VGND VGND VPWR VPWR sky130_fd_sc_hd__decap_3
XFILLER_17_752 VGND VGND VPWR VPWR sky130_fd_sc_hd__decap_3
XFILLER_51_519 VGND VGND VPWR VPWR sky130_fd_sc_hd__fill_2
XFILLER_1_1077 VGND VGND VPWR VPWR sky130_fd_sc_hd__decap_3
XFILLER_17_785 VGND VGND VPWR VPWR sky130_fd_sc_hd__fill_1
XPHY_EDGE_ROW_9_Left_90 VGND VGND VPWR VPWR sky130_fd_sc_hd__decap_3
XFILLER_16_262 VGND VGND VPWR VPWR sky130_fd_sc_hd__decap_3
XFILLER_44_571 VGND VGND VPWR VPWR sky130_fd_sc_hd__decap_3
XFILLER_56_1024 VGND VGND VPWR VPWR sky130_fd_sc_hd__decap_3
X_3870_ _6284_/Q _4010_/B _3902_/B1 _6260_/Q _3902_/C1 VGND VGND VPWR VPWR _3870_/X
+ sky130_fd_sc_hd__a221o_2
XFILLER_32_755 VGND VGND VPWR VPWR sky130_fd_sc_hd__fill_1
XTAP_TAPCELL_ROW_80_2273 VGND VPWR sky130_fd_sc_hd__tapvpwrvgnd_1
XTAP_TAPCELL_ROW_80_2284 VGND VPWR sky130_fd_sc_hd__tapvpwrvgnd_1
XFILLER_34_1300 VGND VGND VPWR VPWR sky130_fd_sc_hd__decap_3
XFILLER_56_1079 VGND VGND VPWR VPWR sky130_fd_sc_hd__decap_3
XTAP_TAPCELL_ROW_80_2295 VGND VPWR sky130_fd_sc_hd__tapvpwrvgnd_1
XFILLER_73_1360 VGND VGND VPWR VPWR sky130_fd_sc_hd__decap_3
XFILLER_73_1393 VGND VGND VPWR VPWR sky130_fd_sc_hd__decap_3
XFILLER_9_940 VGND VGND VPWR VPWR sky130_fd_sc_hd__decap_3
XFILLER_31_287 VGND VGND VPWR VPWR sky130_fd_sc_hd__decap_3
XFILLER_34_1344 VGND VGND VPWR VPWR sky130_fd_sc_hd__decap_3
X_5540_ _6373_/Q _5564_/A2 _5540_/B1 _5564_/B2 VGND VGND VPWR VPWR _6623_/D sky130_fd_sc_hd__a22o_2
XFILLER_76_3 VGND VGND VPWR VPWR sky130_fd_sc_hd__decap_3
Xclkbuf_leaf_11_clk clkbuf_4_6__f_clk/X VGND VGND VPWR VPWR _6912_/CLK sky130_fd_sc_hd__clkbuf_8
XFILLER_34_1388 VGND VGND VPWR VPWR sky130_fd_sc_hd__decap_3
XTAP_TAPCELL_ROW_30_978 VGND VPWR sky130_fd_sc_hd__tapvpwrvgnd_1
XFILLER_69_1407 VGND VGND VPWR VPWR sky130_fd_sc_hd__decap_3
XTAP_TAPCELL_ROW_30_989 VGND VPWR sky130_fd_sc_hd__tapvpwrvgnd_1
X_5471_ _5471_/A1 _5479_/A2 _4838_/X VGND VGND VPWR VPWR _6583_/D sky130_fd_sc_hd__a21o_2
XFILLER_32_1090 VGND VGND VPWR VPWR sky130_fd_sc_hd__fill_2
X_4422_ _4422_/A _4777_/B VGND VGND VPWR VPWR _4422_/Y sky130_fd_sc_hd__nor2_2
X_4353_ _6833_/Q _4898_/A2 _4606_/B1 _4352_/X VGND VGND VPWR VPWR _4353_/X sky130_fd_sc_hd__a211o_2
XFILLER_28_1126 VGND VGND VPWR VPWR sky130_fd_sc_hd__decap_3
XFILLER_67_1175 VGND VGND VPWR VPWR sky130_fd_sc_hd__fill_1
Xfanout407 _4604_/A VGND VGND VPWR VPWR _4853_/C1 sky130_fd_sc_hd__clkdlybuf4s25_1
XFILLER_67_1186 VGND VGND VPWR VPWR sky130_fd_sc_hd__decap_3
X_3304_ _6279_/Q _6383_/Q VGND VGND VPWR VPWR _3304_/X sky130_fd_sc_hd__xor2_2
Xfanout418 _3107_/X VGND VGND VPWR VPWR _3219_/B2 sky130_fd_sc_hd__clkdlybuf4s25_1
X_7072_ _7072_/CLK _7072_/D wire687/X VGND VGND VPWR VPWR _7072_/Q sky130_fd_sc_hd__dfrtp_2
X_4284_ _6489_/Q _4330_/A2 _4881_/A _4283_/Y VGND VGND VPWR VPWR _4284_/X sky130_fd_sc_hd__o211a_2
Xfanout429 wire431/X VGND VGND VPWR VPWR _5591_/A2 sky130_fd_sc_hd__clkdlybuf4s25_1
XFILLER_80_1320 VGND VGND VPWR VPWR sky130_fd_sc_hd__decap_3
XFILLER_45_1440 VGND VGND VPWR VPWR sky130_fd_sc_hd__decap_3
X_6023_ _6023_/A0 _6023_/A1 _6031_/S VGND VGND VPWR VPWR _7027_/D sky130_fd_sc_hd__mux2_1
XFILLER_41_1304 VGND VGND VPWR VPWR sky130_fd_sc_hd__decap_3
X_3235_ _5938_/A0 _3234_/X _3385_/S VGND VGND VPWR VPWR _6091_/D sky130_fd_sc_hd__mux2_1
Xclkbuf_leaf_78_clk clkload1/A VGND VGND VPWR VPWR _6993_/CLK sky130_fd_sc_hd__clkbuf_8
XTAP_TAPCELL_ROW_33_1051 VGND VPWR sky130_fd_sc_hd__tapvpwrvgnd_1
XTAP_TAPCELL_ROW_33_1062 VGND VPWR sky130_fd_sc_hd__tapvpwrvgnd_1
XFILLER_41_1337 VGND VGND VPWR VPWR sky130_fd_sc_hd__decap_3
XFILLER_80_1397 VGND VGND VPWR VPWR sky130_fd_sc_hd__decap_3
XFILLER_41_1348 VGND VGND VPWR VPWR sky130_fd_sc_hd__decap_3
XFILLER_27_505 VGND VGND VPWR VPWR sky130_fd_sc_hd__decap_3
XFILLER_39_365 VGND VGND VPWR VPWR sky130_fd_sc_hd__decap_3
X_3166_ _6076_/A1 _3164_/X _3165_/X _3205_/B1 VGND VGND VPWR VPWR _3166_/X sky130_fd_sc_hd__a211o_2
XFILLER_55_858 VGND VGND VPWR VPWR sky130_fd_sc_hd__decap_3
XFILLER_66_195 VGND VGND VPWR VPWR sky130_fd_sc_hd__fill_1
X_3097_ _3097_/A _3097_/B VGND VGND VPWR VPWR _7084_/D sky130_fd_sc_hd__or2_2
XTAP_TAPCELL_ROW_46_1401 VGND VPWR sky130_fd_sc_hd__tapvpwrvgnd_1
XFILLER_74_1102 VGND VGND VPWR VPWR sky130_fd_sc_hd__decap_3
X_6925_ _6925_/CLK _6925_/D fanout656/X VGND VGND VPWR VPWR _6925_/Q sky130_fd_sc_hd__dfrtp_2
XFILLER_78_1282 VGND VGND VPWR VPWR sky130_fd_sc_hd__decap_3
XFILLER_39_1233 VGND VGND VPWR VPWR sky130_fd_sc_hd__decap_3
XFILLER_63_891 VGND VGND VPWR VPWR sky130_fd_sc_hd__decap_3
XFILLER_74_1135 VGND VGND VPWR VPWR sky130_fd_sc_hd__decap_3
XFILLER_39_1266 VGND VGND VPWR VPWR sky130_fd_sc_hd__decap_3
X_6856_ _6925_/CLK _6856_/D fanout656/X VGND VGND VPWR VPWR _6856_/Q sky130_fd_sc_hd__dfrtp_2
XFILLER_50_530 VGND VGND VPWR VPWR sky130_fd_sc_hd__fill_2
XFILLER_62_390 VGND VGND VPWR VPWR sky130_fd_sc_hd__decap_3
XFILLER_22_232 VGND VGND VPWR VPWR sky130_fd_sc_hd__decap_3
Xfanout47 _4107_/X VGND VGND VPWR VPWR fanout47/X sky130_fd_sc_hd__clkdlybuf4s25_1
XFILLER_74_1179 VGND VGND VPWR VPWR sky130_fd_sc_hd__decap_3
XFILLER_52_1400 VGND VGND VPWR VPWR sky130_fd_sc_hd__decap_3
XFILLER_23_788 VGND VGND VPWR VPWR sky130_fd_sc_hd__decap_3
X_5807_ _5917_/A1 _5807_/A1 _5813_/S VGND VGND VPWR VPWR _6827_/D sky130_fd_sc_hd__mux2_1
XFILLER_13_24 VGND VGND VPWR VPWR sky130_fd_sc_hd__decap_3
X_6787_ _7051_/CLK _6787_/D fanout816/X VGND VGND VPWR VPWR _6787_/Q sky130_fd_sc_hd__dfrtp_2
X_3999_ _4097_/A1 _3996_/X _3997_/Y _3998_/X _4013_/A VGND VGND VPWR VPWR _3999_/X
+ sky130_fd_sc_hd__o221a_2
XFILLER_10_427 VGND VGND VPWR VPWR sky130_fd_sc_hd__decap_3
XFILLER_52_1444 VGND VGND VPWR VPWR sky130_fd_sc_hd__decap_3
XFILLER_13_57 VGND VGND VPWR VPWR sky130_fd_sc_hd__fill_2
X_5738_ _5931_/A0 _5738_/A1 _5738_/S VGND VGND VPWR VPWR _6784_/D sky130_fd_sc_hd__mux2_1
XFILLER_13_1428 VGND VGND VPWR VPWR sky130_fd_sc_hd__decap_3
X_5669_ hold876/X _5917_/A1 _5675_/S VGND VGND VPWR VPWR _6723_/D sky130_fd_sc_hd__mux2_1
XFILLER_11_1174 VGND VGND VPWR VPWR sky130_fd_sc_hd__fill_2
XFILLER_8_6 VGND VGND VPWR VPWR sky130_fd_sc_hd__decap_3
XFILLER_1_125 VGND VGND VPWR VPWR sky130_fd_sc_hd__decap_3
XFILLER_2_648 VGND VGND VPWR VPWR sky130_fd_sc_hd__decap_3
XFILLER_78_906 VGND VGND VPWR VPWR sky130_fd_sc_hd__decap_3
XFILLER_77_405 VGND VGND VPWR VPWR sky130_fd_sc_hd__decap_3
XFILLER_1_158 VGND VGND VPWR VPWR sky130_fd_sc_hd__decap_3
XFILLER_1_169 VGND VGND VPWR VPWR sky130_fd_sc_hd__decap_3
XFILLER_46_1259 VGND VGND VPWR VPWR sky130_fd_sc_hd__fill_1
XFILLER_77_449 VGND VGND VPWR VPWR sky130_fd_sc_hd__decap_3
Xclkbuf_leaf_69_clk clkbuf_4_8__f_clk/X VGND VGND VPWR VPWR _6863_/CLK sky130_fd_sc_hd__clkbuf_8
XFILLER_73_600 VGND VGND VPWR VPWR sky130_fd_sc_hd__decap_3
XFILLER_46_825 VGND VGND VPWR VPWR sky130_fd_sc_hd__decap_3
Xhold1150 _7039_/Q VGND VGND VPWR VPWR _6035_/A1 sky130_fd_sc_hd__dlygate4sd3_1
Xhold1161 _7028_/Q VGND VGND VPWR VPWR _6024_/A1 sky130_fd_sc_hd__dlygate4sd3_1
XFILLER_2_1320 VGND VGND VPWR VPWR sky130_fd_sc_hd__decap_3
Xhold1172 _6812_/Q VGND VGND VPWR VPWR _5777_/A0 sky130_fd_sc_hd__dlygate4sd3_1
Xhold1183 _6871_/Q VGND VGND VPWR VPWR _5856_/A0 sky130_fd_sc_hd__dlygate4sd3_1
XFILLER_22_1270 VGND VGND VPWR VPWR sky130_fd_sc_hd__decap_3
XFILLER_46_869 VGND VGND VPWR VPWR sky130_fd_sc_hd__decap_3
Xhold1194 _6837_/Q VGND VGND VPWR VPWR _5818_/A0 sky130_fd_sc_hd__dlygate4sd3_1
XFILLER_2_1353 VGND VGND VPWR VPWR sky130_fd_sc_hd__decap_3
XFILLER_45_357 VGND VGND VPWR VPWR sky130_fd_sc_hd__decap_3
XFILLER_79_1079 VGND VGND VPWR VPWR sky130_fd_sc_hd__decap_3
XFILLER_33_508 VGND VGND VPWR VPWR sky130_fd_sc_hd__decap_3
XFILLER_72_165 VGND VGND VPWR VPWR sky130_fd_sc_hd__fill_2
XFILLER_57_1322 VGND VGND VPWR VPWR sky130_fd_sc_hd__decap_3
XFILLER_2_1397 VGND VGND VPWR VPWR sky130_fd_sc_hd__decap_3
XFILLER_26_582 VGND VGND VPWR VPWR sky130_fd_sc_hd__decap_3
XTAP_TAPCELL_ROW_0_180 VGND VPWR sky130_fd_sc_hd__tapvpwrvgnd_1
XFILLER_13_210 VGND VGND VPWR VPWR sky130_fd_sc_hd__decap_3
XTAP_TAPCELL_ROW_0_191 VGND VPWR sky130_fd_sc_hd__tapvpwrvgnd_1
XFILLER_18_1306 VGND VGND VPWR VPWR sky130_fd_sc_hd__decap_3
XFILLER_18_1317 VGND VGND VPWR VPWR sky130_fd_sc_hd__decap_3
XFILLER_41_530 VGND VGND VPWR VPWR sky130_fd_sc_hd__decap_3
XFILLER_57_1366 VGND VGND VPWR VPWR sky130_fd_sc_hd__decap_3
XFILLER_57_1399 VGND VGND VPWR VPWR sky130_fd_sc_hd__fill_1
XFILLER_13_276 VGND VGND VPWR VPWR sky130_fd_sc_hd__decap_3
XFILLER_9_225 VGND VGND VPWR VPWR sky130_fd_sc_hd__decap_3
XFILLER_41_596 VGND VGND VPWR VPWR sky130_fd_sc_hd__fill_2
XFILLER_70_41 VGND VGND VPWR VPWR sky130_fd_sc_hd__decap_3
Xclkload17 _6865_/CLK VGND VGND VPWR VPWR clkload17/Y sky130_fd_sc_hd__clkinv_4
Xclkload28 _7095_/CLK VGND VGND VPWR VPWR clkload28/X sky130_fd_sc_hd__clkbuf_4
XTAP_TAPCELL_ROW_11_477 VGND VPWR sky130_fd_sc_hd__tapvpwrvgnd_1
XTAP_TAPCELL_ROW_11_488 VGND VPWR sky130_fd_sc_hd__tapvpwrvgnd_1
XFILLER_5_420 VGND VGND VPWR VPWR sky130_fd_sc_hd__decap_3
Xclkload39 _6959_/CLK VGND VGND VPWR VPWR clkload39/X sky130_fd_sc_hd__clkbuf_8
XTAP_TAPCELL_ROW_11_499 VGND VPWR sky130_fd_sc_hd__tapvpwrvgnd_1
XFILLER_6_965 VGND VGND VPWR VPWR sky130_fd_sc_hd__decap_3
XFILLER_5_464 VGND VGND VPWR VPWR sky130_fd_sc_hd__decap_3
XFILLER_29_1413 VGND VGND VPWR VPWR sky130_fd_sc_hd__decap_3
XFILLER_68_1462 VGND VGND VPWR VPWR sky130_fd_sc_hd__decap_3
XFILLER_79_72 VGND VGND VPWR VPWR sky130_fd_sc_hd__decap_3
XFILLER_64_1315 VGND VGND VPWR VPWR sky130_fd_sc_hd__fill_1
XFILLER_29_1446 VGND VGND VPWR VPWR sky130_fd_sc_hd__decap_3
XFILLER_64_1326 VGND VGND VPWR VPWR sky130_fd_sc_hd__decap_3
XFILLER_29_1457 VGND VGND VPWR VPWR sky130_fd_sc_hd__decap_3
XFILLER_64_1359 VGND VGND VPWR VPWR sky130_fd_sc_hd__decap_3
XFILLER_7_1231 VGND VGND VPWR VPWR sky130_fd_sc_hd__fill_1
XFILLER_7_1242 VGND VGND VPWR VPWR sky130_fd_sc_hd__decap_3
XFILLER_23_1012 VGND VGND VPWR VPWR sky130_fd_sc_hd__decap_3
XFILLER_77_972 VGND VGND VPWR VPWR sky130_fd_sc_hd__decap_3
XFILLER_7_1275 VGND VGND VPWR VPWR sky130_fd_sc_hd__decap_3
XFILLER_62_1083 VGND VGND VPWR VPWR sky130_fd_sc_hd__decap_3
Xclkbuf_leaf_0_clk clkbuf_leaf_2_clk/A VGND VGND VPWR VPWR clkload7/A sky130_fd_sc_hd__clkbuf_8
XFILLER_37_814 VGND VGND VPWR VPWR sky130_fd_sc_hd__decap_3
XFILLER_3_1139 VGND VGND VPWR VPWR sky130_fd_sc_hd__decap_3
XFILLER_63_110 VGND VGND VPWR VPWR sky130_fd_sc_hd__fill_2
XFILLER_24_508 VGND VGND VPWR VPWR sky130_fd_sc_hd__fill_2
XFILLER_36_368 VGND VGND VPWR VPWR sky130_fd_sc_hd__decap_3
XFILLER_52_828 VGND VGND VPWR VPWR sky130_fd_sc_hd__decap_3
XFILLER_36_379 VGND VGND VPWR VPWR sky130_fd_sc_hd__decap_3
X_4971_ _6353_/Q _4970_/X _4971_/S VGND VGND VPWR VPWR _6353_/D sky130_fd_sc_hd__mux2_1
XFILLER_75_1422 VGND VGND VPWR VPWR sky130_fd_sc_hd__decap_3
X_6710_ _7001_/CLK _6710_/D fanout774/X VGND VGND VPWR VPWR _6710_/Q sky130_fd_sc_hd__dfrtp_2
XFILLER_75_1455 VGND VGND VPWR VPWR sky130_fd_sc_hd__fill_1
X_3922_ _6334_/Q _4786_/B _3920_/X _3921_/X VGND VGND VPWR VPWR _4348_/A sky130_fd_sc_hd__o22a_2
XFILLER_36_1406 VGND VGND VPWR VPWR sky130_fd_sc_hd__decap_3
XFILLER_75_1466 VGND VGND VPWR VPWR sky130_fd_sc_hd__decap_3
XFILLER_71_1319 VGND VGND VPWR VPWR sky130_fd_sc_hd__decap_3
X_6641_ _7025_/CLK _6641_/D wire764/X VGND VGND VPWR VPWR _6641_/Q sky130_fd_sc_hd__dfrtp_2
X_3853_ _6219_/Q _4081_/A2 _3851_/X _3852_/X VGND VGND VPWR VPWR _6219_/D sky130_fd_sc_hd__o22a_2
XFILLER_20_725 VGND VGND VPWR VPWR sky130_fd_sc_hd__decap_3
XFILLER_34_1130 VGND VGND VPWR VPWR sky130_fd_sc_hd__decap_3
XFILLER_34_1152 VGND VGND VPWR VPWR sky130_fd_sc_hd__decap_3
X_6572_ _6974_/CLK _6572_/D load_slew780/X VGND VGND VPWR VPWR _6572_/Q sky130_fd_sc_hd__dfrtp_2
X_3784_ _3276_/X _4743_/B2 _4744_/A2 _6835_/Q _4092_/C1 VGND VGND VPWR VPWR _3784_/X
+ sky130_fd_sc_hd__a221o_2
XFILLER_34_1174 VGND VGND VPWR VPWR sky130_fd_sc_hd__decap_3
X_5523_ _6611_/Q _5488_/X _5522_/X VGND VGND VPWR VPWR _6611_/D sky130_fd_sc_hd__o21a_2
XFILLER_69_1204 VGND VGND VPWR VPWR sky130_fd_sc_hd__decap_3
XFILLER_12_1450 VGND VGND VPWR VPWR sky130_fd_sc_hd__decap_3
X_5454_ _5454_/A1 _5480_/A2 _4049_/X VGND VGND VPWR VPWR _6566_/D sky130_fd_sc_hd__a21o_2
XFILLER_69_1248 VGND VGND VPWR VPWR sky130_fd_sc_hd__decap_3
X_4405_ _6509_/Q _4405_/B VGND VGND VPWR VPWR _4405_/Y sky130_fd_sc_hd__nand2_2
X_5385_ _5385_/A1 _5485_/A2 _3783_/X VGND VGND VPWR VPWR _6497_/D sky130_fd_sc_hd__a21o_2
XTAP_TAPCELL_ROW_35_1102 VGND VPWR sky130_fd_sc_hd__tapvpwrvgnd_1
XFILLER_5_80 VGND VGND VPWR VPWR sky130_fd_sc_hd__decap_3
XTAP_TAPCELL_ROW_35_1113 VGND VPWR sky130_fd_sc_hd__tapvpwrvgnd_1
X_4336_ _4348_/A _4336_/B VGND VGND VPWR VPWR _4337_/B sky130_fd_sc_hd__xor2_2
XFILLER_59_405 VGND VGND VPWR VPWR sky130_fd_sc_hd__fill_2
Xfanout226 _5955_/S VGND VGND VPWR VPWR _6047_/S sky130_fd_sc_hd__clkdlybuf4s25_1
Xfanout237 _5464_/A2 VGND VGND VPWR VPWR _5470_/A2 sky130_fd_sc_hd__clkdlybuf4s25_1
X_7055_ _7055_/CLK _7055_/D fanout791/A VGND VGND VPWR VPWR _7055_/Q sky130_fd_sc_hd__dfrtp_2
Xfanout248 _5359_/X VGND VGND VPWR VPWR _5468_/A2 sky130_fd_sc_hd__clkdlybuf4s25_1
X_4267_ _4487_/A _4665_/B _4842_/C VGND VGND VPWR VPWR _4267_/X sky130_fd_sc_hd__or3_2
Xfanout259 _4010_/X VGND VGND VPWR VPWR _4659_/A sky130_fd_sc_hd__clkdlybuf4s25_1
XFILLER_59_449 VGND VGND VPWR VPWR sky130_fd_sc_hd__decap_3
XFILLER_80_1161 VGND VGND VPWR VPWR sky130_fd_sc_hd__decap_3
XFILLER_45_1281 VGND VGND VPWR VPWR sky130_fd_sc_hd__decap_3
XFILLER_74_408 VGND VGND VPWR VPWR sky130_fd_sc_hd__decap_3
X_6006_ _6006_/A0 _7010_/Q _6046_/S VGND VGND VPWR VPWR _6006_/X sky130_fd_sc_hd__mux2_1
XFILLER_45_1292 VGND VGND VPWR VPWR sky130_fd_sc_hd__decap_3
XFILLER_80_1183 VGND VGND VPWR VPWR sky130_fd_sc_hd__decap_3
X_3218_ _6985_/Q _6993_/Q _3222_/A VGND VGND VPWR VPWR _3218_/X sky130_fd_sc_hd__mux2_1
XFILLER_28_803 VGND VGND VPWR VPWR sky130_fd_sc_hd__fill_2
X_4198_ _6256_/Q wire52/X _4195_/X _4197_/X VGND VGND VPWR VPWR _6256_/D sky130_fd_sc_hd__o22a_2
XFILLER_67_482 VGND VGND VPWR VPWR sky130_fd_sc_hd__decap_3
XFILLER_54_110 VGND VGND VPWR VPWR sky130_fd_sc_hd__decap_3
XFILLER_28_858 VGND VGND VPWR VPWR sky130_fd_sc_hd__fill_1
X_3149_ _7012_/Q _7020_/Q _3149_/S VGND VGND VPWR VPWR _3149_/X sky130_fd_sc_hd__mux2_1
XFILLER_39_195 VGND VGND VPWR VPWR sky130_fd_sc_hd__decap_3
XFILLER_28_869 VGND VGND VPWR VPWR sky130_fd_sc_hd__decap_3
XFILLER_76_1208 VGND VGND VPWR VPWR sky130_fd_sc_hd__decap_3
XFILLER_15_508 VGND VGND VPWR VPWR sky130_fd_sc_hd__fill_2
XFILLER_15_519 VGND VGND VPWR VPWR sky130_fd_sc_hd__decap_3
XFILLER_43_839 VGND VGND VPWR VPWR sky130_fd_sc_hd__fill_1
XTAP_TAPCELL_ROW_69_1990 VGND VPWR sky130_fd_sc_hd__tapvpwrvgnd_1
XFILLER_42_327 VGND VGND VPWR VPWR sky130_fd_sc_hd__decap_3
XFILLER_54_187 VGND VGND VPWR VPWR sky130_fd_sc_hd__decap_3
XPHY_EDGE_ROW_59_Left_140 VGND VGND VPWR VPWR sky130_fd_sc_hd__decap_3
XFILLER_24_12 VGND VGND VPWR VPWR sky130_fd_sc_hd__decap_3
X_6908_ _6943_/CLK _6908_/D fanout823/X VGND VGND VPWR VPWR _6908_/Q sky130_fd_sc_hd__dfrtp_2
XFILLER_39_1063 VGND VGND VPWR VPWR sky130_fd_sc_hd__fill_1
XTAP_TAPCELL_ROW_65_1887 VGND VPWR sky130_fd_sc_hd__tapvpwrvgnd_1
XFILLER_39_1085 VGND VGND VPWR VPWR sky130_fd_sc_hd__decap_3
XFILLER_51_872 VGND VGND VPWR VPWR sky130_fd_sc_hd__decap_3
XTAP_TAPCELL_ROW_65_1898 VGND VPWR sky130_fd_sc_hd__tapvpwrvgnd_1
X_6839_ _6999_/CLK _6839_/D load_slew786/X VGND VGND VPWR VPWR _6839_/Q sky130_fd_sc_hd__dfrtp_2
XFILLER_50_371 VGND VGND VPWR VPWR sky130_fd_sc_hd__decap_3
XFILLER_13_1203 VGND VGND VPWR VPWR sky130_fd_sc_hd__decap_3
XFILLER_11_769 VGND VGND VPWR VPWR sky130_fd_sc_hd__decap_3
XFILLER_10_235 VGND VGND VPWR VPWR sky130_fd_sc_hd__fill_2
XFILLER_17_1372 VGND VGND VPWR VPWR sky130_fd_sc_hd__decap_3
XFILLER_52_1252 VGND VGND VPWR VPWR sky130_fd_sc_hd__decap_3
Xwire627 input4/X VGND VGND VPWR VPWR _5791_/C sky130_fd_sc_hd__buf_4
XTAP_TAPCELL_ROW_21_742 VGND VPWR sky130_fd_sc_hd__tapvpwrvgnd_1
XFILLER_7_729 VGND VGND VPWR VPWR sky130_fd_sc_hd__fill_2
XTAP_TAPCELL_ROW_21_753 VGND VPWR sky130_fd_sc_hd__tapvpwrvgnd_1
XFILLER_13_1236 VGND VGND VPWR VPWR sky130_fd_sc_hd__decap_3
XFILLER_52_1285 VGND VGND VPWR VPWR sky130_fd_sc_hd__decap_3
XFILLER_13_1269 VGND VGND VPWR VPWR sky130_fd_sc_hd__decap_3
XFILLER_3_924 VGND VGND VPWR VPWR sky130_fd_sc_hd__decap_3
XFILLER_40_88 VGND VGND VPWR VPWR sky130_fd_sc_hd__decap_3
XFILLER_2_401 VGND VGND VPWR VPWR sky130_fd_sc_hd__decap_3
XFILLER_6_3 VGND VGND VPWR VPWR sky130_fd_sc_hd__decap_3
XFILLER_2_434 VGND VGND VPWR VPWR sky130_fd_sc_hd__decap_3
XFILLER_3_968 VGND VGND VPWR VPWR sky130_fd_sc_hd__decap_3
XFILLER_2_445 VGND VGND VPWR VPWR sky130_fd_sc_hd__decap_3
XFILLER_24_1332 VGND VGND VPWR VPWR sky130_fd_sc_hd__decap_3
XFILLER_63_1381 VGND VGND VPWR VPWR sky130_fd_sc_hd__decap_3
XFILLER_4_1415 VGND VGND VPWR VPWR sky130_fd_sc_hd__decap_3
XFILLER_1_27 VGND VGND VPWR VPWR sky130_fd_sc_hd__decap_3
Xfanout793 fanout803/X VGND VGND VPWR VPWR fanout793/X sky130_fd_sc_hd__clkdlybuf4s25_1
XFILLER_24_1365 VGND VGND VPWR VPWR sky130_fd_sc_hd__decap_3
XFILLER_24_1376 VGND VGND VPWR VPWR sky130_fd_sc_hd__decap_3
XFILLER_65_30 VGND VGND VPWR VPWR sky130_fd_sc_hd__decap_3
XFILLER_4_1459 VGND VGND VPWR VPWR sky130_fd_sc_hd__decap_3
XFILLER_65_63 VGND VGND VPWR VPWR sky130_fd_sc_hd__decap_3
XFILLER_46_666 VGND VGND VPWR VPWR sky130_fd_sc_hd__decap_3
XFILLER_59_1428 VGND VGND VPWR VPWR sky130_fd_sc_hd__decap_3
XFILLER_18_368 VGND VGND VPWR VPWR sky130_fd_sc_hd__decap_3
XFILLER_2_1161 VGND VGND VPWR VPWR sky130_fd_sc_hd__decap_3
XFILLER_27_880 VGND VGND VPWR VPWR sky130_fd_sc_hd__decap_3
XFILLER_33_316 VGND VGND VPWR VPWR sky130_fd_sc_hd__decap_3
XFILLER_2_1194 VGND VGND VPWR VPWR sky130_fd_sc_hd__decap_3
XFILLER_57_1130 VGND VGND VPWR VPWR sky130_fd_sc_hd__fill_1
XFILLER_14_530 VGND VGND VPWR VPWR sky130_fd_sc_hd__fill_2
XFILLER_18_1114 VGND VGND VPWR VPWR sky130_fd_sc_hd__decap_3
XFILLER_42_861 VGND VGND VPWR VPWR sky130_fd_sc_hd__decap_3
XFILLER_42_872 VGND VGND VPWR VPWR sky130_fd_sc_hd__decap_3
XFILLER_41_360 VGND VGND VPWR VPWR sky130_fd_sc_hd__decap_3
XFILLER_41_371 VGND VGND VPWR VPWR sky130_fd_sc_hd__fill_2
XFILLER_41_393 VGND VGND VPWR VPWR sky130_fd_sc_hd__decap_3
XFILLER_70_1341 VGND VGND VPWR VPWR sky130_fd_sc_hd__decap_3
XFILLER_31_1325 VGND VGND VPWR VPWR sky130_fd_sc_hd__decap_3
XFILLER_70_1385 VGND VGND VPWR VPWR sky130_fd_sc_hd__decap_3
XFILLER_31_1369 VGND VGND VPWR VPWR sky130_fd_sc_hd__decap_3
XFILLER_60_6 VGND VGND VPWR VPWR sky130_fd_sc_hd__decap_3
XTAP_TAPCELL_ROW_75_2150 VGND VPWR sky130_fd_sc_hd__tapvpwrvgnd_1
XTAP_TAPCELL_ROW_75_2161 VGND VPWR sky130_fd_sc_hd__tapvpwrvgnd_1
XFILLER_6_795 VGND VGND VPWR VPWR sky130_fd_sc_hd__decap_3
XTAP_TAPCELL_ROW_71_2036 VGND VPWR sky130_fd_sc_hd__tapvpwrvgnd_1
XFILLER_68_1270 VGND VGND VPWR VPWR sky130_fd_sc_hd__decap_3
XTAP_TAPCELL_ROW_71_2047 VGND VPWR sky130_fd_sc_hd__tapvpwrvgnd_1
XFILLER_9_1304 VGND VGND VPWR VPWR sky130_fd_sc_hd__decap_3
XFILLER_64_1123 VGND VGND VPWR VPWR sky130_fd_sc_hd__decap_3
XTAP_TAPCELL_ROW_71_2058 VGND VPWR sky130_fd_sc_hd__tapvpwrvgnd_1
X_5170_ _6732_/Q _5314_/S VGND VGND VPWR VPWR _5170_/X sky130_fd_sc_hd__or2_2
XFILLER_29_1254 VGND VGND VPWR VPWR sky130_fd_sc_hd__decap_3
XFILLER_9_1337 VGND VGND VPWR VPWR sky130_fd_sc_hd__decap_3
XFILLER_39_3 VGND VGND VPWR VPWR sky130_fd_sc_hd__decap_3
XFILLER_9_1348 VGND VGND VPWR VPWR sky130_fd_sc_hd__decap_3
XFILLER_2_990 VGND VGND VPWR VPWR sky130_fd_sc_hd__decap_3
XFILLER_25_1118 VGND VGND VPWR VPWR sky130_fd_sc_hd__fill_2
XFILLER_29_1287 VGND VGND VPWR VPWR sky130_fd_sc_hd__fill_1
X_4121_ _4291_/A _4121_/B VGND VGND VPWR VPWR _4122_/B sky130_fd_sc_hd__xor2_2
XFILLER_64_1167 VGND VGND VPWR VPWR sky130_fd_sc_hd__decap_3
XFILLER_25_1129 VGND VGND VPWR VPWR sky130_fd_sc_hd__decap_3
XFILLER_29_1298 VGND VGND VPWR VPWR sky130_fd_sc_hd__decap_3
XFILLER_42_1421 VGND VGND VPWR VPWR sky130_fd_sc_hd__decap_3
XFILLER_7_1050 VGND VGND VPWR VPWR sky130_fd_sc_hd__decap_3
XFILLER_42_1432 VGND VGND VPWR VPWR sky130_fd_sc_hd__decap_3
XFILLER_56_419 VGND VGND VPWR VPWR sky130_fd_sc_hd__fill_1
X_4052_ _4008_/B _3717_/A _4344_/B _4008_/Y _6567_/Q VGND VGND VPWR VPWR _4052_/X
+ sky130_fd_sc_hd__a32o_2
XFILLER_7_1072 VGND VGND VPWR VPWR sky130_fd_sc_hd__fill_2
XFILLER_42_1465 VGND VGND VPWR VPWR sky130_fd_sc_hd__decap_3
XFILLER_65_920 VGND VGND VPWR VPWR sky130_fd_sc_hd__decap_3
Xinput4 ui_in[2] VGND VGND VPWR VPWR input4/X sky130_fd_sc_hd__buf_1
XFILLER_7_1083 VGND VGND VPWR VPWR sky130_fd_sc_hd__decap_3
XFILLER_76_290 VGND VGND VPWR VPWR sky130_fd_sc_hd__fill_1
XFILLER_64_430 VGND VGND VPWR VPWR sky130_fd_sc_hd__decap_3
XFILLER_65_964 VGND VGND VPWR VPWR sky130_fd_sc_hd__decap_3
XFILLER_36_154 VGND VGND VPWR VPWR sky130_fd_sc_hd__decap_3
XFILLER_24_305 VGND VGND VPWR VPWR sky130_fd_sc_hd__decap_3
XFILLER_51_113 VGND VGND VPWR VPWR sky130_fd_sc_hd__fill_1
XFILLER_51_135 VGND VGND VPWR VPWR sky130_fd_sc_hd__fill_2
X_4954_ _6383_/Q _5219_/B _5359_/B VGND VGND VPWR VPWR _4954_/Y sky130_fd_sc_hd__a21oi_2
XFILLER_75_1263 VGND VGND VPWR VPWR sky130_fd_sc_hd__decap_3
XFILLER_33_872 VGND VGND VPWR VPWR sky130_fd_sc_hd__decap_3
X_3905_ _4240_/B _3905_/B VGND VGND VPWR VPWR _4162_/A sky130_fd_sc_hd__xnor2_2
XFILLER_71_1138 VGND VGND VPWR VPWR sky130_fd_sc_hd__decap_3
X_4885_ _6590_/Q _4842_/X _4885_/B1 VGND VGND VPWR VPWR _4885_/X sky130_fd_sc_hd__a21o_2
XFILLER_36_1258 VGND VGND VPWR VPWR sky130_fd_sc_hd__fill_2
XFILLER_60_691 VGND VGND VPWR VPWR sky130_fd_sc_hd__decap_3
XTAP_TAPCELL_ROW_15_580 VGND VPWR sky130_fd_sc_hd__tapvpwrvgnd_1
XFILLER_20_533 VGND VGND VPWR VPWR sky130_fd_sc_hd__decap_3
XTAP_TAPCELL_ROW_15_591 VGND VPWR sky130_fd_sc_hd__tapvpwrvgnd_1
X_6624_ _7040_/CLK _6624_/D fanout716/X VGND VGND VPWR VPWR _6624_/Q sky130_fd_sc_hd__dfrtp_2
X_3836_ _6226_/Q _3928_/A2 _3928_/B1 _6218_/Q _3928_/C1 VGND VGND VPWR VPWR _3836_/X
+ sky130_fd_sc_hd__a221o_2
XTAP_TAPCELL_ROW_60_1751 VGND VPWR sky130_fd_sc_hd__tapvpwrvgnd_1
XTAP_TAPCELL_ROW_60_1762 VGND VPWR sky130_fd_sc_hd__tapvpwrvgnd_1
Xtt_um_aes128_optimized_852 VGND VGND VPWR VPWR tt_um_aes128_optimized_852/HI uio_oe[4]
+ sky130_fd_sc_hd__conb_1
XTAP_TAPCELL_ROW_60_1773 VGND VPWR sky130_fd_sc_hd__tapvpwrvgnd_1
X_6555_ _6897_/CLK _6555_/D fanout703/X VGND VGND VPWR VPWR _6555_/Q sky130_fd_sc_hd__dfrtp_2
X_3767_ _6321_/Q _4740_/B _3765_/X _3766_/X VGND VGND VPWR VPWR _4281_/B sky130_fd_sc_hd__o22a_2
XFILLER_10_1409 VGND VGND VPWR VPWR sky130_fd_sc_hd__decap_3
X_5506_ _5506_/A _5511_/B VGND VGND VPWR VPWR _5513_/A sky130_fd_sc_hd__or2_2
X_3698_ _3693_/C _3678_/Y _3786_/B _3671_/A VGND VGND VPWR VPWR _3829_/A sky130_fd_sc_hd__o211a_2
X_6486_ _6888_/CLK _6486_/D fanout704/X VGND VGND VPWR VPWR _6486_/Q sky130_fd_sc_hd__dfrtp_2
XFILLER_12_1291 VGND VGND VPWR VPWR sky130_fd_sc_hd__decap_3
X_5437_ _5437_/A1 _5474_/A2 _4647_/X VGND VGND VPWR VPWR _6549_/D sky130_fd_sc_hd__a21o_2
XFILLER_47_1310 VGND VGND VPWR VPWR sky130_fd_sc_hd__decap_3
XFILLER_47_1343 VGND VGND VPWR VPWR sky130_fd_sc_hd__fill_1
X_5368_ _5368_/A1 _5464_/A2 _4195_/X VGND VGND VPWR VPWR _6480_/D sky130_fd_sc_hd__a21o_2
XFILLER_47_1354 VGND VGND VPWR VPWR sky130_fd_sc_hd__decap_3
XFILLER_0_949 VGND VGND VPWR VPWR sky130_fd_sc_hd__decap_3
XFILLER_47_1387 VGND VGND VPWR VPWR sky130_fd_sc_hd__decap_3
XFILLER_19_12 VGND VGND VPWR VPWR sky130_fd_sc_hd__decap_3
X_4319_ _6492_/Q _4319_/A2 _4874_/C1 _4318_/Y VGND VGND VPWR VPWR _4319_/X sky130_fd_sc_hd__o211a_2
X_5299_ _6442_/Q _5298_/X _5331_/S VGND VGND VPWR VPWR _6442_/D sky130_fd_sc_hd__mux2_1
XTAP_TAPCELL_ROW_54_1599 VGND VPWR sky130_fd_sc_hd__tapvpwrvgnd_1
XFILLER_19_45 VGND VGND VPWR VPWR sky130_fd_sc_hd__decap_3
X_7038_ _7088_/CLK _7038_/D load_slew775/X VGND VGND VPWR VPWR _7038_/Q sky130_fd_sc_hd__dfrtp_2
XFILLER_74_216 VGND VGND VPWR VPWR sky130_fd_sc_hd__fill_1
XFILLER_74_249 VGND VGND VPWR VPWR sky130_fd_sc_hd__decap_3
XTAP_TAPCELL_ROW_2_242 VGND VPWR sky130_fd_sc_hd__tapvpwrvgnd_1
XTAP_TAPCELL_ROW_2_253 VGND VPWR sky130_fd_sc_hd__tapvpwrvgnd_1
XFILLER_16_806 VGND VGND VPWR VPWR sky130_fd_sc_hd__decap_3
XFILLER_28_666 VGND VGND VPWR VPWR sky130_fd_sc_hd__decap_3
XTAP_TAPCELL_ROW_2_264 VGND VPWR sky130_fd_sc_hd__tapvpwrvgnd_1
XTAP_TAPCELL_ROW_67_1938 VGND VPWR sky130_fd_sc_hd__tapvpwrvgnd_1
XFILLER_56_997 VGND VGND VPWR VPWR sky130_fd_sc_hd__decap_3
XTAP_TAPCELL_ROW_67_1949 VGND VPWR sky130_fd_sc_hd__tapvpwrvgnd_1
XFILLER_76_1027 VGND VGND VPWR VPWR sky130_fd_sc_hd__decap_3
XFILLER_70_444 VGND VGND VPWR VPWR sky130_fd_sc_hd__decap_3
XFILLER_19_1401 VGND VGND VPWR VPWR sky130_fd_sc_hd__decap_3
XFILLER_42_135 VGND VGND VPWR VPWR sky130_fd_sc_hd__decap_3
XFILLER_58_1450 VGND VGND VPWR VPWR sky130_fd_sc_hd__decap_3
XFILLER_70_455 VGND VGND VPWR VPWR sky130_fd_sc_hd__decap_3
XFILLER_24_850 VGND VGND VPWR VPWR sky130_fd_sc_hd__fill_2
XTAP_TAPCELL_ROW_26_867 VGND VPWR sky130_fd_sc_hd__tapvpwrvgnd_1
XFILLER_54_1303 VGND VGND VPWR VPWR sky130_fd_sc_hd__decap_3
XFILLER_19_1434 VGND VGND VPWR VPWR sky130_fd_sc_hd__decap_3
XTAP_TAPCELL_ROW_26_878 VGND VPWR sky130_fd_sc_hd__tapvpwrvgnd_1
XFILLER_35_88 VGND VGND VPWR VPWR sky130_fd_sc_hd__decap_3
XFILLER_24_872 VGND VGND VPWR VPWR sky130_fd_sc_hd__decap_3
XFILLER_42_168 VGND VGND VPWR VPWR sky130_fd_sc_hd__decap_3
XTAP_TAPCELL_ROW_26_889 VGND VPWR sky130_fd_sc_hd__tapvpwrvgnd_1
XTAP_TAPCELL_ROW_13_528 VGND VPWR sky130_fd_sc_hd__tapvpwrvgnd_1
XFILLER_54_1347 VGND VGND VPWR VPWR sky130_fd_sc_hd__decap_3
XTAP_TAPCELL_ROW_13_539 VGND VPWR sky130_fd_sc_hd__tapvpwrvgnd_1
XFILLER_23_393 VGND VGND VPWR VPWR sky130_fd_sc_hd__decap_3
XFILLER_11_577 VGND VGND VPWR VPWR sky130_fd_sc_hd__decap_3
XFILLER_17_1180 VGND VGND VPWR VPWR sky130_fd_sc_hd__fill_1
XFILLER_7_559 VGND VGND VPWR VPWR sky130_fd_sc_hd__fill_1
XFILLER_13_1055 VGND VGND VPWR VPWR sky130_fd_sc_hd__decap_3
XFILLER_3_732 VGND VGND VPWR VPWR sky130_fd_sc_hd__decap_3
XFILLER_30_1391 VGND VGND VPWR VPWR sky130_fd_sc_hd__decap_3
XFILLER_48_1129 VGND VGND VPWR VPWR sky130_fd_sc_hd__decap_3
XFILLER_65_1410 VGND VGND VPWR VPWR sky130_fd_sc_hd__decap_3
XFILLER_3_765 VGND VGND VPWR VPWR sky130_fd_sc_hd__fill_1
XFILLER_2_242 VGND VGND VPWR VPWR sky130_fd_sc_hd__decap_3
XFILLER_2_253 VGND VGND VPWR VPWR sky130_fd_sc_hd__decap_3
XFILLER_65_1443 VGND VGND VPWR VPWR sky130_fd_sc_hd__decap_3
XFILLER_78_533 VGND VGND VPWR VPWR sky130_fd_sc_hd__decap_3
XFILLER_26_1427 VGND VGND VPWR VPWR sky130_fd_sc_hd__fill_1
XFILLER_61_1307 VGND VGND VPWR VPWR sky130_fd_sc_hd__decap_3
XFILLER_2_297 VGND VGND VPWR VPWR sky130_fd_sc_hd__decap_3
XFILLER_26_1438 VGND VGND VPWR VPWR sky130_fd_sc_hd__decap_3
XFILLER_39_909 VGND VGND VPWR VPWR sky130_fd_sc_hd__fill_1
XFILLER_25_9 VGND VGND VPWR VPWR sky130_fd_sc_hd__decap_3
XFILLER_76_62 VGND VGND VPWR VPWR sky130_fd_sc_hd__decap_3
XFILLER_4_1223 VGND VGND VPWR VPWR sky130_fd_sc_hd__decap_3
Xfanout590 _5505_/A VGND VGND VPWR VPWR _4420_/B sky130_fd_sc_hd__clkdlybuf4s25_1
XFILLER_65_238 VGND VGND VPWR VPWR sky130_fd_sc_hd__decap_3
XFILLER_20_1015 VGND VGND VPWR VPWR sky130_fd_sc_hd__decap_3
XFILLER_4_1256 VGND VGND VPWR VPWR sky130_fd_sc_hd__decap_3
XFILLER_24_1184 VGND VGND VPWR VPWR sky130_fd_sc_hd__decap_3
XFILLER_4_1267 VGND VGND VPWR VPWR sky130_fd_sc_hd__decap_3
XFILLER_19_655 VGND VGND VPWR VPWR sky130_fd_sc_hd__decap_3
XFILLER_46_463 VGND VGND VPWR VPWR sky130_fd_sc_hd__decap_3
XFILLER_59_1225 VGND VGND VPWR VPWR sky130_fd_sc_hd__decap_3
XFILLER_59_1236 VGND VGND VPWR VPWR sky130_fd_sc_hd__decap_3
XFILLER_33_124 VGND VGND VPWR VPWR sky130_fd_sc_hd__fill_1
XFILLER_59_1269 VGND VGND VPWR VPWR sky130_fd_sc_hd__decap_3
XFILLER_34_669 VGND VGND VPWR VPWR sky130_fd_sc_hd__decap_3
XFILLER_15_850 VGND VGND VPWR VPWR sky130_fd_sc_hd__decap_3
XFILLER_72_1403 VGND VGND VPWR VPWR sky130_fd_sc_hd__decap_3
XFILLER_61_466 VGND VGND VPWR VPWR sky130_fd_sc_hd__decap_3
XFILLER_14_371 VGND VGND VPWR VPWR sky130_fd_sc_hd__decap_3
XFILLER_72_1447 VGND VGND VPWR VPWR sky130_fd_sc_hd__decap_3
X_4670_ _6288_/Q _4847_/A2 _3386_/X _4789_/B2 VGND VGND VPWR VPWR _4670_/X sky130_fd_sc_hd__a22o_2
XFILLER_41_190 VGND VGND VPWR VPWR sky130_fd_sc_hd__decap_3
XFILLER_30_864 VGND VGND VPWR VPWR sky130_fd_sc_hd__decap_3
XTAP_TAPCELL_ROW_77_2201 VGND VPWR sky130_fd_sc_hd__tapvpwrvgnd_1
XTAP_TAPCELL_ROW_77_2212 VGND VPWR sky130_fd_sc_hd__tapvpwrvgnd_1
X_3621_ _6232_/Q _3631_/A2 _3630_/C1 _6296_/Q _4532_/B VGND VGND VPWR VPWR _3622_/B
+ sky130_fd_sc_hd__a221o_2
XFILLER_70_1182 VGND VGND VPWR VPWR sky130_fd_sc_hd__decap_3
XFILLER_31_1133 VGND VGND VPWR VPWR sky130_fd_sc_hd__fill_2
X_6340_ _6926_/CLK _6340_/D fanout745/X VGND VGND VPWR VPWR _6340_/Q sky130_fd_sc_hd__dfrtp_2
X_3552_ _6643_/Q _4723_/C _3550_/X _3551_/X _5577_/A VGND VGND VPWR VPWR _3552_/X
+ sky130_fd_sc_hd__o221a_2
XTAP_TAPCELL_ROW_73_2109 VGND VPWR sky130_fd_sc_hd__tapvpwrvgnd_1
XFILLER_31_1177 VGND VGND VPWR VPWR sky130_fd_sc_hd__fill_1
XFILLER_31_1199 VGND VGND VPWR VPWR sky130_fd_sc_hd__decap_3
X_6271_ _6993_/CLK _6271_/D load_slew710/X VGND VGND VPWR VPWR _6271_/Q sky130_fd_sc_hd__dfrtp_2
X_3483_ _3483_/A _3483_/B VGND VGND VPWR VPWR _3483_/Y sky130_fd_sc_hd__nand2_2
XFILLER_66_1229 VGND VGND VPWR VPWR sky130_fd_sc_hd__decap_3
X_5222_ _5326_/S _5222_/B VGND VGND VPWR VPWR _5222_/Y sky130_fd_sc_hd__nand2_2
XFILLER_69_511 VGND VGND VPWR VPWR sky130_fd_sc_hd__decap_3
XFILLER_29_1062 VGND VGND VPWR VPWR sky130_fd_sc_hd__fill_2
XFILLER_9_1145 VGND VGND VPWR VPWR sky130_fd_sc_hd__decap_3
XFILLER_29_1073 VGND VGND VPWR VPWR sky130_fd_sc_hd__decap_3
X_5153_ _6385_/Q _5153_/A2 _4971_/S _5152_/X VGND VGND VPWR VPWR _6385_/D sky130_fd_sc_hd__a22o_2
X_4104_ _3480_/X _4780_/B2 _4781_/A2 _6937_/Q _4104_/C1 VGND VGND VPWR VPWR _4104_/X
+ sky130_fd_sc_hd__a221o_2
XFILLER_29_408 VGND VGND VPWR VPWR sky130_fd_sc_hd__decap_3
XFILLER_9_1189 VGND VGND VPWR VPWR sky130_fd_sc_hd__decap_3
X_5084_ _6369_/Q _5083_/X _5083_/A _6707_/Q VGND VGND VPWR VPWR _5084_/X sky130_fd_sc_hd__a2bb2o_2
XFILLER_56_205 VGND VGND VPWR VPWR sky130_fd_sc_hd__decap_3
XFILLER_42_1240 VGND VGND VPWR VPWR sky130_fd_sc_hd__decap_3
XFILLER_56_216 VGND VGND VPWR VPWR sky130_fd_sc_hd__fill_2
XFILLER_42_1273 VGND VGND VPWR VPWR sky130_fd_sc_hd__decap_3
X_4035_ _4083_/B _4696_/B VGND VGND VPWR VPWR _4035_/Y sky130_fd_sc_hd__nor2_2
XFILLER_38_953 VGND VGND VPWR VPWR sky130_fd_sc_hd__decap_3
XFILLER_37_452 VGND VGND VPWR VPWR sky130_fd_sc_hd__decap_3
XFILLER_77_1325 VGND VGND VPWR VPWR sky130_fd_sc_hd__decap_3
XFILLER_38_1309 VGND VGND VPWR VPWR sky130_fd_sc_hd__decap_3
XFILLER_77_1369 VGND VGND VPWR VPWR sky130_fd_sc_hd__decap_3
XFILLER_64_293 VGND VGND VPWR VPWR sky130_fd_sc_hd__decap_3
XFILLER_80_753 VGND VGND VPWR VPWR sky130_fd_sc_hd__decap_3
XFILLER_13_809 VGND VGND VPWR VPWR sky130_fd_sc_hd__decap_3
XFILLER_80_775 VGND VGND VPWR VPWR sky130_fd_sc_hd__decap_3
X_5986_ _5986_/A0 _5986_/A1 _5989_/S VGND VGND VPWR VPWR _6990_/D sky130_fd_sc_hd__mux2_1
XFILLER_24_157 VGND VGND VPWR VPWR sky130_fd_sc_hd__decap_3
XTAP_TAPCELL_ROW_62_1802 VGND VPWR sky130_fd_sc_hd__tapvpwrvgnd_1
XTAP_TAPCELL_ROW_23_804 VGND VPWR sky130_fd_sc_hd__tapvpwrvgnd_1
XTAP_TAPCELL_ROW_62_1813 VGND VPWR sky130_fd_sc_hd__tapvpwrvgnd_1
XFILLER_52_477 VGND VGND VPWR VPWR sky130_fd_sc_hd__decap_3
XTAP_TAPCELL_ROW_62_1824 VGND VPWR sky130_fd_sc_hd__tapvpwrvgnd_1
XFILLER_40_639 VGND VGND VPWR VPWR sky130_fd_sc_hd__decap_3
X_4937_ _6445_/Q _6663_/Q VGND VGND VPWR VPWR _4938_/B sky130_fd_sc_hd__xor2_2
XFILLER_75_1093 VGND VGND VPWR VPWR sky130_fd_sc_hd__decap_3
XANTENNA_20 _5780_/S VGND VGND VPWR VPWR sky130_fd_sc_hd__diode_2
XANTENNA_31 _7076_/Q VGND VGND VPWR VPWR sky130_fd_sc_hd__diode_2
X_4868_ _6315_/Q _4868_/A2 _3456_/X _4868_/B2 VGND VGND VPWR VPWR _4868_/X sky130_fd_sc_hd__a22o_2
XFILLER_14_1320 VGND VGND VPWR VPWR sky130_fd_sc_hd__decap_3
XANTENNA_42 _5748_/S VGND VGND VPWR VPWR sky130_fd_sc_hd__diode_2
XANTENNA_53 _5627_/S VGND VGND VPWR VPWR sky130_fd_sc_hd__diode_2
XFILLER_21_897 VGND VGND VPWR VPWR sky130_fd_sc_hd__fill_1
XANTENNA_64 _3205_/B1 VGND VGND VPWR VPWR sky130_fd_sc_hd__diode_2
X_6607_ _7041_/CLK _6607_/D fanout730/X VGND VGND VPWR VPWR _6607_/Q sky130_fd_sc_hd__dfrtp_2
XANTENNA_75 _5502_/C VGND VGND VPWR VPWR sky130_fd_sc_hd__diode_2
X_3819_ _3634_/X _3635_/Y _3791_/B VGND VGND VPWR VPWR _3827_/A sky130_fd_sc_hd__a21oi_2
XFILLER_14_1353 VGND VGND VPWR VPWR sky130_fd_sc_hd__decap_3
X_4799_ _4796_/X _4798_/Y _6329_/Q wire63/X VGND VGND VPWR VPWR _6329_/D sky130_fd_sc_hd__o2bb2a_2
XANTENNA_86 _3958_/Y VGND VGND VPWR VPWR sky130_fd_sc_hd__diode_2
XFILLER_10_1217 VGND VGND VPWR VPWR sky130_fd_sc_hd__decap_3
XFILLER_4_518 VGND VGND VPWR VPWR sky130_fd_sc_hd__decap_3
XFILLER_21_57 VGND VGND VPWR VPWR sky130_fd_sc_hd__decap_3
X_6538_ _6847_/CLK _6538_/D load_slew780/X VGND VGND VPWR VPWR _6538_/Q sky130_fd_sc_hd__dfrtp_2
XFILLER_14_1397 VGND VGND VPWR VPWR sky130_fd_sc_hd__decap_3
XFILLER_49_1416 VGND VGND VPWR VPWR sky130_fd_sc_hd__decap_3
X_6469_ _6807_/CLK _6469_/D fanout785/X VGND VGND VPWR VPWR _6469_/Q sky130_fd_sc_hd__dfrtp_2
XFILLER_49_1449 VGND VGND VPWR VPWR sky130_fd_sc_hd__decap_3
XFILLER_0_713 VGND VGND VPWR VPWR sky130_fd_sc_hd__decap_3
XFILLER_0_735 VGND VGND VPWR VPWR sky130_fd_sc_hd__decap_3
XFILLER_43_1004 VGND VGND VPWR VPWR sky130_fd_sc_hd__decap_3
XFILLER_0_757 VGND VGND VPWR VPWR sky130_fd_sc_hd__decap_3
XTAP_TAPCELL_ROW_7_378 VGND VPWR sky130_fd_sc_hd__tapvpwrvgnd_1
XTAP_TAPCELL_ROW_7_389 VGND VPWR sky130_fd_sc_hd__tapvpwrvgnd_1
XFILLER_43_1037 VGND VGND VPWR VPWR sky130_fd_sc_hd__decap_3
XFILLER_75_514 VGND VGND VPWR VPWR sky130_fd_sc_hd__decap_3
XFILLER_47_216 VGND VGND VPWR VPWR sky130_fd_sc_hd__decap_3
XFILLER_25_1460 VGND VGND VPWR VPWR sky130_fd_sc_hd__decap_3
XFILLER_21_1313 VGND VGND VPWR VPWR sky130_fd_sc_hd__decap_3
XFILLER_60_1362 VGND VGND VPWR VPWR sky130_fd_sc_hd__decap_3
XFILLER_60_1373 VGND VGND VPWR VPWR sky130_fd_sc_hd__decap_3
XFILLER_1_1407 VGND VGND VPWR VPWR sky130_fd_sc_hd__decap_3
XFILLER_28_452 VGND VGND VPWR VPWR sky130_fd_sc_hd__decap_3
XFILLER_21_1357 VGND VGND VPWR VPWR sky130_fd_sc_hd__decap_3
XFILLER_71_720 VGND VGND VPWR VPWR sky130_fd_sc_hd__decap_3
XFILLER_56_1409 VGND VGND VPWR VPWR sky130_fd_sc_hd__decap_3
XFILLER_43_466 VGND VGND VPWR VPWR sky130_fd_sc_hd__decap_3
XFILLER_19_1220 VGND VGND VPWR VPWR sky130_fd_sc_hd__decap_3
XFILLER_19_1242 VGND VGND VPWR VPWR sky130_fd_sc_hd__decap_3
XFILLER_58_1291 VGND VGND VPWR VPWR sky130_fd_sc_hd__decap_3
XFILLER_70_285 VGND VGND VPWR VPWR sky130_fd_sc_hd__decap_3
XFILLER_30_138 VGND VGND VPWR VPWR sky130_fd_sc_hd__fill_2
XFILLER_15_1106 VGND VGND VPWR VPWR sky130_fd_sc_hd__fill_2
XFILLER_19_1275 VGND VGND VPWR VPWR sky130_fd_sc_hd__decap_3
XFILLER_15_1117 VGND VGND VPWR VPWR sky130_fd_sc_hd__decap_3
XFILLER_54_1166 VGND VGND VPWR VPWR sky130_fd_sc_hd__fill_2
XFILLER_8_813 VGND VGND VPWR VPWR sky130_fd_sc_hd__fill_1
XFILLER_7_15 VGND VGND VPWR VPWR sky130_fd_sc_hd__decap_3
XFILLER_8_857 VGND VGND VPWR VPWR sky130_fd_sc_hd__decap_3
XFILLER_11_396 VGND VGND VPWR VPWR sky130_fd_sc_hd__fill_1
XFILLER_7_345 VGND VGND VPWR VPWR sky130_fd_sc_hd__decap_3
XFILLER_32_1453 VGND VGND VPWR VPWR sky130_fd_sc_hd__decap_3
XFILLER_3_540 VGND VGND VPWR VPWR sky130_fd_sc_hd__decap_3
XFILLER_3_573 VGND VGND VPWR VPWR sky130_fd_sc_hd__decap_3
Xload_slew204 _3413_/S VGND VGND VPWR VPWR _3429_/S sky130_fd_sc_hd__clkbuf_2
XFILLER_65_1251 VGND VGND VPWR VPWR sky130_fd_sc_hd__decap_3
Xload_slew215 _6060_/S VGND VGND VPWR VPWR _6052_/S sky130_fd_sc_hd__clkbuf_4
XFILLER_26_1235 VGND VGND VPWR VPWR sky130_fd_sc_hd__decap_3
XFILLER_65_1284 VGND VGND VPWR VPWR sky130_fd_sc_hd__decap_3
XFILLER_65_1295 VGND VGND VPWR VPWR sky130_fd_sc_hd__decap_3
XFILLER_6_1329 VGND VGND VPWR VPWR sky130_fd_sc_hd__decap_3
XFILLER_23_6 VGND VGND VPWR VPWR sky130_fd_sc_hd__decap_3
XFILLER_79_897 VGND VGND VPWR VPWR sky130_fd_sc_hd__decap_3
XFILLER_26_1279 VGND VGND VPWR VPWR sky130_fd_sc_hd__decap_3
XFILLER_38_227 VGND VGND VPWR VPWR sky130_fd_sc_hd__decap_3
XFILLER_4_1031 VGND VGND VPWR VPWR sky130_fd_sc_hd__decap_3
XFILLER_66_569 VGND VGND VPWR VPWR sky130_fd_sc_hd__decap_3
XFILLER_47_772 VGND VGND VPWR VPWR sky130_fd_sc_hd__fill_2
XFILLER_47_783 VGND VGND VPWR VPWR sky130_fd_sc_hd__fill_1
XFILLER_35_934 VGND VGND VPWR VPWR sky130_fd_sc_hd__decap_3
XFILLER_47_794 VGND VGND VPWR VPWR sky130_fd_sc_hd__decap_3
XFILLER_35_956 VGND VGND VPWR VPWR sky130_fd_sc_hd__decap_3
XFILLER_62_742 VGND VGND VPWR VPWR sky130_fd_sc_hd__decap_3
XTAP_TAPCELL_ROW_17_631 VGND VPWR sky130_fd_sc_hd__tapvpwrvgnd_1
XFILLER_46_293 VGND VGND VPWR VPWR sky130_fd_sc_hd__decap_3
X_5840_ _5923_/A1 _5840_/A1 _5840_/S VGND VGND VPWR VPWR _6857_/D sky130_fd_sc_hd__mux2_1
XTAP_TAPCELL_ROW_17_642 VGND VPWR sky130_fd_sc_hd__tapvpwrvgnd_1
XTAP_TAPCELL_ROW_17_653 VGND VPWR sky130_fd_sc_hd__tapvpwrvgnd_1
XFILLER_35_989 VGND VGND VPWR VPWR sky130_fd_sc_hd__decap_3
XFILLER_72_1200 VGND VGND VPWR VPWR sky130_fd_sc_hd__decap_3
XFILLER_72_1211 VGND VGND VPWR VPWR sky130_fd_sc_hd__decap_3
XFILLER_37_1331 VGND VGND VPWR VPWR sky130_fd_sc_hd__decap_3
XFILLER_76_1391 VGND VGND VPWR VPWR sky130_fd_sc_hd__decap_3
XFILLER_21_116 VGND VGND VPWR VPWR sky130_fd_sc_hd__fill_2
X_5771_ _5915_/D _5879_/A VGND VGND VPWR VPWR _5915_/B sky130_fd_sc_hd__nand2_2
XFILLER_50_959 VGND VGND VPWR VPWR sky130_fd_sc_hd__decap_3
XFILLER_72_1244 VGND VGND VPWR VPWR sky130_fd_sc_hd__decap_3
X_4722_ _6319_/Q _4721_/X _4899_/S VGND VGND VPWR VPWR _6319_/D sky130_fd_sc_hd__mux2_1
XFILLER_37_1375 VGND VGND VPWR VPWR sky130_fd_sc_hd__decap_3
XFILLER_72_1288 VGND VGND VPWR VPWR sky130_fd_sc_hd__decap_3
XFILLER_33_1239 VGND VGND VPWR VPWR sky130_fd_sc_hd__decap_3
X_4653_ _6550_/Q _4710_/A _4654_/A1 VGND VGND VPWR VPWR _4653_/X sky130_fd_sc_hd__a21bo_2
X_3604_ _3486_/A _3600_/X _3603_/X VGND VGND VPWR VPWR _3605_/B sky130_fd_sc_hd__a21oi_2
X_4584_ _6878_/Q _4584_/A2 _4758_/B1 _4583_/X VGND VGND VPWR VPWR _4584_/X sky130_fd_sc_hd__a211o_2
X_6323_ _7037_/CLK _6323_/D fanout685/X VGND VGND VPWR VPWR _6323_/Q sky130_fd_sc_hd__dfrtp_2
X_3535_ _4783_/A _3532_/X _3534_/X _3526_/X _3529_/X VGND VGND VPWR VPWR _3535_/X
+ sky130_fd_sc_hd__a32o_2
XFILLER_66_1037 VGND VGND VPWR VPWR sky130_fd_sc_hd__decap_3
Xhold868 _7079_/Q VGND VGND VPWR VPWR hold868/X sky130_fd_sc_hd__dlygate4sd3_1
X_3466_ _6240_/Q _6464_/Q VGND VGND VPWR VPWR _3466_/X sky130_fd_sc_hd__xor2_2
Xhold879 _6016_/X VGND VGND VPWR VPWR _7020_/D sky130_fd_sc_hd__dlygate4sd3_1
X_6254_ _7073_/CLK _6254_/D load_slew674/X VGND VGND VPWR VPWR _6254_/Q sky130_fd_sc_hd__dfrtp_2
X_5205_ _6748_/Q _5213_/A _5305_/S _5204_/Y VGND VGND VPWR VPWR _5205_/X sky130_fd_sc_hd__o211a_2
XTAP_TAPCELL_ROW_51_1514 VGND VPWR sky130_fd_sc_hd__tapvpwrvgnd_1
X_3397_ hold989/X _3396_/X _3461_/S VGND VGND VPWR VPWR _6172_/D sky130_fd_sc_hd__mux2_1
XFILLER_44_1335 VGND VGND VPWR VPWR sky130_fd_sc_hd__decap_3
X_6185_ _7036_/CLK _6185_/D fanout835/X VGND VGND VPWR VPWR _6185_/Q sky130_fd_sc_hd__dfrtp_2
XTAP_TAPCELL_ROW_4_304 VGND VPWR sky130_fd_sc_hd__tapvpwrvgnd_1
XTAP_TAPCELL_ROW_51_1525 VGND VPWR sky130_fd_sc_hd__tapvpwrvgnd_1
XTAP_TAPCELL_ROW_4_315 VGND VPWR sky130_fd_sc_hd__tapvpwrvgnd_1
XTAP_TAPCELL_ROW_51_1536 VGND VPWR sky130_fd_sc_hd__tapvpwrvgnd_1
Xload_slew760 fanout759/X VGND VGND VPWR VPWR load_slew760/X sky130_fd_sc_hd__buf_4
Xhold1502 _6520_/Q VGND VGND VPWR VPWR _5408_/A1 sky130_fd_sc_hd__dlygate4sd3_1
Xload_slew771 fanout770/X VGND VGND VPWR VPWR fanout768/A sky130_fd_sc_hd__clkbuf_4
XFILLER_29_205 VGND VGND VPWR VPWR sky130_fd_sc_hd__decap_3
XFILLER_44_1368 VGND VGND VPWR VPWR sky130_fd_sc_hd__decap_3
Xhold1513 _6539_/Q VGND VGND VPWR VPWR _5427_/A1 sky130_fd_sc_hd__dlygate4sd3_1
X_5136_ _6715_/Q _5298_/S VGND VGND VPWR VPWR _5136_/X sky130_fd_sc_hd__or2_2
Xload_slew782 fanout781/X VGND VGND VPWR VPWR load_slew782/X sky130_fd_sc_hd__buf_2
XFILLER_44_1379 VGND VGND VPWR VPWR sky130_fd_sc_hd__decap_3
Xhold1524 _6538_/Q VGND VGND VPWR VPWR _5426_/A1 sky130_fd_sc_hd__dlygate4sd3_1
Xhold1535 _6662_/Q VGND VGND VPWR VPWR _5589_/B2 sky130_fd_sc_hd__dlygate4sd3_1
Xhold1546 _6670_/Q VGND VGND VPWR VPWR _5598_/B2 sky130_fd_sc_hd__dlygate4sd3_1
XFILLER_57_558 VGND VGND VPWR VPWR sky130_fd_sc_hd__fill_2
Xhold1557 _6679_/Q VGND VGND VPWR VPWR _5608_/B2 sky130_fd_sc_hd__dlygate4sd3_1
X_5067_ _5065_/X _5066_/Y _5269_/A2 VGND VGND VPWR VPWR _5069_/S sky130_fd_sc_hd__a21oi_2
Xhold1568 _6616_/Q VGND VGND VPWR VPWR _5534_/A1 sky130_fd_sc_hd__dlygate4sd3_1
XFILLER_42_1081 VGND VGND VPWR VPWR sky130_fd_sc_hd__decap_3
XFILLER_26_912 VGND VGND VPWR VPWR sky130_fd_sc_hd__decap_3
XTAP_TAPCELL_ROW_28_918 VGND VPWR sky130_fd_sc_hd__tapvpwrvgnd_1
XFILLER_72_528 VGND VGND VPWR VPWR sky130_fd_sc_hd__decap_3
X_4018_ _6561_/Q _4588_/B _4123_/B2 VGND VGND VPWR VPWR _4018_/X sky130_fd_sc_hd__a21bo_2
XTAP_TAPCELL_ROW_28_929 VGND VPWR sky130_fd_sc_hd__tapvpwrvgnd_1
XFILLER_72_539 VGND VGND VPWR VPWR sky130_fd_sc_hd__decap_3
XFILLER_25_411 VGND VGND VPWR VPWR sky130_fd_sc_hd__fill_1
XFILLER_77_1133 VGND VGND VPWR VPWR sky130_fd_sc_hd__decap_3
XFILLER_25_433 VGND VGND VPWR VPWR sky130_fd_sc_hd__decap_3
XFILLER_37_293 VGND VGND VPWR VPWR sky130_fd_sc_hd__decap_3
XTAP_TAPCELL_ROW_49_1465 VGND VPWR sky130_fd_sc_hd__tapvpwrvgnd_1
XFILLER_52_230 VGND VGND VPWR VPWR sky130_fd_sc_hd__decap_3
XFILLER_53_753 VGND VGND VPWR VPWR sky130_fd_sc_hd__decap_3
XFILLER_77_1166 VGND VGND VPWR VPWR sky130_fd_sc_hd__decap_3
XTAP_TAPCELL_ROW_49_1476 VGND VPWR sky130_fd_sc_hd__tapvpwrvgnd_1
XFILLER_77_1177 VGND VGND VPWR VPWR sky130_fd_sc_hd__decap_3
XFILLER_13_606 VGND VGND VPWR VPWR sky130_fd_sc_hd__decap_3
XFILLER_80_561 VGND VGND VPWR VPWR sky130_fd_sc_hd__fill_1
XFILLER_13_617 VGND VGND VPWR VPWR sky130_fd_sc_hd__decap_3
XTAP_TAPCELL_ROW_49_1487 VGND VPWR sky130_fd_sc_hd__tapvpwrvgnd_1
XFILLER_12_105 VGND VGND VPWR VPWR sky130_fd_sc_hd__decap_3
XFILLER_55_1431 VGND VGND VPWR VPWR sky130_fd_sc_hd__decap_3
XFILLER_41_959 VGND VGND VPWR VPWR sky130_fd_sc_hd__decap_3
X_5969_ _5969_/A0 _6973_/Q _5998_/S VGND VGND VPWR VPWR _5969_/X sky130_fd_sc_hd__mux2_1
XFILLER_52_296 VGND VGND VPWR VPWR sky130_fd_sc_hd__decap_3
XFILLER_16_1415 VGND VGND VPWR VPWR sky130_fd_sc_hd__decap_3
XFILLER_32_12 VGND VGND VPWR VPWR sky130_fd_sc_hd__decap_3
XFILLER_8_109 VGND VGND VPWR VPWR sky130_fd_sc_hd__decap_3
XFILLER_40_469 VGND VGND VPWR VPWR sky130_fd_sc_hd__decap_3
XFILLER_51_1328 VGND VGND VPWR VPWR sky130_fd_sc_hd__decap_3
XFILLER_16_1459 VGND VGND VPWR VPWR sky130_fd_sc_hd__decap_3
XFILLER_32_78 VGND VGND VPWR VPWR sky130_fd_sc_hd__decap_3
XFILLER_5_838 VGND VGND VPWR VPWR sky130_fd_sc_hd__fill_2
XFILLER_4_348 VGND VGND VPWR VPWR sky130_fd_sc_hd__decap_3
XFILLER_49_1257 VGND VGND VPWR VPWR sky130_fd_sc_hd__decap_3
XFILLER_62_1424 VGND VGND VPWR VPWR sky130_fd_sc_hd__decap_3
XFILLER_0_554 VGND VGND VPWR VPWR sky130_fd_sc_hd__decap_3
XFILLER_62_1435 VGND VGND VPWR VPWR sky130_fd_sc_hd__decap_3
XFILLER_0_576 VGND VGND VPWR VPWR sky130_fd_sc_hd__decap_3
XFILLER_23_1419 VGND VGND VPWR VPWR sky130_fd_sc_hd__decap_3
XFILLER_57_42 VGND VGND VPWR VPWR sky130_fd_sc_hd__decap_3
XFILLER_62_1468 VGND VGND VPWR VPWR sky130_fd_sc_hd__fill_1
XFILLER_0_598 VGND VGND VPWR VPWR sky130_fd_sc_hd__decap_3
XFILLER_48_536 VGND VGND VPWR VPWR sky130_fd_sc_hd__decap_3
XFILLER_5_1340 VGND VGND VPWR VPWR sky130_fd_sc_hd__decap_3
XFILLER_76_878 VGND VGND VPWR VPWR sky130_fd_sc_hd__decap_3
XFILLER_5_1351 VGND VGND VPWR VPWR sky130_fd_sc_hd__decap_3
XFILLER_1_1204 VGND VGND VPWR VPWR sky130_fd_sc_hd__decap_3
XFILLER_21_1132 VGND VGND VPWR VPWR sky130_fd_sc_hd__decap_3
XFILLER_35_208 VGND VGND VPWR VPWR sky130_fd_sc_hd__fill_1
XFILLER_63_517 VGND VGND VPWR VPWR sky130_fd_sc_hd__decap_3
XFILLER_5_1384 VGND VGND VPWR VPWR sky130_fd_sc_hd__decap_3
XFILLER_17_923 VGND VGND VPWR VPWR sky130_fd_sc_hd__decap_3
XFILLER_75_399 VGND VGND VPWR VPWR sky130_fd_sc_hd__decap_3
XFILLER_29_794 VGND VGND VPWR VPWR sky130_fd_sc_hd__decap_3
XFILLER_16_411 VGND VGND VPWR VPWR sky130_fd_sc_hd__decap_3
XFILLER_44_720 VGND VGND VPWR VPWR sky130_fd_sc_hd__fill_2
XFILLER_1_1248 VGND VGND VPWR VPWR sky130_fd_sc_hd__decap_3
XFILLER_73_30 VGND VGND VPWR VPWR sky130_fd_sc_hd__decap_3
XFILLER_17_956 VGND VGND VPWR VPWR sky130_fd_sc_hd__decap_3
XFILLER_44_742 VGND VGND VPWR VPWR sky130_fd_sc_hd__decap_3
XFILLER_32_904 VGND VGND VPWR VPWR sky130_fd_sc_hd__decap_3
XFILLER_44_764 VGND VGND VPWR VPWR sky130_fd_sc_hd__decap_3
XFILLER_73_63 VGND VGND VPWR VPWR sky130_fd_sc_hd__decap_3
XFILLER_17_989 VGND VGND VPWR VPWR sky130_fd_sc_hd__decap_3
XFILLER_16_477 VGND VGND VPWR VPWR sky130_fd_sc_hd__decap_3
XFILLER_31_414 VGND VGND VPWR VPWR sky130_fd_sc_hd__fill_2
XFILLER_32_937 VGND VGND VPWR VPWR sky130_fd_sc_hd__decap_3
XFILLER_40_992 VGND VGND VPWR VPWR sky130_fd_sc_hd__decap_3
XFILLER_32_1250 VGND VGND VPWR VPWR sky130_fd_sc_hd__decap_3
XFILLER_32_1261 VGND VGND VPWR VPWR sky130_fd_sc_hd__decap_3
XFILLER_8_698 VGND VGND VPWR VPWR sky130_fd_sc_hd__fill_2
XFILLER_32_1294 VGND VGND VPWR VPWR sky130_fd_sc_hd__decap_3
XFILLER_67_1313 VGND VGND VPWR VPWR sky130_fd_sc_hd__decap_3
X_3320_ _6287_/Q _6391_/Q VGND VGND VPWR VPWR _3320_/X sky130_fd_sc_hd__xor2_2
XFILLER_67_1357 VGND VGND VPWR VPWR sky130_fd_sc_hd__decap_3
XFILLER_4_882 VGND VGND VPWR VPWR sky130_fd_sc_hd__decap_3
X_3251_ _5946_/A0 _3250_/X _3379_/S VGND VGND VPWR VPWR _6099_/D sky130_fd_sc_hd__mux2_1
XFILLER_26_1032 VGND VGND VPWR VPWR sky130_fd_sc_hd__decap_3
XFILLER_21_3 VGND VGND VPWR VPWR sky130_fd_sc_hd__decap_3
X_3182_ _7062_/Q _3181_/X _3225_/S VGND VGND VPWR VPWR wire30/A sky130_fd_sc_hd__mux2_1
XFILLER_6_1126 VGND VGND VPWR VPWR sky130_fd_sc_hd__decap_3
XFILLER_26_1076 VGND VGND VPWR VPWR sky130_fd_sc_hd__decap_3
XFILLER_67_856 VGND VGND VPWR VPWR sky130_fd_sc_hd__decap_3
XFILLER_43_1390 VGND VGND VPWR VPWR sky130_fd_sc_hd__decap_3
XFILLER_66_388 VGND VGND VPWR VPWR sky130_fd_sc_hd__decap_3
X_6941_ _6970_/CLK _6941_/D fanout672/X VGND VGND VPWR VPWR _6941_/Q sky130_fd_sc_hd__dfrtp_2
XFILLER_19_271 VGND VGND VPWR VPWR sky130_fd_sc_hd__decap_3
XFILLER_78_1453 VGND VGND VPWR VPWR sky130_fd_sc_hd__decap_3
XFILLER_39_1404 VGND VGND VPWR VPWR sky130_fd_sc_hd__decap_3
XFILLER_35_753 VGND VGND VPWR VPWR sky130_fd_sc_hd__decap_3
XFILLER_74_1306 VGND VGND VPWR VPWR sky130_fd_sc_hd__decap_3
XFILLER_74_1317 VGND VGND VPWR VPWR sky130_fd_sc_hd__decap_3
XFILLER_34_241 VGND VGND VPWR VPWR sky130_fd_sc_hd__decap_3
X_6872_ _7032_/CLK _6872_/D fanout697/X VGND VGND VPWR VPWR _6872_/Q sky130_fd_sc_hd__dfrtp_2
XFILLER_39_1437 VGND VGND VPWR VPWR sky130_fd_sc_hd__decap_3
XFILLER_50_701 VGND VGND VPWR VPWR sky130_fd_sc_hd__decap_3
XPHY_EDGE_ROW_22_Left_103 VGND VGND VPWR VPWR sky130_fd_sc_hd__decap_3
XFILLER_23_926 VGND VGND VPWR VPWR sky130_fd_sc_hd__decap_3
XFILLER_35_797 VGND VGND VPWR VPWR sky130_fd_sc_hd__decap_3
XFILLER_62_572 VGND VGND VPWR VPWR sky130_fd_sc_hd__decap_3
X_5823_ _5924_/A _5915_/B _5850_/B VGND VGND VPWR VPWR _5831_/S sky130_fd_sc_hd__or3_2
XFILLER_34_285 VGND VGND VPWR VPWR sky130_fd_sc_hd__fill_2
XTAP_TAPCELL_ROW_44_1340 VGND VPWR sky130_fd_sc_hd__tapvpwrvgnd_1
XTAP_TAPCELL_ROW_44_1351 VGND VPWR sky130_fd_sc_hd__tapvpwrvgnd_1
X_5754_ _5795_/C _5754_/A1 _5757_/S VGND VGND VPWR VPWR _6798_/D sky130_fd_sc_hd__mux2_1
XFILLER_37_1183 VGND VGND VPWR VPWR sky130_fd_sc_hd__fill_2
X_4705_ _4880_/C1 _4702_/X _4703_/Y _4704_/X _4683_/A VGND VGND VPWR VPWR _4705_/X
+ sky130_fd_sc_hd__o221a_2
XFILLER_33_1047 VGND VGND VPWR VPWR sky130_fd_sc_hd__decap_3
XTAP_TAPCELL_ROW_40_1237 VGND VPWR sky130_fd_sc_hd__tapvpwrvgnd_1
XTAP_TAPCELL_ROW_40_1248 VGND VPWR sky130_fd_sc_hd__tapvpwrvgnd_1
X_5685_ _5758_/B _5722_/A _5685_/C VGND VGND VPWR VPWR _5693_/S sky130_fd_sc_hd__and3b_2
XFILLER_11_1301 VGND VGND VPWR VPWR sky130_fd_sc_hd__decap_3
XFILLER_50_1350 VGND VGND VPWR VPWR sky130_fd_sc_hd__decap_3
X_4636_ _6307_/Q _4635_/X wire49/X VGND VGND VPWR VPWR _6307_/D sky130_fd_sc_hd__mux2_1
XFILLER_11_1334 VGND VGND VPWR VPWR sky130_fd_sc_hd__decap_3
XFILLER_11_1345 VGND VGND VPWR VPWR sky130_fd_sc_hd__decap_3
XFILLER_50_1394 VGND VGND VPWR VPWR sky130_fd_sc_hd__decap_3
X_4567_ _6322_/Q _4743_/A2 _3358_/X _4743_/B2 VGND VGND VPWR VPWR _4567_/X sky130_fd_sc_hd__a22o_2
XFILLER_11_1378 VGND VGND VPWR VPWR sky130_fd_sc_hd__decap_3
XFILLER_2_819 VGND VGND VPWR VPWR sky130_fd_sc_hd__decap_3
XPHY_EDGE_ROW_31_Left_112 VGND VGND VPWR VPWR sky130_fd_sc_hd__decap_3
XTAP_TAPCELL_ROW_9_429 VGND VPWR sky130_fd_sc_hd__tapvpwrvgnd_1
X_6306_ _7015_/CLK _6306_/D load_slew801/X VGND VGND VPWR VPWR _6306_/Q sky130_fd_sc_hd__dfrtp_2
X_3518_ _6630_/Q _4312_/A _5607_/A2 _6638_/Q _5576_/A2 VGND VGND VPWR VPWR _3518_/X
+ sky130_fd_sc_hd__a221o_2
X_4498_ _4619_/A1 _4495_/X _4496_/Y _4497_/X _4881_/A VGND VGND VPWR VPWR _4498_/X
+ sky130_fd_sc_hd__o221a_2
XTAP_TAPCELL_ROW_38_1177 VGND VPWR sky130_fd_sc_hd__tapvpwrvgnd_1
XTAP_TAPCELL_ROW_38_1188 VGND VPWR sky130_fd_sc_hd__tapvpwrvgnd_1
X_6237_ _6999_/CLK _6237_/D wire827/X VGND VGND VPWR VPWR _6237_/Q sky130_fd_sc_hd__dfrtp_2
X_3449_ hold892/X _3448_/X _3465_/S VGND VGND VPWR VPWR _6198_/D sky130_fd_sc_hd__mux2_1
XTAP_TAPCELL_ROW_38_1199 VGND VPWR sky130_fd_sc_hd__tapvpwrvgnd_1
X_6168_ _6987_/CLK _6168_/D load_slew837/X VGND VGND VPWR VPWR _6168_/Q sky130_fd_sc_hd__dfrtp_2
Xhold1310 _6760_/Q VGND VGND VPWR VPWR _5711_/A1 sky130_fd_sc_hd__dlygate4sd3_1
Xhold1321 _6932_/Q VGND VGND VPWR VPWR _5927_/A1 sky130_fd_sc_hd__dlygate4sd3_1
XFILLER_57_333 VGND VGND VPWR VPWR sky130_fd_sc_hd__decap_3
Xhold1332 _6846_/Q VGND VGND VPWR VPWR _5828_/A1 sky130_fd_sc_hd__dlygate4sd3_1
X_5119_ _6470_/Q _5119_/B VGND VGND VPWR VPWR _5120_/B sky130_fd_sc_hd__xnor2_2
XFILLER_40_1029 VGND VGND VPWR VPWR sky130_fd_sc_hd__decap_3
Xhold1343 _6627_/Q VGND VGND VPWR VPWR _5544_/B1 sky130_fd_sc_hd__dlygate4sd3_1
Xhold1354 _6775_/Q VGND VGND VPWR VPWR _5728_/A1 sky130_fd_sc_hd__dlygate4sd3_1
XFILLER_57_355 VGND VGND VPWR VPWR sky130_fd_sc_hd__decap_3
XFILLER_58_878 VGND VGND VPWR VPWR sky130_fd_sc_hd__fill_2
XFILLER_22_1441 VGND VGND VPWR VPWR sky130_fd_sc_hd__decap_3
X_6099_ _6990_/CLK _6099_/D fanout752/X VGND VGND VPWR VPWR _6099_/Q sky130_fd_sc_hd__dfrtp_2
XFILLER_79_1228 VGND VGND VPWR VPWR sky130_fd_sc_hd__decap_3
Xhold1365 _6852_/Q VGND VGND VPWR VPWR _5835_/A1 sky130_fd_sc_hd__dlygate4sd3_1
XFILLER_79_1239 VGND VGND VPWR VPWR sky130_fd_sc_hd__decap_3
Xhold1376 _6828_/Q VGND VGND VPWR VPWR _5808_/A1 sky130_fd_sc_hd__dlygate4sd3_1
Xhold1387 _6546_/Q VGND VGND VPWR VPWR _5434_/A1 sky130_fd_sc_hd__dlygate4sd3_1
XFILLER_57_388 VGND VGND VPWR VPWR sky130_fd_sc_hd__decap_3
Xhold1398 _6893_/Q VGND VGND VPWR VPWR _5883_/A1 sky130_fd_sc_hd__dlygate4sd3_1
XFILLER_57_399 VGND VGND VPWR VPWR sky130_fd_sc_hd__decap_3
XPHY_EDGE_ROW_40_Left_121 VGND VGND VPWR VPWR sky130_fd_sc_hd__decap_3
XFILLER_26_742 VGND VGND VPWR VPWR sky130_fd_sc_hd__decap_3
XFILLER_53_550 VGND VGND VPWR VPWR sky130_fd_sc_hd__decap_3
XFILLER_26_786 VGND VGND VPWR VPWR sky130_fd_sc_hd__decap_3
XFILLER_25_263 VGND VGND VPWR VPWR sky130_fd_sc_hd__decap_3
XFILLER_53_572 VGND VGND VPWR VPWR sky130_fd_sc_hd__fill_2
XFILLER_0_1270 VGND VGND VPWR VPWR sky130_fd_sc_hd__decap_3
XFILLER_40_200 VGND VGND VPWR VPWR sky130_fd_sc_hd__fill_2
XFILLER_13_425 VGND VGND VPWR VPWR sky130_fd_sc_hd__decap_3
XFILLER_0_1292 VGND VGND VPWR VPWR sky130_fd_sc_hd__decap_3
XFILLER_43_44 VGND VGND VPWR VPWR sky130_fd_sc_hd__decap_3
XFILLER_9_429 VGND VGND VPWR VPWR sky130_fd_sc_hd__decap_3
XFILLER_16_1223 VGND VGND VPWR VPWR sky130_fd_sc_hd__decap_3
XFILLER_43_77 VGND VGND VPWR VPWR sky130_fd_sc_hd__decap_3
XFILLER_55_1272 VGND VGND VPWR VPWR sky130_fd_sc_hd__decap_3
XFILLER_51_1114 VGND VGND VPWR VPWR sky130_fd_sc_hd__decap_3
XFILLER_22_981 VGND VGND VPWR VPWR sky130_fd_sc_hd__decap_3
XFILLER_16_1256 VGND VGND VPWR VPWR sky130_fd_sc_hd__decap_3
XFILLER_16_1267 VGND VGND VPWR VPWR sky130_fd_sc_hd__decap_3
XFILLER_5_635 VGND VGND VPWR VPWR sky130_fd_sc_hd__fill_1
XFILLER_5_657 VGND VGND VPWR VPWR sky130_fd_sc_hd__decap_3
XFILLER_4_134 VGND VGND VPWR VPWR sky130_fd_sc_hd__decap_3
XFILLER_5_679 VGND VGND VPWR VPWR sky130_fd_sc_hd__decap_3
XFILLER_49_1032 VGND VGND VPWR VPWR sky130_fd_sc_hd__decap_3
XFILLER_4_27 VGND VGND VPWR VPWR sky130_fd_sc_hd__fill_1
XFILLER_4_38 VGND VGND VPWR VPWR sky130_fd_sc_hd__decap_3
XFILLER_49_1076 VGND VGND VPWR VPWR sky130_fd_sc_hd__decap_3
XFILLER_1_830 VGND VGND VPWR VPWR sky130_fd_sc_hd__decap_3
XFILLER_1_841 VGND VGND VPWR VPWR sky130_fd_sc_hd__decap_3
XFILLER_68_41 VGND VGND VPWR VPWR sky130_fd_sc_hd__decap_3
XFILLER_7_1413 VGND VGND VPWR VPWR sky130_fd_sc_hd__decap_3
XFILLER_0_340 VGND VGND VPWR VPWR sky130_fd_sc_hd__decap_3
XFILLER_1_874 VGND VGND VPWR VPWR sky130_fd_sc_hd__decap_3
XFILLER_62_1232 VGND VGND VPWR VPWR sky130_fd_sc_hd__decap_3
XFILLER_27_1363 VGND VGND VPWR VPWR sky130_fd_sc_hd__decap_3
XFILLER_48_300 VGND VGND VPWR VPWR sky130_fd_sc_hd__decap_3
XFILLER_67_119 VGND VGND VPWR VPWR sky130_fd_sc_hd__decap_3
XFILLER_68_85 VGND VGND VPWR VPWR sky130_fd_sc_hd__decap_3
XFILLER_7_1446 VGND VGND VPWR VPWR sky130_fd_sc_hd__decap_3
XFILLER_7_1457 VGND VGND VPWR VPWR sky130_fd_sc_hd__decap_3
XFILLER_23_1227 VGND VGND VPWR VPWR sky130_fd_sc_hd__decap_3
XFILLER_48_322 VGND VGND VPWR VPWR sky130_fd_sc_hd__fill_2
XFILLER_62_1276 VGND VGND VPWR VPWR sky130_fd_sc_hd__decap_3
XFILLER_27_1396 VGND VGND VPWR VPWR sky130_fd_sc_hd__decap_3
XFILLER_36_506 VGND VGND VPWR VPWR sky130_fd_sc_hd__decap_3
XTAP_TAPCELL_ROW_19_704 VGND VPWR sky130_fd_sc_hd__tapvpwrvgnd_1
XFILLER_64_826 VGND VGND VPWR VPWR sky130_fd_sc_hd__fill_1
XFILLER_76_686 VGND VGND VPWR VPWR sky130_fd_sc_hd__fill_2
XFILLER_1_1001 VGND VGND VPWR VPWR sky130_fd_sc_hd__decap_3
XFILLER_1_1012 VGND VGND VPWR VPWR sky130_fd_sc_hd__decap_3
XFILLER_64_848 VGND VGND VPWR VPWR sky130_fd_sc_hd__decap_3
XFILLER_5_1192 VGND VGND VPWR VPWR sky130_fd_sc_hd__decap_3
XFILLER_75_196 VGND VGND VPWR VPWR sky130_fd_sc_hd__fill_2
XFILLER_1_1045 VGND VGND VPWR VPWR sky130_fd_sc_hd__decap_3
XFILLER_17_764 VGND VGND VPWR VPWR sky130_fd_sc_hd__decap_3
XFILLER_56_1003 VGND VGND VPWR VPWR sky130_fd_sc_hd__decap_3
XFILLER_32_701 VGND VGND VPWR VPWR sky130_fd_sc_hd__decap_3
XFILLER_1_1089 VGND VGND VPWR VPWR sky130_fd_sc_hd__decap_3
XFILLER_17_797 VGND VGND VPWR VPWR sky130_fd_sc_hd__decap_3
XFILLER_44_583 VGND VGND VPWR VPWR sky130_fd_sc_hd__decap_3
XFILLER_31_200 VGND VGND VPWR VPWR sky130_fd_sc_hd__decap_3
XFILLER_16_285 VGND VGND VPWR VPWR sky130_fd_sc_hd__fill_1
XFILLER_71_391 VGND VGND VPWR VPWR sky130_fd_sc_hd__fill_1
XFILLER_17_1009 VGND VGND VPWR VPWR sky130_fd_sc_hd__fill_1
XTAP_TAPCELL_ROW_80_2274 VGND VPWR sky130_fd_sc_hd__tapvpwrvgnd_1
XFILLER_20_907 VGND VGND VPWR VPWR sky130_fd_sc_hd__decap_3
XTAP_TAPCELL_ROW_80_2285 VGND VPWR sky130_fd_sc_hd__tapvpwrvgnd_1
XTAP_TAPCELL_ROW_80_2296 VGND VPWR sky130_fd_sc_hd__tapvpwrvgnd_1
XFILLER_32_789 VGND VGND VPWR VPWR sky130_fd_sc_hd__decap_3
XFILLER_34_1312 VGND VGND VPWR VPWR sky130_fd_sc_hd__decap_3
XFILLER_73_1372 VGND VGND VPWR VPWR sky130_fd_sc_hd__decap_3
XFILLER_34_1323 VGND VGND VPWR VPWR sky130_fd_sc_hd__decap_3
XFILLER_34_1356 VGND VGND VPWR VPWR sky130_fd_sc_hd__decap_3
XFILLER_12_480 VGND VGND VPWR VPWR sky130_fd_sc_hd__fill_2
XFILLER_8_451 VGND VGND VPWR VPWR sky130_fd_sc_hd__decap_3
XTAP_TAPCELL_ROW_30_968 VGND VPWR sky130_fd_sc_hd__tapvpwrvgnd_1
XTAP_TAPCELL_ROW_30_979 VGND VPWR sky130_fd_sc_hd__tapvpwrvgnd_1
X_5470_ _5470_/A1 _5470_/A2 _4831_/X VGND VGND VPWR VPWR _6582_/D sky130_fd_sc_hd__a21o_2
XFILLER_69_3 VGND VGND VPWR VPWR sky130_fd_sc_hd__decap_3
XFILLER_69_1419 VGND VGND VPWR VPWR sky130_fd_sc_hd__decap_3
X_4421_ _4008_/A _4420_/X _4360_/X _6511_/Q VGND VGND VPWR VPWR _4421_/X sky130_fd_sc_hd__a2bb2o_2
X_4352_ _6343_/Q wire503/X _3272_/X wire383/X VGND VGND VPWR VPWR _4352_/X sky130_fd_sc_hd__a22o_2
XFILLER_28_1138 VGND VGND VPWR VPWR sky130_fd_sc_hd__decap_3
X_3303_ hold900/X _3302_/X _3425_/S VGND VGND VPWR VPWR _6125_/D sky130_fd_sc_hd__mux2_1
X_4283_ _4283_/A _4851_/B VGND VGND VPWR VPWR _4283_/Y sky130_fd_sc_hd__nand2_2
X_7071_ _7072_/CLK _7071_/D wire687/X VGND VGND VPWR VPWR _7071_/Q sky130_fd_sc_hd__dfrtp_2
XFILLER_67_1198 VGND VGND VPWR VPWR sky130_fd_sc_hd__decap_3
XFILLER_80_1310 VGND VGND VPWR VPWR sky130_fd_sc_hd__decap_3
XFILLER_80_1332 VGND VGND VPWR VPWR sky130_fd_sc_hd__decap_3
XFILLER_58_108 VGND VGND VPWR VPWR sky130_fd_sc_hd__decap_3
XFILLER_45_1452 VGND VGND VPWR VPWR sky130_fd_sc_hd__decap_3
X_3234_ _6252_/Q _6348_/Q VGND VGND VPWR VPWR _3234_/X sky130_fd_sc_hd__xor2_2
X_6022_ hold871/X _7026_/Q _6033_/S VGND VGND VPWR VPWR _6022_/X sky130_fd_sc_hd__mux2_1
XFILLER_45_1463 VGND VGND VPWR VPWR sky130_fd_sc_hd__decap_3
XFILLER_80_1354 VGND VGND VPWR VPWR sky130_fd_sc_hd__decap_3
XFILLER_39_311 VGND VGND VPWR VPWR sky130_fd_sc_hd__decap_3
XFILLER_41_1316 VGND VGND VPWR VPWR sky130_fd_sc_hd__decap_3
XFILLER_80_1376 VGND VGND VPWR VPWR sky130_fd_sc_hd__decap_3
XTAP_TAPCELL_ROW_33_1052 VGND VPWR sky130_fd_sc_hd__tapvpwrvgnd_1
XTAP_TAPCELL_ROW_33_1063 VGND VPWR sky130_fd_sc_hd__tapvpwrvgnd_1
XFILLER_39_344 VGND VGND VPWR VPWR sky130_fd_sc_hd__fill_2
X_3165_ _6075_/S _7075_/Q _6941_/Q VGND VGND VPWR VPWR _3165_/X sky130_fd_sc_hd__and3_2
XFILLER_66_141 VGND VGND VPWR VPWR sky130_fd_sc_hd__fill_1
XFILLER_67_686 VGND VGND VPWR VPWR sky130_fd_sc_hd__decap_3
X_3096_ _3077_/B _7082_/Q VGND VGND VPWR VPWR _3097_/B sky130_fd_sc_hd__and2b_2
XFILLER_78_1250 VGND VGND VPWR VPWR sky130_fd_sc_hd__decap_3
X_6924_ _7015_/CLK _6924_/D fanout797/X VGND VGND VPWR VPWR _6924_/Q sky130_fd_sc_hd__dfrtp_2
XFILLER_78_1261 VGND VGND VPWR VPWR sky130_fd_sc_hd__decap_3
XFILLER_70_829 VGND VGND VPWR VPWR sky130_fd_sc_hd__decap_3
XFILLER_35_550 VGND VGND VPWR VPWR sky130_fd_sc_hd__decap_3
XTAP_TAPCELL_ROW_46_1402 VGND VPWR sky130_fd_sc_hd__tapvpwrvgnd_1
XFILLER_35_561 VGND VGND VPWR VPWR sky130_fd_sc_hd__decap_3
XFILLER_74_1114 VGND VGND VPWR VPWR sky130_fd_sc_hd__decap_3
XFILLER_78_1294 VGND VGND VPWR VPWR sky130_fd_sc_hd__decap_3
XFILLER_39_1245 VGND VGND VPWR VPWR sky130_fd_sc_hd__decap_3
XFILLER_22_200 VGND VGND VPWR VPWR sky130_fd_sc_hd__decap_3
Xfanout15 _3915_/X VGND VGND VPWR VPWR _5609_/A3 sky130_fd_sc_hd__clkdlybuf4s25_1
X_6855_ _6863_/CLK _6855_/D fanout797/X VGND VGND VPWR VPWR _6855_/Q sky130_fd_sc_hd__dfrtp_2
XFILLER_74_1147 VGND VGND VPWR VPWR sky130_fd_sc_hd__fill_1
XFILLER_74_1158 VGND VGND VPWR VPWR sky130_fd_sc_hd__decap_3
XFILLER_39_1278 VGND VGND VPWR VPWR sky130_fd_sc_hd__decap_3
XFILLER_23_767 VGND VGND VPWR VPWR sky130_fd_sc_hd__decap_3
XFILLER_39_1289 VGND VGND VPWR VPWR sky130_fd_sc_hd__decap_3
XFILLER_50_542 VGND VGND VPWR VPWR sky130_fd_sc_hd__fill_1
Xfanout37 fanout47/X VGND VGND VPWR VPWR _4891_/B1 sky130_fd_sc_hd__clkdlybuf4s25_1
Xfanout48 wire52/X VGND VGND VPWR VPWR wire49/A sky130_fd_sc_hd__clkdlybuf4s25_1
X_5806_ _5784_/C _5806_/A1 _5813_/S VGND VGND VPWR VPWR _6826_/D sky130_fd_sc_hd__mux2_1
Xfanout59 _4759_/A2 VGND VGND VPWR VPWR wire60/A sky130_fd_sc_hd__clkdlybuf4s25_1
XFILLER_50_564 VGND VGND VPWR VPWR sky130_fd_sc_hd__decap_3
XFILLER_52_1412 VGND VGND VPWR VPWR sky130_fd_sc_hd__decap_3
X_6786_ _7050_/CLK _6786_/D load_slew645/X VGND VGND VPWR VPWR _6786_/Q sky130_fd_sc_hd__dfrtp_2
XFILLER_10_417 VGND VGND VPWR VPWR sky130_fd_sc_hd__decap_3
X_3998_ _6534_/Q _4422_/A _4061_/A1 VGND VGND VPWR VPWR _3998_/X sky130_fd_sc_hd__a21bo_2
XFILLER_13_36 VGND VGND VPWR VPWR sky130_fd_sc_hd__decap_3
XFILLER_22_288 VGND VGND VPWR VPWR sky130_fd_sc_hd__decap_3
XFILLER_50_597 VGND VGND VPWR VPWR sky130_fd_sc_hd__decap_3
XFILLER_13_1407 VGND VGND VPWR VPWR sky130_fd_sc_hd__decap_3
X_5737_ _5903_/A0 _5737_/A1 _5739_/S VGND VGND VPWR VPWR _6783_/D sky130_fd_sc_hd__mux2_1
XFILLER_52_1456 VGND VGND VPWR VPWR sky130_fd_sc_hd__decap_3
X_5668_ _5668_/A0 _5784_/C _5674_/S VGND VGND VPWR VPWR _6722_/D sky130_fd_sc_hd__mux2_1
X_4619_ _4619_/A1 _4616_/X _4617_/Y _4618_/X _4881_/A VGND VGND VPWR VPWR _4619_/X
+ sky130_fd_sc_hd__o221a_2
X_5599_ _3491_/X _5578_/Y _5593_/Y _5599_/B2 VGND VGND VPWR VPWR _6671_/D sky130_fd_sc_hd__a22o_2
XFILLER_2_616 VGND VGND VPWR VPWR sky130_fd_sc_hd__decap_3
XFILLER_11_1186 VGND VGND VPWR VPWR sky130_fd_sc_hd__decap_3
XFILLER_46_1205 VGND VGND VPWR VPWR sky130_fd_sc_hd__fill_1
XFILLER_1_137 VGND VGND VPWR VPWR sky130_fd_sc_hd__decap_3
XFILLER_46_1238 VGND VGND VPWR VPWR sky130_fd_sc_hd__decap_3
XFILLER_58_620 VGND VGND VPWR VPWR sky130_fd_sc_hd__decap_3
Xhold1140 _5979_/X VGND VGND VPWR VPWR _6983_/D sky130_fd_sc_hd__dlygate4sd3_1
Xhold1151 _6799_/Q VGND VGND VPWR VPWR _5755_/A1 sky130_fd_sc_hd__dlygate4sd3_1
XFILLER_58_686 VGND VGND VPWR VPWR sky130_fd_sc_hd__decap_3
Xhold1162 _6809_/Q VGND VGND VPWR VPWR _5766_/A1 sky130_fd_sc_hd__dlygate4sd3_1
XFILLER_46_837 VGND VGND VPWR VPWR sky130_fd_sc_hd__fill_1
XFILLER_73_623 VGND VGND VPWR VPWR sky130_fd_sc_hd__fill_1
Xhold1173 _7041_/Q VGND VGND VPWR VPWR _6037_/A1 sky130_fd_sc_hd__dlygate4sd3_1
XFILLER_72_111 VGND VGND VPWR VPWR sky130_fd_sc_hd__decap_3
XFILLER_2_1332 VGND VGND VPWR VPWR sky130_fd_sc_hd__decap_3
Xhold1184 _6943_/Q VGND VGND VPWR VPWR _5939_/A1 sky130_fd_sc_hd__dlygate4sd3_1
Xhold1195 _6136_/Q VGND VGND VPWR VPWR _5983_/A0 sky130_fd_sc_hd__dlygate4sd3_1
XFILLER_22_1282 VGND VGND VPWR VPWR sky130_fd_sc_hd__decap_3
XFILLER_72_144 VGND VGND VPWR VPWR sky130_fd_sc_hd__decap_3
XFILLER_2_1365 VGND VGND VPWR VPWR sky130_fd_sc_hd__decap_3
XFILLER_57_1301 VGND VGND VPWR VPWR sky130_fd_sc_hd__decap_3
XFILLER_2_1376 VGND VGND VPWR VPWR sky130_fd_sc_hd__decap_3
XFILLER_61_829 VGND VGND VPWR VPWR sky130_fd_sc_hd__decap_3
XFILLER_14_712 VGND VGND VPWR VPWR sky130_fd_sc_hd__decap_3
XTAP_TAPCELL_ROW_0_170 VGND VPWR sky130_fd_sc_hd__tapvpwrvgnd_1
XFILLER_26_572 VGND VGND VPWR VPWR sky130_fd_sc_hd__fill_2
XFILLER_57_1334 VGND VGND VPWR VPWR sky130_fd_sc_hd__decap_3
XTAP_TAPCELL_ROW_0_181 VGND VPWR sky130_fd_sc_hd__tapvpwrvgnd_1
XFILLER_57_1345 VGND VGND VPWR VPWR sky130_fd_sc_hd__decap_3
XTAP_TAPCELL_ROW_0_192 VGND VPWR sky130_fd_sc_hd__tapvpwrvgnd_1
XFILLER_13_222 VGND VGND VPWR VPWR sky130_fd_sc_hd__fill_2
XFILLER_53_391 VGND VGND VPWR VPWR sky130_fd_sc_hd__fill_1
XFILLER_18_1329 VGND VGND VPWR VPWR sky130_fd_sc_hd__decap_3
XFILLER_57_1378 VGND VGND VPWR VPWR sky130_fd_sc_hd__decap_3
XFILLER_14_778 VGND VGND VPWR VPWR sky130_fd_sc_hd__fill_1
XFILLER_41_564 VGND VGND VPWR VPWR sky130_fd_sc_hd__fill_2
XFILLER_41_575 VGND VGND VPWR VPWR sky130_fd_sc_hd__decap_3
XFILLER_9_237 VGND VGND VPWR VPWR sky130_fd_sc_hd__decap_3
XFILLER_70_53 VGND VGND VPWR VPWR sky130_fd_sc_hd__fill_2
XFILLER_10_940 VGND VGND VPWR VPWR sky130_fd_sc_hd__fill_2
XFILLER_6_911 VGND VGND VPWR VPWR sky130_fd_sc_hd__decap_3
XFILLER_10_973 VGND VGND VPWR VPWR sky130_fd_sc_hd__decap_3
Xclkload18 _6882_/CLK VGND VGND VPWR VPWR clkload18/X sky130_fd_sc_hd__clkbuf_4
XTAP_TAPCELL_ROW_11_478 VGND VPWR sky130_fd_sc_hd__tapvpwrvgnd_1
Xclkload29 _6912_/CLK VGND VGND VPWR VPWR clkload29/X sky130_fd_sc_hd__clkbuf_8
XTAP_TAPCELL_ROW_11_489 VGND VPWR sky130_fd_sc_hd__tapvpwrvgnd_1
XFILLER_6_977 VGND VGND VPWR VPWR sky130_fd_sc_hd__decap_3
XFILLER_55_9 VGND VGND VPWR VPWR sky130_fd_sc_hd__decap_3
XFILLER_68_1441 VGND VGND VPWR VPWR sky130_fd_sc_hd__decap_3
XFILLER_5_476 VGND VGND VPWR VPWR sky130_fd_sc_hd__decap_3
XFILLER_79_51 VGND VGND VPWR VPWR sky130_fd_sc_hd__decap_3
XFILLER_29_1425 VGND VGND VPWR VPWR sky130_fd_sc_hd__decap_3
XFILLER_79_84 VGND VGND VPWR VPWR sky130_fd_sc_hd__decap_3
XFILLER_64_1338 VGND VGND VPWR VPWR sky130_fd_sc_hd__decap_3
XFILLER_68_417 VGND VGND VPWR VPWR sky130_fd_sc_hd__decap_3
XFILLER_1_660 VGND VGND VPWR VPWR sky130_fd_sc_hd__decap_3
XFILLER_7_1210 VGND VGND VPWR VPWR sky130_fd_sc_hd__decap_3
XFILLER_1_682 VGND VGND VPWR VPWR sky130_fd_sc_hd__decap_3
XFILLER_49_620 VGND VGND VPWR VPWR sky130_fd_sc_hd__fill_2
XFILLER_62_1040 VGND VGND VPWR VPWR sky130_fd_sc_hd__decap_3
XFILLER_23_1002 VGND VGND VPWR VPWR sky130_fd_sc_hd__decap_3
XFILLER_7_1254 VGND VGND VPWR VPWR sky130_fd_sc_hd__decap_3
XFILLER_0_181 VGND VGND VPWR VPWR sky130_fd_sc_hd__decap_3
XFILLER_49_642 VGND VGND VPWR VPWR sky130_fd_sc_hd__decap_3
XFILLER_3_1107 VGND VGND VPWR VPWR sky130_fd_sc_hd__decap_3
XFILLER_48_141 VGND VGND VPWR VPWR sky130_fd_sc_hd__decap_3
XFILLER_76_461 VGND VGND VPWR VPWR sky130_fd_sc_hd__decap_3
XFILLER_7_1287 VGND VGND VPWR VPWR sky130_fd_sc_hd__fill_1
XFILLER_37_826 VGND VGND VPWR VPWR sky130_fd_sc_hd__fill_1
XFILLER_7_1298 VGND VGND VPWR VPWR sky130_fd_sc_hd__decap_3
XFILLER_23_1068 VGND VGND VPWR VPWR sky130_fd_sc_hd__decap_3
XFILLER_48_174 VGND VGND VPWR VPWR sky130_fd_sc_hd__decap_3
XFILLER_64_645 VGND VGND VPWR VPWR sky130_fd_sc_hd__decap_3
XFILLER_40_1371 VGND VGND VPWR VPWR sky130_fd_sc_hd__fill_1
XFILLER_40_1382 VGND VGND VPWR VPWR sky130_fd_sc_hd__decap_3
XFILLER_75_1401 VGND VGND VPWR VPWR sky130_fd_sc_hd__decap_3
X_4970_ _6691_/Q _3057_/Y _5213_/A VGND VGND VPWR VPWR _4970_/X sky130_fd_sc_hd__mux2_1
XFILLER_17_561 VGND VGND VPWR VPWR sky130_fd_sc_hd__decap_3
XFILLER_45_870 VGND VGND VPWR VPWR sky130_fd_sc_hd__decap_3
XFILLER_75_1434 VGND VGND VPWR VPWR sky130_fd_sc_hd__decap_3
XFILLER_45_892 VGND VGND VPWR VPWR sky130_fd_sc_hd__decap_3
X_3921_ _6286_/Q _3948_/A2 _3921_/B1 _6262_/Q _3921_/C1 VGND VGND VPWR VPWR _3921_/X
+ sky130_fd_sc_hd__a221o_2
XFILLER_63_199 VGND VGND VPWR VPWR sky130_fd_sc_hd__decap_3
XFILLER_36_1418 VGND VGND VPWR VPWR sky130_fd_sc_hd__decap_3
XFILLER_36_1429 VGND VGND VPWR VPWR sky130_fd_sc_hd__decap_3
X_6640_ _6882_/CLK _6640_/D fanout663/X VGND VGND VPWR VPWR _6640_/Q sky130_fd_sc_hd__dfrtp_2
XFILLER_32_564 VGND VGND VPWR VPWR sky130_fd_sc_hd__decap_3
X_3852_ _3280_/X _4080_/A2 _4080_/B1 _6837_/Q _4080_/C1 VGND VGND VPWR VPWR _3852_/X
+ sky130_fd_sc_hd__a221o_2
XFILLER_60_895 VGND VGND VPWR VPWR sky130_fd_sc_hd__decap_3
XFILLER_73_1180 VGND VGND VPWR VPWR sky130_fd_sc_hd__decap_3
XFILLER_34_1142 VGND VGND VPWR VPWR sky130_fd_sc_hd__decap_3
X_6571_ _7040_/CLK _6571_/D load_slew718/X VGND VGND VPWR VPWR _6571_/Q sky130_fd_sc_hd__dfrtp_2
X_3783_ _6497_/Q _4330_/A2 _4734_/C1 _3782_/X VGND VGND VPWR VPWR _3783_/X sky130_fd_sc_hd__o211a_2
X_5522_ _7082_/Q _5520_/X _5521_/Y _5534_/B1 VGND VGND VPWR VPWR _5522_/X sky130_fd_sc_hd__a31o_2
XFILLER_69_1216 VGND VGND VPWR VPWR sky130_fd_sc_hd__decap_3
X_5453_ _5453_/A1 _5453_/A2 _4043_/X VGND VGND VPWR VPWR _6565_/D sky130_fd_sc_hd__a21o_2
XFILLER_12_1462 VGND VGND VPWR VPWR sky130_fd_sc_hd__decap_3
X_4404_ _6509_/Q _4360_/X _4763_/C1 VGND VGND VPWR VPWR _4404_/X sky130_fd_sc_hd__a21o_2
X_5384_ _5384_/A1 _5480_/A2 _3742_/X VGND VGND VPWR VPWR _6496_/D sky130_fd_sc_hd__a21o_2
XTAP_TAPCELL_ROW_35_1103 VGND VPWR sky130_fd_sc_hd__tapvpwrvgnd_1
Xfanout205 _6044_/S VGND VGND VPWR VPWR _6017_/S sky130_fd_sc_hd__clkdlybuf4s25_1
X_4335_ _4783_/B _4335_/A2 _4532_/C _4267_/X _6494_/Q VGND VGND VPWR VPWR _4335_/X
+ sky130_fd_sc_hd__a32o_2
XTAP_TAPCELL_ROW_35_1114 VGND VPWR sky130_fd_sc_hd__tapvpwrvgnd_1
XFILLER_5_92 VGND VGND VPWR VPWR sky130_fd_sc_hd__decap_3
Xfanout216 _5933_/Y VGND VGND VPWR VPWR fanout216/X sky130_fd_sc_hd__clkdlybuf4s25_1
Xfanout227 _6059_/S VGND VGND VPWR VPWR _5955_/S sky130_fd_sc_hd__clkdlybuf4s25_1
Xfanout238 _5464_/A2 VGND VGND VPWR VPWR _5478_/A2 sky130_fd_sc_hd__clkdlybuf4s25_1
X_7054_ _7054_/CLK _7054_/D load_slew754/X VGND VGND VPWR VPWR _7054_/Q sky130_fd_sc_hd__dfrtp_2
X_4266_ _5508_/A _4420_/B wire25/X VGND VGND VPWR VPWR _4266_/Y sky130_fd_sc_hd__nor3_2
XFILLER_45_1260 VGND VGND VPWR VPWR sky130_fd_sc_hd__decap_3
X_6005_ hold982/X _7009_/Q _6021_/S VGND VGND VPWR VPWR _6005_/X sky130_fd_sc_hd__mux2_1
XFILLER_68_962 VGND VGND VPWR VPWR sky130_fd_sc_hd__decap_3
XFILLER_80_1173 VGND VGND VPWR VPWR sky130_fd_sc_hd__decap_3
XFILLER_39_130 VGND VGND VPWR VPWR sky130_fd_sc_hd__decap_3
X_3217_ _3217_/A _3217_/B _3217_/C VGND VGND VPWR VPWR _3217_/X sky130_fd_sc_hd__and3_2
XFILLER_41_1135 VGND VGND VPWR VPWR sky130_fd_sc_hd__fill_2
XFILLER_80_1195 VGND VGND VPWR VPWR sky130_fd_sc_hd__decap_3
X_4197_ _6818_/Q _4833_/A2 _4869_/B1 _4196_/X VGND VGND VPWR VPWR _4197_/X sky130_fd_sc_hd__a211o_2
XFILLER_55_601 VGND VGND VPWR VPWR sky130_fd_sc_hd__fill_2
XFILLER_68_995 VGND VGND VPWR VPWR sky130_fd_sc_hd__fill_2
XFILLER_28_837 VGND VGND VPWR VPWR sky130_fd_sc_hd__decap_3
X_3148_ _3193_/A1 _3146_/X _3147_/X _3220_/C1 VGND VGND VPWR VPWR _3148_/X sky130_fd_sc_hd__a211o_2
XFILLER_67_494 VGND VGND VPWR VPWR sky130_fd_sc_hd__decap_3
XFILLER_27_358 VGND VGND VPWR VPWR sky130_fd_sc_hd__decap_3
XFILLER_43_818 VGND VGND VPWR VPWR sky130_fd_sc_hd__decap_3
X_3079_ _7110_/A _7079_/Q _7078_/Q VGND VGND VPWR VPWR _7112_/A sky130_fd_sc_hd__and3b_2
XTAP_TAPCELL_ROW_69_1991 VGND VPWR sky130_fd_sc_hd__tapvpwrvgnd_1
X_6907_ _7039_/CLK _6907_/D fanout821/X VGND VGND VPWR VPWR _6907_/Q sky130_fd_sc_hd__dfrtp_2
XFILLER_78_1091 VGND VGND VPWR VPWR sky130_fd_sc_hd__fill_1
XFILLER_35_380 VGND VGND VPWR VPWR sky130_fd_sc_hd__decap_3
XTAP_TAPCELL_ROW_65_1888 VGND VPWR sky130_fd_sc_hd__tapvpwrvgnd_1
X_6838_ _7088_/CLK _6838_/D load_slew769/X VGND VGND VPWR VPWR _6838_/Q sky130_fd_sc_hd__dfrtp_2
XTAP_TAPCELL_ROW_65_1899 VGND VPWR sky130_fd_sc_hd__tapvpwrvgnd_1
XFILLER_11_715 VGND VGND VPWR VPWR sky130_fd_sc_hd__decap_3
XFILLER_50_361 VGND VGND VPWR VPWR sky130_fd_sc_hd__decap_3
XFILLER_23_586 VGND VGND VPWR VPWR sky130_fd_sc_hd__decap_3
XFILLER_17_1340 VGND VGND VPWR VPWR sky130_fd_sc_hd__decap_3
XFILLER_17_1351 VGND VGND VPWR VPWR sky130_fd_sc_hd__decap_3
XFILLER_52_1231 VGND VGND VPWR VPWR sky130_fd_sc_hd__decap_3
XFILLER_11_748 VGND VGND VPWR VPWR sky130_fd_sc_hd__decap_3
X_6769_ _6865_/CLK _6769_/D wire712/X VGND VGND VPWR VPWR _6769_/Q sky130_fd_sc_hd__dfrtp_2
XTAP_TAPCELL_ROW_21_743 VGND VPWR sky130_fd_sc_hd__tapvpwrvgnd_1
XFILLER_13_1215 VGND VGND VPWR VPWR sky130_fd_sc_hd__decap_3
Xwire639 wire639/A VGND VGND VPWR VPWR wire639/X sky130_fd_sc_hd__clkbuf_4
XFILLER_17_1384 VGND VGND VPWR VPWR sky130_fd_sc_hd__decap_3
XTAP_TAPCELL_ROW_21_754 VGND VPWR sky130_fd_sc_hd__tapvpwrvgnd_1
XFILLER_52_1264 VGND VGND VPWR VPWR sky130_fd_sc_hd__decap_3
XFILLER_40_12 VGND VGND VPWR VPWR sky130_fd_sc_hd__decap_3
XFILLER_13_1248 VGND VGND VPWR VPWR sky130_fd_sc_hd__decap_3
XFILLER_52_1297 VGND VGND VPWR VPWR sky130_fd_sc_hd__decap_3
XFILLER_40_56 VGND VGND VPWR VPWR sky130_fd_sc_hd__decap_3
XFILLER_3_903 VGND VGND VPWR VPWR sky130_fd_sc_hd__decap_3
XFILLER_2_413 VGND VGND VPWR VPWR sky130_fd_sc_hd__decap_3
XFILLER_78_704 VGND VGND VPWR VPWR sky130_fd_sc_hd__decap_3
XFILLER_78_748 VGND VGND VPWR VPWR sky130_fd_sc_hd__decap_3
XFILLER_77_225 VGND VGND VPWR VPWR sky130_fd_sc_hd__decap_3
XFILLER_24_1300 VGND VGND VPWR VPWR sky130_fd_sc_hd__decap_3
Xfanout750 fanout752/X VGND VGND VPWR VPWR fanout750/X sky130_fd_sc_hd__clkdlybuf4s25_1
XFILLER_63_1360 VGND VGND VPWR VPWR sky130_fd_sc_hd__decap_3
XFILLER_49_98 VGND VGND VPWR VPWR sky130_fd_sc_hd__decap_3
XFILLER_59_951 VGND VGND VPWR VPWR sky130_fd_sc_hd__fill_1
Xfanout761 fanout790/X VGND VGND VPWR VPWR fanout761/X sky130_fd_sc_hd__clkdlybuf4s25_1
Xfanout772 fanout774/X VGND VGND VPWR VPWR fanout772/X sky130_fd_sc_hd__clkdlybuf4s25_1
Xfanout783 fanout788/X VGND VGND VPWR VPWR fanout783/X sky130_fd_sc_hd__clkdlybuf4s25_1
XFILLER_19_804 VGND VGND VPWR VPWR sky130_fd_sc_hd__fill_2
XFILLER_24_1344 VGND VGND VPWR VPWR sky130_fd_sc_hd__decap_3
XFILLER_63_1393 VGND VGND VPWR VPWR sky130_fd_sc_hd__decap_3
XFILLER_4_1427 VGND VGND VPWR VPWR sky130_fd_sc_hd__fill_1
XFILLER_1_39 VGND VGND VPWR VPWR sky130_fd_sc_hd__decap_3
XFILLER_4_1438 VGND VGND VPWR VPWR sky130_fd_sc_hd__decap_3
XFILLER_73_420 VGND VGND VPWR VPWR sky130_fd_sc_hd__decap_3
XFILLER_24_1388 VGND VGND VPWR VPWR sky130_fd_sc_hd__decap_3
XFILLER_58_494 VGND VGND VPWR VPWR sky130_fd_sc_hd__decap_3
XFILLER_59_1407 VGND VGND VPWR VPWR sky130_fd_sc_hd__decap_3
XFILLER_74_976 VGND VGND VPWR VPWR sky130_fd_sc_hd__decap_3
XFILLER_65_75 VGND VGND VPWR VPWR sky130_fd_sc_hd__decap_3
XFILLER_2_1173 VGND VGND VPWR VPWR sky130_fd_sc_hd__decap_3
XFILLER_33_328 VGND VGND VPWR VPWR sky130_fd_sc_hd__decap_3
XFILLER_27_892 VGND VGND VPWR VPWR sky130_fd_sc_hd__decap_3
XFILLER_61_648 VGND VGND VPWR VPWR sky130_fd_sc_hd__decap_3
XFILLER_57_1175 VGND VGND VPWR VPWR sky130_fd_sc_hd__fill_1
XFILLER_14_564 VGND VGND VPWR VPWR sky130_fd_sc_hd__decap_3
XFILLER_42_884 VGND VGND VPWR VPWR sky130_fd_sc_hd__decap_3
XFILLER_57_1186 VGND VGND VPWR VPWR sky130_fd_sc_hd__decap_3
XFILLER_70_1320 VGND VGND VPWR VPWR sky130_fd_sc_hd__decap_3
XFILLER_35_1440 VGND VGND VPWR VPWR sky130_fd_sc_hd__decap_3
XFILLER_70_1353 VGND VGND VPWR VPWR sky130_fd_sc_hd__decap_3
XFILLER_31_1304 VGND VGND VPWR VPWR sky130_fd_sc_hd__decap_3
XFILLER_31_1337 VGND VGND VPWR VPWR sky130_fd_sc_hd__decap_3
XFILLER_70_1397 VGND VGND VPWR VPWR sky130_fd_sc_hd__decap_3
XFILLER_31_1348 VGND VGND VPWR VPWR sky130_fd_sc_hd__decap_3
XTAP_TAPCELL_ROW_75_2140 VGND VPWR sky130_fd_sc_hd__tapvpwrvgnd_1
XTAP_TAPCELL_ROW_75_2151 VGND VPWR sky130_fd_sc_hd__tapvpwrvgnd_1
XFILLER_5_251 VGND VGND VPWR VPWR sky130_fd_sc_hd__fill_1
XTAP_TAPCELL_ROW_75_2162 VGND VPWR sky130_fd_sc_hd__tapvpwrvgnd_1
XFILLER_53_6 VGND VGND VPWR VPWR sky130_fd_sc_hd__decap_3
XFILLER_5_273 VGND VGND VPWR VPWR sky130_fd_sc_hd__decap_3
XFILLER_5_295 VGND VGND VPWR VPWR sky130_fd_sc_hd__decap_3
XTAP_TAPCELL_ROW_71_2037 VGND VPWR sky130_fd_sc_hd__tapvpwrvgnd_1
XTAP_TAPCELL_ROW_71_2048 VGND VPWR sky130_fd_sc_hd__tapvpwrvgnd_1
XFILLER_29_1233 VGND VGND VPWR VPWR sky130_fd_sc_hd__decap_3
XFILLER_68_1282 VGND VGND VPWR VPWR sky130_fd_sc_hd__decap_3
XTAP_TAPCELL_ROW_71_2059 VGND VPWR sky130_fd_sc_hd__tapvpwrvgnd_1
XFILLER_9_1316 VGND VGND VPWR VPWR sky130_fd_sc_hd__decap_3
XFILLER_64_1135 VGND VGND VPWR VPWR sky130_fd_sc_hd__decap_3
XFILLER_29_1266 VGND VGND VPWR VPWR sky130_fd_sc_hd__decap_3
XFILLER_69_726 VGND VGND VPWR VPWR sky130_fd_sc_hd__fill_2
X_4120_ _4202_/B _4201_/A VGND VGND VPWR VPWR _4122_/A sky130_fd_sc_hd__xnor2_2
XFILLER_68_214 VGND VGND VPWR VPWR sky130_fd_sc_hd__decap_3
XFILLER_42_1400 VGND VGND VPWR VPWR sky130_fd_sc_hd__decap_3
XFILLER_1_490 VGND VGND VPWR VPWR sky130_fd_sc_hd__fill_1
X_4051_ _6238_/Q _4105_/A2 _4049_/X _4050_/X VGND VGND VPWR VPWR _6238_/D sky130_fd_sc_hd__o22a_2
XFILLER_42_1444 VGND VGND VPWR VPWR sky130_fd_sc_hd__decap_3
XFILLER_49_461 VGND VGND VPWR VPWR sky130_fd_sc_hd__decap_3
Xinput5 ui_in[3] VGND VGND VPWR VPWR input5/X sky130_fd_sc_hd__clkdlybuf4s25_1
XFILLER_77_781 VGND VGND VPWR VPWR sky130_fd_sc_hd__decap_3
XFILLER_7_1095 VGND VGND VPWR VPWR sky130_fd_sc_hd__decap_3
XFILLER_36_133 VGND VGND VPWR VPWR sky130_fd_sc_hd__decap_3
XFILLER_64_442 VGND VGND VPWR VPWR sky130_fd_sc_hd__decap_3
XFILLER_25_818 VGND VGND VPWR VPWR sky130_fd_sc_hd__fill_2
XFILLER_52_615 VGND VGND VPWR VPWR sky130_fd_sc_hd__decap_3
XFILLER_64_475 VGND VGND VPWR VPWR sky130_fd_sc_hd__fill_1
XFILLER_36_177 VGND VGND VPWR VPWR sky130_fd_sc_hd__decap_3
XFILLER_24_328 VGND VGND VPWR VPWR sky130_fd_sc_hd__fill_2
XFILLER_75_1231 VGND VGND VPWR VPWR sky130_fd_sc_hd__fill_1
X_4953_ _6383_/Q _5219_/B VGND VGND VPWR VPWR _4953_/X sky130_fd_sc_hd__or2_2
XFILLER_75_1242 VGND VGND VPWR VPWR sky130_fd_sc_hd__decap_3
XFILLER_75_1275 VGND VGND VPWR VPWR sky130_fd_sc_hd__decap_3
X_3904_ _4170_/A _3905_/B VGND VGND VPWR VPWR _4328_/A sky130_fd_sc_hd__xnor2_2
XFILLER_51_169 VGND VGND VPWR VPWR sky130_fd_sc_hd__decap_3
XFILLER_36_1237 VGND VGND VPWR VPWR sky130_fd_sc_hd__decap_3
X_4884_ _6341_/Q wire63/X _4881_/X _4883_/X VGND VGND VPWR VPWR _6341_/D sky130_fd_sc_hd__o22a_2
XFILLER_33_884 VGND VGND VPWR VPWR sky130_fd_sc_hd__decap_3
XFILLER_20_523 VGND VGND VPWR VPWR sky130_fd_sc_hd__decap_3
X_6623_ _6847_/CLK _6623_/D load_slew819/X VGND VGND VPWR VPWR _6623_/Q sky130_fd_sc_hd__dfrtp_2
XTAP_TAPCELL_ROW_15_581 VGND VPWR sky130_fd_sc_hd__tapvpwrvgnd_1
X_3835_ _4010_/A _6234_/Q VGND VGND VPWR VPWR _3835_/X sky130_fd_sc_hd__and2b_2
XTAP_TAPCELL_ROW_15_592 VGND VPWR sky130_fd_sc_hd__tapvpwrvgnd_1
XTAP_TAPCELL_ROW_60_1752 VGND VPWR sky130_fd_sc_hd__tapvpwrvgnd_1
XTAP_TAPCELL_ROW_60_1763 VGND VPWR sky130_fd_sc_hd__tapvpwrvgnd_1
Xtt_um_aes128_optimized_853 VGND VGND VPWR VPWR tt_um_aes128_optimized_853/HI uio_out[0]
+ sky130_fd_sc_hd__conb_1
X_6554_ _6926_/CLK _6554_/D fanout755/X VGND VGND VPWR VPWR _6554_/Q sky130_fd_sc_hd__dfrtp_2
X_3766_ _6273_/Q _3928_/A2 _3928_/B1 _6249_/Q _3928_/C1 VGND VGND VPWR VPWR _3766_/X
+ sky130_fd_sc_hd__a221o_2
X_5505_ _5505_/A _5512_/B VGND VGND VPWR VPWR _5508_/B sky130_fd_sc_hd__nand2_2
X_6485_ _6959_/CLK _6485_/D load_slew760/X VGND VGND VPWR VPWR _6485_/Q sky130_fd_sc_hd__dfrtp_2
X_3697_ _3697_/A _3882_/A VGND VGND VPWR VPWR _3855_/A sky130_fd_sc_hd__xnor2_2
XFILLER_12_1270 VGND VGND VPWR VPWR sky130_fd_sc_hd__decap_3
XFILLER_10_15 VGND VGND VPWR VPWR sky130_fd_sc_hd__decap_3
XFILLER_69_1057 VGND VGND VPWR VPWR sky130_fd_sc_hd__decap_3
X_5436_ _5436_/A1 _5476_/A2 _4640_/X VGND VGND VPWR VPWR _6548_/D sky130_fd_sc_hd__a21o_2
XFILLER_69_1068 VGND VGND VPWR VPWR sky130_fd_sc_hd__decap_3
XFILLER_47_1322 VGND VGND VPWR VPWR sky130_fd_sc_hd__decap_3
XFILLER_0_906 VGND VGND VPWR VPWR sky130_fd_sc_hd__decap_3
X_5367_ _5367_/A1 _5487_/A2 _4185_/X VGND VGND VPWR VPWR _6479_/D sky130_fd_sc_hd__a21o_2
XFILLER_0_928 VGND VGND VPWR VPWR sky130_fd_sc_hd__decap_3
XFILLER_47_1366 VGND VGND VPWR VPWR sky130_fd_sc_hd__decap_3
XFILLER_43_1208 VGND VGND VPWR VPWR sky130_fd_sc_hd__decap_3
X_4318_ _4318_/A _4872_/B VGND VGND VPWR VPWR _4318_/Y sky130_fd_sc_hd__nand2_2
XFILLER_59_225 VGND VGND VPWR VPWR sky130_fd_sc_hd__decap_3
XFILLER_47_1399 VGND VGND VPWR VPWR sky130_fd_sc_hd__fill_1
X_5298_ _6780_/Q _4917_/B _5298_/S VGND VGND VPWR VPWR _5298_/X sky130_fd_sc_hd__mux2_1
X_7037_ _7037_/CLK _7037_/D load_slew692/X VGND VGND VPWR VPWR _7037_/Q sky130_fd_sc_hd__dfrtp_2
XFILLER_75_729 VGND VGND VPWR VPWR sky130_fd_sc_hd__decap_3
X_4249_ _4249_/A _4249_/B VGND VGND VPWR VPWR _4250_/B sky130_fd_sc_hd__xor2_2
XFILLER_56_921 VGND VGND VPWR VPWR sky130_fd_sc_hd__decap_3
XFILLER_27_111 VGND VGND VPWR VPWR sky130_fd_sc_hd__fill_1
XTAP_TAPCELL_ROW_2_243 VGND VPWR sky130_fd_sc_hd__tapvpwrvgnd_1
XFILLER_28_645 VGND VGND VPWR VPWR sky130_fd_sc_hd__decap_3
XTAP_TAPCELL_ROW_2_254 VGND VPWR sky130_fd_sc_hd__tapvpwrvgnd_1
XTAP_TAPCELL_ROW_2_265 VGND VPWR sky130_fd_sc_hd__tapvpwrvgnd_1
XFILLER_3_1460 VGND VGND VPWR VPWR sky130_fd_sc_hd__decap_3
XFILLER_27_155 VGND VGND VPWR VPWR sky130_fd_sc_hd__fill_2
XFILLER_28_689 VGND VGND VPWR VPWR sky130_fd_sc_hd__decap_3
XTAP_TAPCELL_ROW_67_1939 VGND VPWR sky130_fd_sc_hd__tapvpwrvgnd_1
XFILLER_35_45 VGND VGND VPWR VPWR sky130_fd_sc_hd__decap_3
XFILLER_43_659 VGND VGND VPWR VPWR sky130_fd_sc_hd__decap_3
XFILLER_19_1413 VGND VGND VPWR VPWR sky130_fd_sc_hd__decap_3
XFILLER_58_1462 VGND VGND VPWR VPWR sky130_fd_sc_hd__decap_3
XTAP_TAPCELL_ROW_26_868 VGND VPWR sky130_fd_sc_hd__tapvpwrvgnd_1
XTAP_TAPCELL_ROW_26_879 VGND VPWR sky130_fd_sc_hd__tapvpwrvgnd_1
XFILLER_54_1315 VGND VGND VPWR VPWR sky130_fd_sc_hd__fill_1
XFILLER_19_1446 VGND VGND VPWR VPWR sky130_fd_sc_hd__decap_3
XFILLER_54_1326 VGND VGND VPWR VPWR sky130_fd_sc_hd__decap_3
XFILLER_19_1457 VGND VGND VPWR VPWR sky130_fd_sc_hd__decap_3
XTAP_TAPCELL_ROW_13_529 VGND VPWR sky130_fd_sc_hd__tapvpwrvgnd_1
XFILLER_54_1359 VGND VGND VPWR VPWR sky130_fd_sc_hd__decap_3
XFILLER_7_505 VGND VGND VPWR VPWR sky130_fd_sc_hd__decap_3
XFILLER_52_1050 VGND VGND VPWR VPWR sky130_fd_sc_hd__fill_1
XFILLER_11_589 VGND VGND VPWR VPWR sky130_fd_sc_hd__decap_3
XFILLER_7_538 VGND VGND VPWR VPWR sky130_fd_sc_hd__decap_3
XFILLER_3_700 VGND VGND VPWR VPWR sky130_fd_sc_hd__decap_3
XFILLER_2_221 VGND VGND VPWR VPWR sky130_fd_sc_hd__decap_3
XFILLER_65_1422 VGND VGND VPWR VPWR sky130_fd_sc_hd__decap_3
Xload_slew408 _4853_/C1 VGND VGND VPWR VPWR _4874_/C1 sky130_fd_sc_hd__buf_2
XFILLER_3_788 VGND VGND VPWR VPWR sky130_fd_sc_hd__decap_3
XFILLER_26_1406 VGND VGND VPWR VPWR sky130_fd_sc_hd__decap_3
XFILLER_65_1455 VGND VGND VPWR VPWR sky130_fd_sc_hd__fill_1
XFILLER_2_276 VGND VGND VPWR VPWR sky130_fd_sc_hd__decap_3
XFILLER_65_1466 VGND VGND VPWR VPWR sky130_fd_sc_hd__decap_3
XFILLER_61_1319 VGND VGND VPWR VPWR sky130_fd_sc_hd__decap_3
XFILLER_76_41 VGND VGND VPWR VPWR sky130_fd_sc_hd__decap_3
XFILLER_24_1130 VGND VGND VPWR VPWR sky130_fd_sc_hd__decap_3
XFILLER_78_589 VGND VGND VPWR VPWR sky130_fd_sc_hd__decap_3
XFILLER_8_1371 VGND VGND VPWR VPWR sky130_fd_sc_hd__fill_1
XFILLER_19_601 VGND VGND VPWR VPWR sky130_fd_sc_hd__fill_2
XFILLER_59_770 VGND VGND VPWR VPWR sky130_fd_sc_hd__decap_3
XFILLER_8_1382 VGND VGND VPWR VPWR sky130_fd_sc_hd__decap_3
XFILLER_18_9 VGND VGND VPWR VPWR sky130_fd_sc_hd__fill_2
Xfanout580 _6607_/Q VGND VGND VPWR VPWR _4403_/A sky130_fd_sc_hd__clkdlybuf4s25_1
XFILLER_76_74 VGND VGND VPWR VPWR sky130_fd_sc_hd__decap_3
XFILLER_24_1152 VGND VGND VPWR VPWR sky130_fd_sc_hd__decap_3
XFILLER_4_1235 VGND VGND VPWR VPWR sky130_fd_sc_hd__decap_3
XFILLER_20_1027 VGND VGND VPWR VPWR sky130_fd_sc_hd__fill_1
XFILLER_4_1279 VGND VGND VPWR VPWR sky130_fd_sc_hd__decap_3
XFILLER_62_902 VGND VGND VPWR VPWR sky130_fd_sc_hd__decap_3
XFILLER_74_773 VGND VGND VPWR VPWR sky130_fd_sc_hd__decap_3
XFILLER_74_784 VGND VGND VPWR VPWR sky130_fd_sc_hd__fill_2
XFILLER_73_261 VGND VGND VPWR VPWR sky130_fd_sc_hd__fill_1
XFILLER_34_626 VGND VGND VPWR VPWR sky130_fd_sc_hd__decap_3
XFILLER_34_637 VGND VGND VPWR VPWR sky130_fd_sc_hd__decap_3
XFILLER_59_1248 VGND VGND VPWR VPWR sky130_fd_sc_hd__decap_3
XFILLER_34_648 VGND VGND VPWR VPWR sky130_fd_sc_hd__fill_2
XFILLER_33_136 VGND VGND VPWR VPWR sky130_fd_sc_hd__decap_3
XFILLER_34_659 VGND VGND VPWR VPWR sky130_fd_sc_hd__fill_1
XFILLER_72_1415 VGND VGND VPWR VPWR sky130_fd_sc_hd__decap_3
XFILLER_61_489 VGND VGND VPWR VPWR sky130_fd_sc_hd__decap_3
XFILLER_15_895 VGND VGND VPWR VPWR sky130_fd_sc_hd__fill_1
XFILLER_72_1459 VGND VGND VPWR VPWR sky130_fd_sc_hd__decap_3
XFILLER_14_383 VGND VGND VPWR VPWR sky130_fd_sc_hd__decap_3
XFILLER_30_843 VGND VGND VPWR VPWR sky130_fd_sc_hd__decap_3
XTAP_TAPCELL_ROW_77_2202 VGND VPWR sky130_fd_sc_hd__tapvpwrvgnd_1
XPHY_EDGE_ROW_78_Left_159 VGND VGND VPWR VPWR sky130_fd_sc_hd__decap_3
XTAP_TAPCELL_ROW_77_2213 VGND VPWR sky130_fd_sc_hd__tapvpwrvgnd_1
XFILLER_70_1161 VGND VGND VPWR VPWR sky130_fd_sc_hd__decap_3
XFILLER_35_1281 VGND VGND VPWR VPWR sky130_fd_sc_hd__decap_3
X_3620_ _6312_/Q _5594_/A1 _5603_/A1 _6304_/Q VGND VGND VPWR VPWR _3622_/A sky130_fd_sc_hd__a22o_2
XFILLER_35_1292 VGND VGND VPWR VPWR sky130_fd_sc_hd__decap_3
XFILLER_70_1194 VGND VGND VPWR VPWR sky130_fd_sc_hd__decap_3
X_3551_ _6627_/Q _4312_/A _5607_/A2 _6635_/Q _3551_/C1 VGND VGND VPWR VPWR _3551_/X
+ sky130_fd_sc_hd__a221o_2
XFILLER_66_1208 VGND VGND VPWR VPWR sky130_fd_sc_hd__decap_3
X_6270_ _6897_/CLK _6270_/D fanout701/X VGND VGND VPWR VPWR _6270_/Q sky130_fd_sc_hd__dfrtp_2
XFILLER_51_3 VGND VGND VPWR VPWR sky130_fd_sc_hd__decap_3
X_3482_ _7081_/Q _3482_/A2 _7081_/D VGND VGND VPWR VPWR _6215_/D sky130_fd_sc_hd__o21ba_2
X_5221_ _6415_/Q _5221_/A2 _5220_/X VGND VGND VPWR VPWR _6415_/D sky130_fd_sc_hd__a21o_2
XFILLER_9_1124 VGND VGND VPWR VPWR sky130_fd_sc_hd__decap_3
X_5152_ _6723_/Q _5213_/A VGND VGND VPWR VPWR _5152_/X sky130_fd_sc_hd__or2_2
XFILLER_69_534 VGND VGND VPWR VPWR sky130_fd_sc_hd__decap_3
XFILLER_9_1157 VGND VGND VPWR VPWR sky130_fd_sc_hd__decap_3
X_4103_ _4779_/A1 _4100_/X _4101_/Y _4102_/X _4772_/C1 VGND VGND VPWR VPWR _4103_/X
+ sky130_fd_sc_hd__o221a_2
XFILLER_69_567 VGND VGND VPWR VPWR sky130_fd_sc_hd__decap_3
X_5083_ _5083_/A _5083_/B VGND VGND VPWR VPWR _5083_/X sky130_fd_sc_hd__or2_2
XFILLER_42_1252 VGND VGND VPWR VPWR sky130_fd_sc_hd__decap_3
XFILLER_2_71 VGND VGND VPWR VPWR sky130_fd_sc_hd__decap_3
XFILLER_38_932 VGND VGND VPWR VPWR sky130_fd_sc_hd__fill_2
X_4034_ _4040_/A1 _4694_/B _4312_/B _4008_/Y _6564_/Q VGND VGND VPWR VPWR _4034_/X
+ sky130_fd_sc_hd__a32o_2
XFILLER_42_1285 VGND VGND VPWR VPWR sky130_fd_sc_hd__decap_3
XFILLER_37_442 VGND VGND VPWR VPWR sky130_fd_sc_hd__decap_3
XFILLER_77_1304 VGND VGND VPWR VPWR sky130_fd_sc_hd__decap_3
XFILLER_37_464 VGND VGND VPWR VPWR sky130_fd_sc_hd__decap_3
XFILLER_65_773 VGND VGND VPWR VPWR sky130_fd_sc_hd__decap_3
XFILLER_38_998 VGND VGND VPWR VPWR sky130_fd_sc_hd__decap_3
XFILLER_80_710 VGND VGND VPWR VPWR sky130_fd_sc_hd__decap_3
XFILLER_77_1337 VGND VGND VPWR VPWR sky130_fd_sc_hd__decap_3
XFILLER_52_401 VGND VGND VPWR VPWR sky130_fd_sc_hd__fill_2
XFILLER_77_1348 VGND VGND VPWR VPWR sky130_fd_sc_hd__decap_3
XFILLER_80_732 VGND VGND VPWR VPWR sky130_fd_sc_hd__decap_3
X_5985_ hold882/X _6989_/Q _6049_/S VGND VGND VPWR VPWR _5985_/X sky130_fd_sc_hd__mux2_1
XFILLER_36_1001 VGND VGND VPWR VPWR sky130_fd_sc_hd__decap_3
XFILLER_52_467 VGND VGND VPWR VPWR sky130_fd_sc_hd__fill_2
XTAP_TAPCELL_ROW_62_1803 VGND VPWR sky130_fd_sc_hd__tapvpwrvgnd_1
XFILLER_12_309 VGND VGND VPWR VPWR sky130_fd_sc_hd__fill_2
XTAP_TAPCELL_ROW_23_805 VGND VPWR sky130_fd_sc_hd__tapvpwrvgnd_1
XTAP_TAPCELL_ROW_62_1814 VGND VPWR sky130_fd_sc_hd__tapvpwrvgnd_1
XFILLER_75_1061 VGND VGND VPWR VPWR sky130_fd_sc_hd__decap_3
X_4936_ _6348_/Q _4935_/X _4936_/S VGND VGND VPWR VPWR _6348_/D sky130_fd_sc_hd__mux2_1
XTAP_TAPCELL_ROW_62_1825 VGND VPWR sky130_fd_sc_hd__tapvpwrvgnd_1
XFILLER_33_670 VGND VGND VPWR VPWR sky130_fd_sc_hd__fill_2
XANTENNA_10 _3202_/A VGND VGND VPWR VPWR sky130_fd_sc_hd__diode_2
X_4867_ _4885_/B1 _4864_/X _4865_/Y _4866_/X _4889_/A VGND VGND VPWR VPWR _4867_/X
+ sky130_fd_sc_hd__o221a_2
XFILLER_20_331 VGND VGND VPWR VPWR sky130_fd_sc_hd__decap_3
XANTENNA_21 _5813_/S VGND VGND VPWR VPWR sky130_fd_sc_hd__diode_2
XFILLER_32_191 VGND VGND VPWR VPWR sky130_fd_sc_hd__decap_3
XFILLER_21_865 VGND VGND VPWR VPWR sky130_fd_sc_hd__fill_2
XANTENNA_32 _7083_/Q VGND VGND VPWR VPWR sky130_fd_sc_hd__diode_2
XANTENNA_43 _5748_/S VGND VGND VPWR VPWR sky130_fd_sc_hd__diode_2
XANTENNA_54 _5627_/S VGND VGND VPWR VPWR sky130_fd_sc_hd__diode_2
X_6606_ _7041_/CLK _6606_/D fanout730/X VGND VGND VPWR VPWR _6606_/Q sky130_fd_sc_hd__dfrtp_2
XFILLER_14_1332 VGND VGND VPWR VPWR sky130_fd_sc_hd__decap_3
XFILLER_53_1381 VGND VGND VPWR VPWR sky130_fd_sc_hd__decap_3
X_3818_ _6218_/Q wire77/X _3816_/X _3817_/X VGND VGND VPWR VPWR _6218_/D sky130_fd_sc_hd__o22a_2
XANTENNA_65 _3205_/B1 VGND VGND VPWR VPWR sky130_fd_sc_hd__diode_2
XANTENNA_76 _5581_/A VGND VGND VPWR VPWR sky130_fd_sc_hd__diode_2
X_4798_ _6915_/Q _4855_/A2 _4855_/B1 _4797_/X VGND VGND VPWR VPWR _4798_/Y sky130_fd_sc_hd__a211oi_2
XANTENNA_87 _7085_/Q VGND VGND VPWR VPWR sky130_fd_sc_hd__diode_2
XFILLER_14_1365 VGND VGND VPWR VPWR sky130_fd_sc_hd__decap_3
XFILLER_14_1376 VGND VGND VPWR VPWR sky130_fd_sc_hd__decap_3
X_6537_ _6974_/CLK _6537_/D load_slew780/X VGND VGND VPWR VPWR _6537_/Q sky130_fd_sc_hd__dfrtp_2
X_3749_ _3748_/B _3680_/Y _3692_/X VGND VGND VPWR VPWR _3822_/C sky130_fd_sc_hd__a21o_2
XFILLER_10_1229 VGND VGND VPWR VPWR sky130_fd_sc_hd__decap_3
XFILLER_49_1428 VGND VGND VPWR VPWR sky130_fd_sc_hd__decap_3
X_6468_ _7063_/CLK _6468_/D fanout768/A VGND VGND VPWR VPWR _6468_/Q sky130_fd_sc_hd__dfrtp_2
X_5419_ _5419_/A1 _5480_/A2 _3981_/X VGND VGND VPWR VPWR _6531_/D sky130_fd_sc_hd__a21o_2
X_6399_ _6865_/CLK _6399_/D fanout741/X VGND VGND VPWR VPWR _6399_/Q sky130_fd_sc_hd__dfrtp_2
XFILLER_0_725 VGND VGND VPWR VPWR sky130_fd_sc_hd__decap_3
XFILLER_0_747 VGND VGND VPWR VPWR sky130_fd_sc_hd__decap_3
XFILLER_43_1016 VGND VGND VPWR VPWR sky130_fd_sc_hd__decap_3
XFILLER_0_769 VGND VGND VPWR VPWR sky130_fd_sc_hd__decap_3
XTAP_TAPCELL_ROW_7_379 VGND VPWR sky130_fd_sc_hd__tapvpwrvgnd_1
XFILLER_48_718 VGND VGND VPWR VPWR sky130_fd_sc_hd__decap_3
XFILLER_75_526 VGND VGND VPWR VPWR sky130_fd_sc_hd__decap_3
XFILLER_60_1341 VGND VGND VPWR VPWR sky130_fd_sc_hd__decap_3
XFILLER_75_559 VGND VGND VPWR VPWR sky130_fd_sc_hd__fill_1
XFILLER_21_1325 VGND VGND VPWR VPWR sky130_fd_sc_hd__decap_3
XFILLER_60_1385 VGND VGND VPWR VPWR sky130_fd_sc_hd__decap_3
XFILLER_1_1419 VGND VGND VPWR VPWR sky130_fd_sc_hd__decap_3
XFILLER_16_604 VGND VGND VPWR VPWR sky130_fd_sc_hd__decap_3
XFILLER_44_913 VGND VGND VPWR VPWR sky130_fd_sc_hd__decap_3
XFILLER_46_55 VGND VGND VPWR VPWR sky130_fd_sc_hd__decap_3
XFILLER_21_1369 VGND VGND VPWR VPWR sky130_fd_sc_hd__decap_3
XFILLER_43_401 VGND VGND VPWR VPWR sky130_fd_sc_hd__decap_3
XFILLER_46_88 VGND VGND VPWR VPWR sky130_fd_sc_hd__decap_3
XFILLER_71_732 VGND VGND VPWR VPWR sky130_fd_sc_hd__decap_3
XFILLER_43_423 VGND VGND VPWR VPWR sky130_fd_sc_hd__decap_3
XFILLER_71_765 VGND VGND VPWR VPWR sky130_fd_sc_hd__decap_3
XFILLER_44_979 VGND VGND VPWR VPWR sky130_fd_sc_hd__fill_1
XFILLER_58_1270 VGND VGND VPWR VPWR sky130_fd_sc_hd__decap_3
XFILLER_70_253 VGND VGND VPWR VPWR sky130_fd_sc_hd__decap_3
XFILLER_19_1254 VGND VGND VPWR VPWR sky130_fd_sc_hd__decap_3
XFILLER_11_320 VGND VGND VPWR VPWR sky130_fd_sc_hd__decap_3
XFILLER_19_1287 VGND VGND VPWR VPWR sky130_fd_sc_hd__fill_1
XFILLER_15_1129 VGND VGND VPWR VPWR sky130_fd_sc_hd__decap_3
XFILLER_19_1298 VGND VGND VPWR VPWR sky130_fd_sc_hd__decap_3
XFILLER_11_364 VGND VGND VPWR VPWR sky130_fd_sc_hd__decap_3
XFILLER_8_836 VGND VGND VPWR VPWR sky130_fd_sc_hd__decap_3
XFILLER_32_1421 VGND VGND VPWR VPWR sky130_fd_sc_hd__decap_3
XFILLER_7_27 VGND VGND VPWR VPWR sky130_fd_sc_hd__decap_3
XFILLER_32_1432 VGND VGND VPWR VPWR sky130_fd_sc_hd__decap_3
XFILLER_32_1465 VGND VGND VPWR VPWR sky130_fd_sc_hd__decap_3
XFILLER_7_368 VGND VGND VPWR VPWR sky130_fd_sc_hd__decap_3
Xwire277 _4438_/A VGND VGND VPWR VPWR _4526_/B sky130_fd_sc_hd__clkbuf_4
XFILLER_11_91 VGND VGND VPWR VPWR sky130_fd_sc_hd__decap_3
XFILLER_26_1203 VGND VGND VPWR VPWR sky130_fd_sc_hd__fill_1
XFILLER_65_1263 VGND VGND VPWR VPWR sky130_fd_sc_hd__decap_3
Xload_slew249 _5468_/A2 VGND VGND VPWR VPWR _5476_/A2 sky130_fd_sc_hd__clkbuf_4
XFILLER_61_1116 VGND VGND VPWR VPWR sky130_fd_sc_hd__decap_3
XFILLER_26_1247 VGND VGND VPWR VPWR sky130_fd_sc_hd__decap_3
XFILLER_61_1127 VGND VGND VPWR VPWR sky130_fd_sc_hd__decap_3
XFILLER_16_6 VGND VGND VPWR VPWR sky130_fd_sc_hd__decap_3
XFILLER_4_1043 VGND VGND VPWR VPWR sky130_fd_sc_hd__decap_3
XFILLER_4_1076 VGND VGND VPWR VPWR sky130_fd_sc_hd__decap_3
XFILLER_34_401 VGND VGND VPWR VPWR sky130_fd_sc_hd__decap_3
XFILLER_19_486 VGND VGND VPWR VPWR sky130_fd_sc_hd__decap_3
XFILLER_35_946 VGND VGND VPWR VPWR sky130_fd_sc_hd__decap_3
XFILLER_62_721 VGND VGND VPWR VPWR sky130_fd_sc_hd__decap_3
XFILLER_74_592 VGND VGND VPWR VPWR sky130_fd_sc_hd__decap_3
XTAP_TAPCELL_ROW_17_632 VGND VPWR sky130_fd_sc_hd__tapvpwrvgnd_1
XFILLER_34_445 VGND VGND VPWR VPWR sky130_fd_sc_hd__decap_3
XFILLER_35_968 VGND VGND VPWR VPWR sky130_fd_sc_hd__decap_3
XFILLER_62_754 VGND VGND VPWR VPWR sky130_fd_sc_hd__fill_2
XTAP_TAPCELL_ROW_17_643 VGND VPWR sky130_fd_sc_hd__tapvpwrvgnd_1
XFILLER_35_979 VGND VGND VPWR VPWR sky130_fd_sc_hd__decap_3
XFILLER_50_905 VGND VGND VPWR VPWR sky130_fd_sc_hd__decap_3
XTAP_TAPCELL_ROW_17_654 VGND VPWR sky130_fd_sc_hd__tapvpwrvgnd_1
XFILLER_61_242 VGND VGND VPWR VPWR sky130_fd_sc_hd__fill_1
XFILLER_37_1310 VGND VGND VPWR VPWR sky130_fd_sc_hd__decap_3
XFILLER_21_106 VGND VGND VPWR VPWR sky130_fd_sc_hd__decap_3
X_5770_ _5906_/B _5879_/A VGND VGND VPWR VPWR _5868_/B sky130_fd_sc_hd__and2_2
XFILLER_72_1223 VGND VGND VPWR VPWR sky130_fd_sc_hd__decap_3
XFILLER_37_1343 VGND VGND VPWR VPWR sky130_fd_sc_hd__fill_1
XFILLER_43_990 VGND VGND VPWR VPWR sky130_fd_sc_hd__decap_3
XFILLER_37_1354 VGND VGND VPWR VPWR sky130_fd_sc_hd__decap_3
X_4721_ _6897_/Q _4898_/A2 _4719_/X _4720_/X VGND VGND VPWR VPWR _4721_/X sky130_fd_sc_hd__a211o_2
XFILLER_72_1256 VGND VGND VPWR VPWR sky130_fd_sc_hd__decap_3
XFILLER_72_1267 VGND VGND VPWR VPWR sky130_fd_sc_hd__decap_3
XFILLER_30_640 VGND VGND VPWR VPWR sky130_fd_sc_hd__decap_3
XFILLER_37_1387 VGND VGND VPWR VPWR sky130_fd_sc_hd__decap_3
XFILLER_30_651 VGND VGND VPWR VPWR sky130_fd_sc_hd__decap_3
X_4652_ _4710_/A _4829_/B VGND VGND VPWR VPWR _4652_/Y sky130_fd_sc_hd__nor2_2
X_3603_ _6647_/Q _4723_/C _3601_/X _3602_/X _5577_/A VGND VGND VPWR VPWR _3603_/X
+ sky130_fd_sc_hd__o221a_2
XTAP_TAPCELL_ROW_42_1290 VGND VPWR sky130_fd_sc_hd__tapvpwrvgnd_1
X_4583_ _6324_/Q wire515/A _3362_/X _4583_/B2 VGND VGND VPWR VPWR _4583_/X sky130_fd_sc_hd__a22o_2
X_6322_ _6943_/CLK _6322_/D fanout823/X VGND VGND VPWR VPWR _6322_/Q sky130_fd_sc_hd__dfrtp_2
X_3534_ _6294_/Q _5600_/A2 _5606_/A2 _6286_/Q _3533_/X VGND VGND VPWR VPWR _3534_/X
+ sky130_fd_sc_hd__a221o_2
XFILLER_66_1005 VGND VGND VPWR VPWR sky130_fd_sc_hd__decap_3
X_6253_ _6847_/CLK _6253_/D load_slew819/X VGND VGND VPWR VPWR _6253_/Q sky130_fd_sc_hd__dfrtp_2
Xhold869 _6182_/Q VGND VGND VPWR VPWR hold869/X sky130_fd_sc_hd__dlygate4sd3_1
X_3465_ _3465_/A0 _3464_/X _3465_/S VGND VGND VPWR VPWR _6206_/D sky130_fd_sc_hd__mux2_1
XFILLER_66_1049 VGND VGND VPWR VPWR sky130_fd_sc_hd__fill_1
XFILLER_48_1450 VGND VGND VPWR VPWR sky130_fd_sc_hd__decap_3
XTAP_TAPCELL_ROW_55_1640 VGND VPWR sky130_fd_sc_hd__tapvpwrvgnd_1
XFILLER_44_1303 VGND VGND VPWR VPWR sky130_fd_sc_hd__decap_3
X_5204_ _5213_/A _5204_/B VGND VGND VPWR VPWR _5204_/Y sky130_fd_sc_hd__nand2_2
X_6184_ _7035_/CLK _6184_/D load_slew843/X VGND VGND VPWR VPWR _6184_/Q sky130_fd_sc_hd__dfrtp_2
X_3396_ _6317_/Q _6429_/Q VGND VGND VPWR VPWR _3396_/X sky130_fd_sc_hd__xor2_2
XTAP_TAPCELL_ROW_51_1515 VGND VPWR sky130_fd_sc_hd__tapvpwrvgnd_1
XTAP_TAPCELL_ROW_4_305 VGND VPWR sky130_fd_sc_hd__tapvpwrvgnd_1
XTAP_TAPCELL_ROW_51_1526 VGND VPWR sky130_fd_sc_hd__tapvpwrvgnd_1
XFILLER_44_1347 VGND VGND VPWR VPWR sky130_fd_sc_hd__decap_3
XTAP_TAPCELL_ROW_51_1537 VGND VPWR sky130_fd_sc_hd__tapvpwrvgnd_1
XTAP_TAPCELL_ROW_4_316 VGND VPWR sky130_fd_sc_hd__tapvpwrvgnd_1
X_5135_ _6376_/Q wire105/X _4908_/S _5134_/X VGND VGND VPWR VPWR _6376_/D sky130_fd_sc_hd__a22o_2
Xhold1503 _6625_/Q VGND VGND VPWR VPWR _5542_/B1 sky130_fd_sc_hd__dlygate4sd3_1
Xhold1514 _6578_/Q VGND VGND VPWR VPWR _5466_/A1 sky130_fd_sc_hd__dlygate4sd3_1
Xhold1525 _6537_/Q VGND VGND VPWR VPWR _5425_/A1 sky130_fd_sc_hd__dlygate4sd3_1
XFILLER_69_386 VGND VGND VPWR VPWR sky130_fd_sc_hd__decap_3
Xhold1536 _6680_/Q VGND VGND VPWR VPWR _5609_/B2 sky130_fd_sc_hd__dlygate4sd3_1
Xload_slew794 fanout793/X VGND VGND VPWR VPWR fanout791/A sky130_fd_sc_hd__buf_2
Xhold1547 _6603_/Q VGND VGND VPWR VPWR _5500_/A1 sky130_fd_sc_hd__dlygate4sd3_1
Xhold1558 _6650_/Q VGND VGND VPWR VPWR _5570_/A1 sky130_fd_sc_hd__dlygate4sd3_1
X_5066_ _6399_/Q _5267_/B _5359_/B VGND VGND VPWR VPWR _5066_/Y sky130_fd_sc_hd__a21oi_2
XFILLER_38_740 VGND VGND VPWR VPWR sky130_fd_sc_hd__decap_3
Xhold1569 _6668_/Q VGND VGND VPWR VPWR _5596_/B2 sky130_fd_sc_hd__dlygate4sd3_1
XTAP_TAPCELL_ROW_28_919 VGND VPWR sky130_fd_sc_hd__tapvpwrvgnd_1
XFILLER_77_1101 VGND VGND VPWR VPWR sky130_fd_sc_hd__decap_3
XFILLER_38_773 VGND VGND VPWR VPWR sky130_fd_sc_hd__decap_3
XFILLER_44_209 VGND VGND VPWR VPWR sky130_fd_sc_hd__fill_1
X_4017_ _4065_/B _4588_/B VGND VGND VPWR VPWR _4017_/Y sky130_fd_sc_hd__nor2_2
XFILLER_53_732 VGND VGND VPWR VPWR sky130_fd_sc_hd__decap_3
XFILLER_65_592 VGND VGND VPWR VPWR sky130_fd_sc_hd__decap_3
XFILLER_77_1145 VGND VGND VPWR VPWR sky130_fd_sc_hd__decap_3
XFILLER_0_1441 VGND VGND VPWR VPWR sky130_fd_sc_hd__decap_3
XFILLER_25_445 VGND VGND VPWR VPWR sky130_fd_sc_hd__decap_3
XTAP_TAPCELL_ROW_49_1466 VGND VPWR sky130_fd_sc_hd__tapvpwrvgnd_1
XFILLER_20_1391 VGND VGND VPWR VPWR sky130_fd_sc_hd__decap_3
XTAP_TAPCELL_ROW_49_1477 VGND VPWR sky130_fd_sc_hd__tapvpwrvgnd_1
XFILLER_52_242 VGND VGND VPWR VPWR sky130_fd_sc_hd__fill_1
XFILLER_0_1463 VGND VGND VPWR VPWR sky130_fd_sc_hd__decap_3
XFILLER_52_253 VGND VGND VPWR VPWR sky130_fd_sc_hd__fill_1
XFILLER_77_1189 VGND VGND VPWR VPWR sky130_fd_sc_hd__decap_3
XFILLER_55_1410 VGND VGND VPWR VPWR sky130_fd_sc_hd__decap_3
XFILLER_41_949 VGND VGND VPWR VPWR sky130_fd_sc_hd__decap_3
X_5968_ hold926/X hold943/X _6015_/S VGND VGND VPWR VPWR _6972_/D sky130_fd_sc_hd__mux2_1
XFILLER_80_595 VGND VGND VPWR VPWR sky130_fd_sc_hd__decap_3
XFILLER_55_1443 VGND VGND VPWR VPWR sky130_fd_sc_hd__decap_3
X_4919_ _6378_/Q _5204_/B _5083_/A VGND VGND VPWR VPWR _4919_/Y sky130_fd_sc_hd__a21oi_2
XFILLER_16_1427 VGND VGND VPWR VPWR sky130_fd_sc_hd__fill_1
XFILLER_51_1307 VGND VGND VPWR VPWR sky130_fd_sc_hd__decap_3
XFILLER_16_1438 VGND VGND VPWR VPWR sky130_fd_sc_hd__decap_3
X_5899_ _5899_/A0 _5899_/A1 _5905_/S VGND VGND VPWR VPWR _6907_/D sky130_fd_sc_hd__mux2_1
XFILLER_21_662 VGND VGND VPWR VPWR sky130_fd_sc_hd__fill_1
XFILLER_32_68 VGND VGND VPWR VPWR sky130_fd_sc_hd__fill_1
XFILLER_20_194 VGND VGND VPWR VPWR sky130_fd_sc_hd__fill_2
XFILLER_49_1236 VGND VGND VPWR VPWR sky130_fd_sc_hd__decap_3
XFILLER_79_106 VGND VGND VPWR VPWR sky130_fd_sc_hd__fill_2
XFILLER_49_1269 VGND VGND VPWR VPWR sky130_fd_sc_hd__decap_3
XFILLER_0_511 VGND VGND VPWR VPWR sky130_fd_sc_hd__decap_3
XFILLER_62_1403 VGND VGND VPWR VPWR sky130_fd_sc_hd__decap_3
XFILLER_0_533 VGND VGND VPWR VPWR sky130_fd_sc_hd__decap_3
XFILLER_76_813 VGND VGND VPWR VPWR sky130_fd_sc_hd__fill_1
XFILLER_62_1447 VGND VGND VPWR VPWR sky130_fd_sc_hd__decap_3
XFILLER_57_54 VGND VGND VPWR VPWR sky130_fd_sc_hd__fill_2
XFILLER_76_857 VGND VGND VPWR VPWR sky130_fd_sc_hd__decap_3
XFILLER_75_334 VGND VGND VPWR VPWR sky130_fd_sc_hd__fill_2
XFILLER_29_751 VGND VGND VPWR VPWR sky130_fd_sc_hd__decap_3
XFILLER_75_367 VGND VGND VPWR VPWR sky130_fd_sc_hd__fill_1
XFILLER_5_1363 VGND VGND VPWR VPWR sky130_fd_sc_hd__decap_3
XFILLER_60_1182 VGND VGND VPWR VPWR sky130_fd_sc_hd__decap_3
XFILLER_1_1216 VGND VGND VPWR VPWR sky130_fd_sc_hd__decap_3
XFILLER_21_1144 VGND VGND VPWR VPWR sky130_fd_sc_hd__fill_2
XFILLER_5_1396 VGND VGND VPWR VPWR sky130_fd_sc_hd__decap_3
XFILLER_56_570 VGND VGND VPWR VPWR sky130_fd_sc_hd__decap_3
XFILLER_17_935 VGND VGND VPWR VPWR sky130_fd_sc_hd__decap_3
XFILLER_73_42 VGND VGND VPWR VPWR sky130_fd_sc_hd__decap_3
XFILLER_17_968 VGND VGND VPWR VPWR sky130_fd_sc_hd__decap_3
XFILLER_43_242 VGND VGND VPWR VPWR sky130_fd_sc_hd__decap_3
XFILLER_16_467 VGND VGND VPWR VPWR sky130_fd_sc_hd__decap_3
XFILLER_44_776 VGND VGND VPWR VPWR sky130_fd_sc_hd__decap_3
XFILLER_56_1229 VGND VGND VPWR VPWR sky130_fd_sc_hd__decap_3
XFILLER_73_75 VGND VGND VPWR VPWR sky130_fd_sc_hd__decap_3
XFILLER_16_489 VGND VGND VPWR VPWR sky130_fd_sc_hd__fill_1
XFILLER_19_1040 VGND VGND VPWR VPWR sky130_fd_sc_hd__decap_3
XFILLER_19_1073 VGND VGND VPWR VPWR sky130_fd_sc_hd__decap_3
XFILLER_12_651 VGND VGND VPWR VPWR sky130_fd_sc_hd__decap_3
XFILLER_8_611 VGND VGND VPWR VPWR sky130_fd_sc_hd__decap_3
XFILLER_7_110 VGND VGND VPWR VPWR sky130_fd_sc_hd__fill_2
XFILLER_8_655 VGND VGND VPWR VPWR sky130_fd_sc_hd__decap_3
XFILLER_32_1273 VGND VGND VPWR VPWR sky130_fd_sc_hd__decap_3
XFILLER_67_1325 VGND VGND VPWR VPWR sky130_fd_sc_hd__decap_3
XFILLER_4_861 VGND VGND VPWR VPWR sky130_fd_sc_hd__decap_3
XFILLER_28_1309 VGND VGND VPWR VPWR sky130_fd_sc_hd__decap_3
XFILLER_4_872 VGND VGND VPWR VPWR sky130_fd_sc_hd__fill_2
XFILLER_67_1369 VGND VGND VPWR VPWR sky130_fd_sc_hd__decap_3
XFILLER_4_894 VGND VGND VPWR VPWR sky130_fd_sc_hd__decap_3
X_3250_ _6260_/Q _6356_/Q VGND VGND VPWR VPWR _3250_/X sky130_fd_sc_hd__xor2_2
XFILLER_3_393 VGND VGND VPWR VPWR sky130_fd_sc_hd__decap_3
XFILLER_6_1105 VGND VGND VPWR VPWR sky130_fd_sc_hd__decap_3
XFILLER_78_150 VGND VGND VPWR VPWR sky130_fd_sc_hd__fill_1
XFILLER_67_813 VGND VGND VPWR VPWR sky130_fd_sc_hd__decap_3
X_3181_ _3202_/A _3177_/X _3180_/X _3175_/X VGND VGND VPWR VPWR _3181_/X sky130_fd_sc_hd__a31o_2
XFILLER_66_312 VGND VGND VPWR VPWR sky130_fd_sc_hd__fill_2
XFILLER_67_835 VGND VGND VPWR VPWR sky130_fd_sc_hd__decap_3
XFILLER_78_172 VGND VGND VPWR VPWR sky130_fd_sc_hd__decap_3
XFILLER_6_1138 VGND VGND VPWR VPWR sky130_fd_sc_hd__decap_3
XFILLER_6_1149 VGND VGND VPWR VPWR sky130_fd_sc_hd__decap_3
XFILLER_14_3 VGND VGND VPWR VPWR sky130_fd_sc_hd__decap_3
XFILLER_26_1088 VGND VGND VPWR VPWR sky130_fd_sc_hd__decap_3
XFILLER_39_559 VGND VGND VPWR VPWR sky130_fd_sc_hd__fill_1
XFILLER_26_209 VGND VGND VPWR VPWR sky130_fd_sc_hd__fill_1
X_6940_ _6987_/CLK _6940_/D load_slew834/X VGND VGND VPWR VPWR _6940_/Q sky130_fd_sc_hd__dfrtp_2
XFILLER_78_1421 VGND VGND VPWR VPWR sky130_fd_sc_hd__decap_3
XFILLER_78_1432 VGND VGND VPWR VPWR sky130_fd_sc_hd__decap_3
XFILLER_35_732 VGND VGND VPWR VPWR sky130_fd_sc_hd__fill_2
XFILLER_47_592 VGND VGND VPWR VPWR sky130_fd_sc_hd__decap_3
XFILLER_78_1465 VGND VGND VPWR VPWR sky130_fd_sc_hd__decap_3
XFILLER_39_1416 VGND VGND VPWR VPWR sky130_fd_sc_hd__decap_3
X_6871_ _6999_/CLK _6871_/D wire827/X VGND VGND VPWR VPWR _6871_/Q sky130_fd_sc_hd__dfrtp_2
XFILLER_23_905 VGND VGND VPWR VPWR sky130_fd_sc_hd__decap_3
XFILLER_74_1329 VGND VGND VPWR VPWR sky130_fd_sc_hd__decap_3
XFILLER_34_253 VGND VGND VPWR VPWR sky130_fd_sc_hd__decap_3
XFILLER_39_1449 VGND VGND VPWR VPWR sky130_fd_sc_hd__decap_3
XFILLER_50_713 VGND VGND VPWR VPWR sky130_fd_sc_hd__decap_3
X_5822_ _5822_/A0 _5858_/A1 _5822_/S VGND VGND VPWR VPWR _6841_/D sky130_fd_sc_hd__mux2_1
XFILLER_37_1140 VGND VGND VPWR VPWR sky130_fd_sc_hd__decap_3
XFILLER_50_746 VGND VGND VPWR VPWR sky130_fd_sc_hd__decap_3
XFILLER_50_757 VGND VGND VPWR VPWR sky130_fd_sc_hd__decap_3
X_5753_ _5910_/A0 _5753_/A1 _5757_/S VGND VGND VPWR VPWR _6797_/D sky130_fd_sc_hd__mux2_1
XTAP_TAPCELL_ROW_44_1341 VGND VPWR sky130_fd_sc_hd__tapvpwrvgnd_1
XTAP_TAPCELL_ROW_44_1352 VGND VPWR sky130_fd_sc_hd__tapvpwrvgnd_1
XFILLER_50_779 VGND VGND VPWR VPWR sky130_fd_sc_hd__decap_3
X_4704_ _6557_/Q _4703_/A _4880_/C1 VGND VGND VPWR VPWR _4704_/X sky130_fd_sc_hd__a21bo_2
X_5684_ hold915/X _5801_/C wire90/X VGND VGND VPWR VPWR _6737_/D sky130_fd_sc_hd__mux2_1
XTAP_TAPCELL_ROW_40_1238 VGND VPWR sky130_fd_sc_hd__tapvpwrvgnd_1
XFILLER_30_492 VGND VGND VPWR VPWR sky130_fd_sc_hd__decap_3
XTAP_TAPCELL_ROW_40_1249 VGND VPWR sky130_fd_sc_hd__tapvpwrvgnd_1
XFILLER_15_1460 VGND VGND VPWR VPWR sky130_fd_sc_hd__decap_3
X_4635_ _6885_/Q _4635_/A2 _4633_/X _4634_/X VGND VGND VPWR VPWR _4635_/X sky130_fd_sc_hd__a211o_2
XFILLER_11_1313 VGND VGND VPWR VPWR sky130_fd_sc_hd__decap_3
XFILLER_50_1362 VGND VGND VPWR VPWR sky130_fd_sc_hd__decap_3
XFILLER_50_1373 VGND VGND VPWR VPWR sky130_fd_sc_hd__decap_3
XFILLER_11_1357 VGND VGND VPWR VPWR sky130_fd_sc_hd__decap_3
X_4566_ _4562_/X _4563_/X _4565_/Y _4558_/A VGND VGND VPWR VPWR _4566_/X sky130_fd_sc_hd__o211a_2
XFILLER_2_809 VGND VGND VPWR VPWR sky130_fd_sc_hd__decap_3
X_6305_ _6923_/CLK _6305_/D fanout798/X VGND VGND VPWR VPWR _6305_/Q sky130_fd_sc_hd__dfrtp_2
X_3517_ _6646_/Q _4723_/C VGND VGND VPWR VPWR _3517_/Y sky130_fd_sc_hd__nor2_2
XFILLER_1_308 VGND VGND VPWR VPWR sky130_fd_sc_hd__decap_3
XFILLER_46_1409 VGND VGND VPWR VPWR sky130_fd_sc_hd__decap_3
X_4497_ _6521_/Q _4518_/A _4619_/A1 VGND VGND VPWR VPWR _4497_/X sky130_fd_sc_hd__a21bo_2
X_6236_ _7001_/CLK _6236_/D load_slew775/X VGND VGND VPWR VPWR _6236_/Q sky130_fd_sc_hd__dfrtp_2
XTAP_TAPCELL_ROW_38_1178 VGND VPWR sky130_fd_sc_hd__tapvpwrvgnd_1
X_3448_ _6335_/Q _6455_/Q VGND VGND VPWR VPWR _3448_/X sky130_fd_sc_hd__xor2_2
XTAP_TAPCELL_ROW_38_1189 VGND VPWR sky130_fd_sc_hd__tapvpwrvgnd_1
XFILLER_48_1291 VGND VGND VPWR VPWR sky130_fd_sc_hd__decap_3
XFILLER_44_1133 VGND VGND VPWR VPWR sky130_fd_sc_hd__decap_3
XFILLER_58_813 VGND VGND VPWR VPWR sky130_fd_sc_hd__decap_3
X_6167_ _7050_/CLK _6167_/D load_slew645/X VGND VGND VPWR VPWR _6167_/Q sky130_fd_sc_hd__dfrtp_2
Xhold1300 _6917_/Q VGND VGND VPWR VPWR _5910_/A1 sky130_fd_sc_hd__dlygate4sd3_1
X_3379_ _6010_/A0 _3378_/X _3379_/S VGND VGND VPWR VPWR _6163_/D sky130_fd_sc_hd__mux2_1
Xhold1311 _7006_/Q VGND VGND VPWR VPWR _6002_/A1 sky130_fd_sc_hd__dlygate4sd3_1
Xhold1322 _6755_/Q VGND VGND VPWR VPWR _5706_/A1 sky130_fd_sc_hd__dlygate4sd3_1
X_5118_ _6616_/Q _6656_/Q VGND VGND VPWR VPWR _5119_/B sky130_fd_sc_hd__xnor2_2
XFILLER_44_1188 VGND VGND VPWR VPWR sky130_fd_sc_hd__decap_3
Xload_slew591 _4420_/B VGND VGND VPWR VPWR _3504_/S0 sky130_fd_sc_hd__buf_4
Xhold1333 _6901_/Q VGND VGND VPWR VPWR _5892_/A1 sky130_fd_sc_hd__dlygate4sd3_1
XFILLER_79_1207 VGND VGND VPWR VPWR sky130_fd_sc_hd__decap_3
Xhold1344 _6936_/Q VGND VGND VPWR VPWR _5931_/A1 sky130_fd_sc_hd__dlygate4sd3_1
X_6098_ _7050_/CLK _6098_/D load_slew645/X VGND VGND VPWR VPWR _6098_/Q sky130_fd_sc_hd__dfrtp_2
Xhold1355 _6648_/Q VGND VGND VPWR VPWR _5565_/B1 sky130_fd_sc_hd__dlygate4sd3_1
Xhold1366 _6763_/Q VGND VGND VPWR VPWR _5715_/A1 sky130_fd_sc_hd__dlygate4sd3_1
Xhold1377 _6766_/Q VGND VGND VPWR VPWR _5718_/A1 sky130_fd_sc_hd__dlygate4sd3_1
XFILLER_22_1453 VGND VGND VPWR VPWR sky130_fd_sc_hd__decap_3
XFILLER_72_315 VGND VGND VPWR VPWR sky130_fd_sc_hd__decap_3
X_5049_ _6461_/Q _6679_/Q VGND VGND VPWR VPWR _5050_/B sky130_fd_sc_hd__xor2_2
Xhold1388 _6885_/Q VGND VGND VPWR VPWR _5874_/A1 sky130_fd_sc_hd__dlygate4sd3_1
XFILLER_27_57 VGND VGND VPWR VPWR sky130_fd_sc_hd__decap_3
XFILLER_26_710 VGND VGND VPWR VPWR sky130_fd_sc_hd__decap_3
Xhold1399 _6845_/Q VGND VGND VPWR VPWR _5827_/A1 sky130_fd_sc_hd__dlygate4sd3_1
XFILLER_26_754 VGND VGND VPWR VPWR sky130_fd_sc_hd__fill_2
XFILLER_14_938 VGND VGND VPWR VPWR sky130_fd_sc_hd__decap_3
XFILLER_26_798 VGND VGND VPWR VPWR sky130_fd_sc_hd__decap_3
XFILLER_43_12 VGND VGND VPWR VPWR sky130_fd_sc_hd__decap_3
XFILLER_25_275 VGND VGND VPWR VPWR sky130_fd_sc_hd__decap_3
XFILLER_0_1282 VGND VGND VPWR VPWR sky130_fd_sc_hd__decap_3
XFILLER_41_735 VGND VGND VPWR VPWR sky130_fd_sc_hd__decap_3
XFILLER_13_437 VGND VGND VPWR VPWR sky130_fd_sc_hd__decap_3
XFILLER_43_34 VGND VGND VPWR VPWR sky130_fd_sc_hd__decap_3
XFILLER_13_459 VGND VGND VPWR VPWR sky130_fd_sc_hd__decap_3
XFILLER_9_408 VGND VGND VPWR VPWR sky130_fd_sc_hd__decap_3
XFILLER_41_768 VGND VGND VPWR VPWR sky130_fd_sc_hd__decap_3
XFILLER_55_1251 VGND VGND VPWR VPWR sky130_fd_sc_hd__decap_3
XFILLER_40_256 VGND VGND VPWR VPWR sky130_fd_sc_hd__decap_3
XFILLER_16_1235 VGND VGND VPWR VPWR sky130_fd_sc_hd__decap_3
XFILLER_43_89 VGND VGND VPWR VPWR sky130_fd_sc_hd__decap_3
XFILLER_55_1284 VGND VGND VPWR VPWR sky130_fd_sc_hd__decap_3
XFILLER_55_1295 VGND VGND VPWR VPWR sky130_fd_sc_hd__decap_3
XFILLER_22_993 VGND VGND VPWR VPWR sky130_fd_sc_hd__decap_3
XFILLER_16_1279 VGND VGND VPWR VPWR sky130_fd_sc_hd__decap_3
XFILLER_5_614 VGND VGND VPWR VPWR sky130_fd_sc_hd__fill_2
XFILLER_4_113 VGND VGND VPWR VPWR sky130_fd_sc_hd__decap_3
XFILLER_5_669 VGND VGND VPWR VPWR sky130_fd_sc_hd__decap_3
XFILLER_4_168 VGND VGND VPWR VPWR sky130_fd_sc_hd__decap_3
XFILLER_0_330 VGND VGND VPWR VPWR sky130_fd_sc_hd__decap_3
XFILLER_1_853 VGND VGND VPWR VPWR sky130_fd_sc_hd__decap_3
XFILLER_27_1331 VGND VGND VPWR VPWR sky130_fd_sc_hd__decap_3
XFILLER_62_1211 VGND VGND VPWR VPWR sky130_fd_sc_hd__decap_3
XFILLER_68_53 VGND VGND VPWR VPWR sky130_fd_sc_hd__decap_3
XFILLER_49_802 VGND VGND VPWR VPWR sky130_fd_sc_hd__fill_1
XFILLER_66_1391 VGND VGND VPWR VPWR sky130_fd_sc_hd__decap_3
XFILLER_0_352 VGND VGND VPWR VPWR sky130_fd_sc_hd__decap_3
XFILLER_7_1425 VGND VGND VPWR VPWR sky130_fd_sc_hd__decap_3
XFILLER_1_886 VGND VGND VPWR VPWR sky130_fd_sc_hd__decap_3
XFILLER_49_824 VGND VGND VPWR VPWR sky130_fd_sc_hd__decap_3
XFILLER_62_1244 VGND VGND VPWR VPWR sky130_fd_sc_hd__decap_3
XFILLER_1_897 VGND VGND VPWR VPWR sky130_fd_sc_hd__decap_3
XFILLER_0_374 VGND VGND VPWR VPWR sky130_fd_sc_hd__decap_3
XFILLER_27_1375 VGND VGND VPWR VPWR sky130_fd_sc_hd__decap_3
XFILLER_76_632 VGND VGND VPWR VPWR sky130_fd_sc_hd__decap_3
XFILLER_0_396 VGND VGND VPWR VPWR sky130_fd_sc_hd__decap_3
XFILLER_23_1239 VGND VGND VPWR VPWR sky130_fd_sc_hd__decap_3
XFILLER_49_868 VGND VGND VPWR VPWR sky130_fd_sc_hd__fill_1
XFILLER_62_1288 VGND VGND VPWR VPWR sky130_fd_sc_hd__decap_3
XFILLER_75_131 VGND VGND VPWR VPWR sky130_fd_sc_hd__decap_3
XFILLER_48_345 VGND VGND VPWR VPWR sky130_fd_sc_hd__fill_2
XFILLER_5_1160 VGND VGND VPWR VPWR sky130_fd_sc_hd__decap_3
XTAP_TAPCELL_ROW_19_705 VGND VPWR sky130_fd_sc_hd__tapvpwrvgnd_1
XFILLER_36_518 VGND VGND VPWR VPWR sky130_fd_sc_hd__fill_1
XFILLER_1_1024 VGND VGND VPWR VPWR sky130_fd_sc_hd__decap_3
XFILLER_17_732 VGND VGND VPWR VPWR sky130_fd_sc_hd__decap_3
XFILLER_63_337 VGND VGND VPWR VPWR sky130_fd_sc_hd__decap_3
XFILLER_1_1057 VGND VGND VPWR VPWR sky130_fd_sc_hd__decap_3
XFILLER_72_860 VGND VGND VPWR VPWR sky130_fd_sc_hd__decap_3
XFILLER_1_1068 VGND VGND VPWR VPWR sky130_fd_sc_hd__decap_3
XFILLER_16_253 VGND VGND VPWR VPWR sky130_fd_sc_hd__decap_3
XFILLER_56_1015 VGND VGND VPWR VPWR sky130_fd_sc_hd__fill_1
XFILLER_71_370 VGND VGND VPWR VPWR sky130_fd_sc_hd__decap_3
XFILLER_56_1037 VGND VGND VPWR VPWR sky130_fd_sc_hd__decap_3
XFILLER_56_1048 VGND VGND VPWR VPWR sky130_fd_sc_hd__fill_1
XTAP_TAPCELL_ROW_80_2275 VGND VPWR sky130_fd_sc_hd__tapvpwrvgnd_1
XFILLER_73_1340 VGND VGND VPWR VPWR sky130_fd_sc_hd__decap_3
XTAP_TAPCELL_ROW_80_2286 VGND VPWR sky130_fd_sc_hd__tapvpwrvgnd_1
XFILLER_73_1351 VGND VGND VPWR VPWR sky130_fd_sc_hd__decap_3
XTAP_TAPCELL_ROW_80_2297 VGND VPWR sky130_fd_sc_hd__tapvpwrvgnd_1
XFILLER_73_1384 VGND VGND VPWR VPWR sky130_fd_sc_hd__decap_3
XFILLER_34_1335 VGND VGND VPWR VPWR sky130_fd_sc_hd__decap_3
XFILLER_12_470 VGND VGND VPWR VPWR sky130_fd_sc_hd__decap_3
XFILLER_8_430 VGND VGND VPWR VPWR sky130_fd_sc_hd__decap_3
XFILLER_34_1368 VGND VGND VPWR VPWR sky130_fd_sc_hd__decap_3
XFILLER_34_1379 VGND VGND VPWR VPWR sky130_fd_sc_hd__decap_3
XTAP_TAPCELL_ROW_30_969 VGND VPWR sky130_fd_sc_hd__tapvpwrvgnd_1
XFILLER_8_463 VGND VGND VPWR VPWR sky130_fd_sc_hd__decap_3
X_4420_ _4420_/A _4420_/B _4420_/C _5581_/B VGND VGND VPWR VPWR _4420_/X sky130_fd_sc_hd__or4b_2
X_4351_ _6495_/Q _3483_/A _4896_/C1 _4350_/X VGND VGND VPWR VPWR _4351_/X sky130_fd_sc_hd__o211a_2
XFILLER_67_1166 VGND VGND VPWR VPWR sky130_fd_sc_hd__decap_3
X_3302_ _6278_/Q _6382_/Q VGND VGND VPWR VPWR _3302_/X sky130_fd_sc_hd__xor2_2
XFILLER_67_1177 VGND VGND VPWR VPWR sky130_fd_sc_hd__decap_3
X_7070_ _7072_/CLK _7070_/D wire687/X VGND VGND VPWR VPWR _7070_/Q sky130_fd_sc_hd__dfrtp_2
Xfanout409 _4382_/C1 VGND VGND VPWR VPWR _4558_/A sky130_fd_sc_hd__clkdlybuf4s25_1
X_4282_ _4282_/A _4282_/B VGND VGND VPWR VPWR _4851_/B sky130_fd_sc_hd__xnor2_2
XFILLER_45_1431 VGND VGND VPWR VPWR sky130_fd_sc_hd__decap_3
X_6021_ _6174_/Q _6021_/A1 _6021_/S VGND VGND VPWR VPWR _6021_/X sky130_fd_sc_hd__mux2_1
X_3233_ hold945/X _3232_/X _7087_/D VGND VGND VPWR VPWR _6090_/D sky130_fd_sc_hd__mux2_1
XFILLER_39_323 VGND VGND VPWR VPWR sky130_fd_sc_hd__decap_3
XFILLER_80_1366 VGND VGND VPWR VPWR sky130_fd_sc_hd__decap_3
XTAP_TAPCELL_ROW_33_1053 VGND VPWR sky130_fd_sc_hd__tapvpwrvgnd_1
XTAP_TAPCELL_ROW_33_1064 VGND VPWR sky130_fd_sc_hd__tapvpwrvgnd_1
XFILLER_41_1328 VGND VGND VPWR VPWR sky130_fd_sc_hd__decap_3
XFILLER_80_1388 VGND VGND VPWR VPWR sky130_fd_sc_hd__decap_3
X_3164_ _6949_/Q _6957_/Q _3200_/S VGND VGND VPWR VPWR _3164_/X sky130_fd_sc_hd__mux2_1
XFILLER_54_304 VGND VGND VPWR VPWR sky130_fd_sc_hd__decap_3
XFILLER_55_849 VGND VGND VPWR VPWR sky130_fd_sc_hd__fill_1
X_3095_ _5506_/A _5515_/A1 _5210_/A VGND VGND VPWR VPWR _7088_/D sky130_fd_sc_hd__a21o_2
XFILLER_66_197 VGND VGND VPWR VPWR sky130_fd_sc_hd__decap_3
X_6923_ _6923_/CLK _6923_/D fanout800/X VGND VGND VPWR VPWR _6923_/Q sky130_fd_sc_hd__dfrtp_2
XTAP_TAPCELL_ROW_46_1403 VGND VPWR sky130_fd_sc_hd__tapvpwrvgnd_1
XFILLER_78_1273 VGND VGND VPWR VPWR sky130_fd_sc_hd__decap_3
XFILLER_74_1126 VGND VGND VPWR VPWR sky130_fd_sc_hd__decap_3
X_6854_ _6918_/CLK _6854_/D fanout746/X VGND VGND VPWR VPWR _6854_/Q sky130_fd_sc_hd__dfrtp_2
XFILLER_23_735 VGND VGND VPWR VPWR sky130_fd_sc_hd__decap_3
XFILLER_39_1257 VGND VGND VPWR VPWR sky130_fd_sc_hd__decap_3
Xfanout16 _5577_/B VGND VGND VPWR VPWR _4586_/B sky130_fd_sc_hd__clkdlybuf4s25_1
XFILLER_22_245 VGND VGND VPWR VPWR sky130_fd_sc_hd__decap_3
X_5805_ _5879_/A _5850_/B _6069_/S _5906_/B VGND VGND VPWR VPWR _5813_/S sky130_fd_sc_hd__or4bb_2
X_6785_ _7089_/CLK _6785_/D wire734/X VGND VGND VPWR VPWR _6785_/Q sky130_fd_sc_hd__dfrtp_2
XFILLER_22_256 VGND VGND VPWR VPWR sky130_fd_sc_hd__fill_2
X_3997_ _4095_/B _4422_/A VGND VGND VPWR VPWR _3997_/Y sky130_fd_sc_hd__nor2_2
XFILLER_13_15 VGND VGND VPWR VPWR sky130_fd_sc_hd__decap_3
XFILLER_52_1424 VGND VGND VPWR VPWR sky130_fd_sc_hd__decap_3
XFILLER_52_1435 VGND VGND VPWR VPWR sky130_fd_sc_hd__decap_3
X_5736_ _5929_/A0 _5736_/A1 _5739_/S VGND VGND VPWR VPWR _6782_/D sky130_fd_sc_hd__mux2_1
XFILLER_13_1419 VGND VGND VPWR VPWR sky130_fd_sc_hd__decap_3
XFILLER_52_1468 VGND VGND VPWR VPWR sky130_fd_sc_hd__fill_1
X_5667_ _5749_/A _5722_/A _7067_/Q _5685_/C VGND VGND VPWR VPWR _5674_/S sky130_fd_sc_hd__and4_2
XFILLER_11_1132 VGND VGND VPWR VPWR sky130_fd_sc_hd__decap_3
X_4618_ _6545_/Q _4624_/A _4619_/A1 VGND VGND VPWR VPWR _4618_/X sky130_fd_sc_hd__a21bo_2
X_5598_ _5607_/A1 _4694_/C _5601_/B1 _5598_/B2 VGND VGND VPWR VPWR _6670_/D sky130_fd_sc_hd__a22o_2
XFILLER_11_1165 VGND VGND VPWR VPWR sky130_fd_sc_hd__decap_3
X_4549_ _6536_/Q _4549_/B VGND VGND VPWR VPWR _4549_/Y sky130_fd_sc_hd__nand2_2
XFILLER_11_1198 VGND VGND VPWR VPWR sky130_fd_sc_hd__decap_3
XFILLER_1_105 VGND VGND VPWR VPWR sky130_fd_sc_hd__decap_3
XFILLER_1_116 VGND VGND VPWR VPWR sky130_fd_sc_hd__decap_3
XFILLER_1_149 VGND VGND VPWR VPWR sky130_fd_sc_hd__decap_3
X_6219_ _7037_/CLK _6219_/D fanout693/X VGND VGND VPWR VPWR _6219_/Q sky130_fd_sc_hd__dfrtp_2
XFILLER_38_12 VGND VGND VPWR VPWR sky130_fd_sc_hd__fill_2
XFILLER_58_643 VGND VGND VPWR VPWR sky130_fd_sc_hd__fill_1
XFILLER_58_654 VGND VGND VPWR VPWR sky130_fd_sc_hd__decap_3
Xhold1130 _6992_/Q VGND VGND VPWR VPWR _5988_/A1 sky130_fd_sc_hd__dlygate4sd3_1
Xhold1141 _6697_/Q VGND VGND VPWR VPWR _5638_/A1 sky130_fd_sc_hd__dlygate4sd3_1
XFILLER_46_816 VGND VGND VPWR VPWR sky130_fd_sc_hd__decap_3
XFILLER_57_142 VGND VGND VPWR VPWR sky130_fd_sc_hd__fill_1
XFILLER_79_1004 VGND VGND VPWR VPWR sky130_fd_sc_hd__decap_3
Xhold1152 _7027_/Q VGND VGND VPWR VPWR _6023_/A1 sky130_fd_sc_hd__dlygate4sd3_1
XFILLER_2_1300 VGND VGND VPWR VPWR sky130_fd_sc_hd__decap_3
XFILLER_45_304 VGND VGND VPWR VPWR sky130_fd_sc_hd__decap_3
Xhold1163 _6692_/Q VGND VGND VPWR VPWR _5633_/A1 sky130_fd_sc_hd__dlygate4sd3_1
XFILLER_58_698 VGND VGND VPWR VPWR sky130_fd_sc_hd__fill_2
XFILLER_79_1037 VGND VGND VPWR VPWR sky130_fd_sc_hd__fill_1
Xhold1174 _6119_/Q VGND VGND VPWR VPWR _5966_/A0 sky130_fd_sc_hd__dlygate4sd3_1
XFILLER_79_1048 VGND VGND VPWR VPWR sky130_fd_sc_hd__decap_3
XFILLER_22_1261 VGND VGND VPWR VPWR sky130_fd_sc_hd__decap_3
Xhold1185 _6811_/Q VGND VGND VPWR VPWR _5776_/A0 sky130_fd_sc_hd__dlygate4sd3_1
Xhold1196 _6792_/Q VGND VGND VPWR VPWR _5747_/A1 sky130_fd_sc_hd__dlygate4sd3_1
XFILLER_2_1344 VGND VGND VPWR VPWR sky130_fd_sc_hd__decap_3
XFILLER_45_348 VGND VGND VPWR VPWR sky130_fd_sc_hd__decap_3
XFILLER_22_1294 VGND VGND VPWR VPWR sky130_fd_sc_hd__decap_3
XFILLER_72_156 VGND VGND VPWR VPWR sky130_fd_sc_hd__decap_3
XFILLER_57_1313 VGND VGND VPWR VPWR sky130_fd_sc_hd__decap_3
XFILLER_2_1388 VGND VGND VPWR VPWR sky130_fd_sc_hd__decap_3
XFILLER_60_307 VGND VGND VPWR VPWR sky130_fd_sc_hd__fill_1
XFILLER_54_55 VGND VGND VPWR VPWR sky130_fd_sc_hd__decap_3
XFILLER_14_724 VGND VGND VPWR VPWR sky130_fd_sc_hd__fill_1
XTAP_TAPCELL_ROW_0_171 VGND VPWR sky130_fd_sc_hd__tapvpwrvgnd_1
XTAP_TAPCELL_ROW_0_182 VGND VPWR sky130_fd_sc_hd__tapvpwrvgnd_1
XTAP_TAPCELL_ROW_0_193 VGND VPWR sky130_fd_sc_hd__tapvpwrvgnd_1
XFILLER_57_1357 VGND VGND VPWR VPWR sky130_fd_sc_hd__decap_3
XFILLER_70_21 VGND VGND VPWR VPWR sky130_fd_sc_hd__decap_3
XFILLER_16_1032 VGND VGND VPWR VPWR sky130_fd_sc_hd__decap_3
XFILLER_70_32 VGND VGND VPWR VPWR sky130_fd_sc_hd__decap_3
XFILLER_16_1076 VGND VGND VPWR VPWR sky130_fd_sc_hd__decap_3
XFILLER_10_963 VGND VGND VPWR VPWR sky130_fd_sc_hd__fill_1
XFILLER_6_923 VGND VGND VPWR VPWR sky130_fd_sc_hd__fill_1
Xclkload19 _6888_/CLK VGND VGND VPWR VPWR clkload19/X sky130_fd_sc_hd__clkbuf_8
XFILLER_6_934 VGND VGND VPWR VPWR sky130_fd_sc_hd__decap_3
XTAP_TAPCELL_ROW_11_479 VGND VPWR sky130_fd_sc_hd__tapvpwrvgnd_1
XFILLER_5_411 VGND VGND VPWR VPWR sky130_fd_sc_hd__decap_3
XFILLER_33_1390 VGND VGND VPWR VPWR sky130_fd_sc_hd__decap_3
XFILLER_79_30 VGND VGND VPWR VPWR sky130_fd_sc_hd__decap_3
XFILLER_5_455 VGND VGND VPWR VPWR sky130_fd_sc_hd__decap_3
XFILLER_29_1404 VGND VGND VPWR VPWR sky130_fd_sc_hd__decap_3
XFILLER_68_1453 VGND VGND VPWR VPWR sky130_fd_sc_hd__decap_3
XFILLER_5_488 VGND VGND VPWR VPWR sky130_fd_sc_hd__decap_3
XFILLER_79_63 VGND VGND VPWR VPWR sky130_fd_sc_hd__decap_3
XFILLER_64_1306 VGND VGND VPWR VPWR sky130_fd_sc_hd__decap_3
XFILLER_48_9 VGND VGND VPWR VPWR sky130_fd_sc_hd__decap_3
XFILLER_29_1437 VGND VGND VPWR VPWR sky130_fd_sc_hd__decap_3
XFILLER_64_1317 VGND VGND VPWR VPWR sky130_fd_sc_hd__decap_3
XTAP_TAPCELL_ROW_73_2090 VGND VPWR sky130_fd_sc_hd__tapvpwrvgnd_1
XFILLER_68_407 VGND VGND VPWR VPWR sky130_fd_sc_hd__fill_1
XFILLER_68_429 VGND VGND VPWR VPWR sky130_fd_sc_hd__decap_3
XFILLER_7_1222 VGND VGND VPWR VPWR sky130_fd_sc_hd__decap_3
XFILLER_7_1233 VGND VGND VPWR VPWR sky130_fd_sc_hd__decap_3
XFILLER_1_694 VGND VGND VPWR VPWR sky130_fd_sc_hd__decap_3
XFILLER_27_1172 VGND VGND VPWR VPWR sky130_fd_sc_hd__decap_3
XFILLER_7_1266 VGND VGND VPWR VPWR sky130_fd_sc_hd__decap_3
XFILLER_0_193 VGND VGND VPWR VPWR sky130_fd_sc_hd__decap_3
XFILLER_48_131 VGND VGND VPWR VPWR sky130_fd_sc_hd__decap_3
XFILLER_62_1074 VGND VGND VPWR VPWR sky130_fd_sc_hd__decap_3
XFILLER_3_1119 VGND VGND VPWR VPWR sky130_fd_sc_hd__fill_1
XFILLER_49_676 VGND VGND VPWR VPWR sky130_fd_sc_hd__fill_1
XFILLER_76_484 VGND VGND VPWR VPWR sky130_fd_sc_hd__fill_1
XFILLER_36_315 VGND VGND VPWR VPWR sky130_fd_sc_hd__decap_3
XFILLER_40_1350 VGND VGND VPWR VPWR sky130_fd_sc_hd__decap_3
XFILLER_48_197 VGND VGND VPWR VPWR sky130_fd_sc_hd__decap_3
XFILLER_36_348 VGND VGND VPWR VPWR sky130_fd_sc_hd__decap_3
XFILLER_52_808 VGND VGND VPWR VPWR sky130_fd_sc_hd__decap_3
XFILLER_40_1394 VGND VGND VPWR VPWR sky130_fd_sc_hd__decap_3
XFILLER_52_819 VGND VGND VPWR VPWR sky130_fd_sc_hd__decap_3
XFILLER_75_1413 VGND VGND VPWR VPWR sky130_fd_sc_hd__decap_3
XFILLER_17_573 VGND VGND VPWR VPWR sky130_fd_sc_hd__decap_3
X_3920_ _3722_/A _6310_/Q VGND VGND VPWR VPWR _3920_/X sky130_fd_sc_hd__and2b_2
XFILLER_75_1446 VGND VGND VPWR VPWR sky130_fd_sc_hd__decap_3
XFILLER_32_521 VGND VGND VPWR VPWR sky130_fd_sc_hd__fill_2
XFILLER_60_830 VGND VGND VPWR VPWR sky130_fd_sc_hd__decap_3
XFILLER_75_1457 VGND VGND VPWR VPWR sky130_fd_sc_hd__decap_3
XFILLER_72_690 VGND VGND VPWR VPWR sky130_fd_sc_hd__fill_1
X_3851_ _6499_/Q _4174_/A2 _4013_/A _3850_/X VGND VGND VPWR VPWR _3851_/X sky130_fd_sc_hd__o211a_2
XFILLER_32_598 VGND VGND VPWR VPWR sky130_fd_sc_hd__decap_3
X_6570_ _6819_/CLK _6570_/D fanout777/X VGND VGND VPWR VPWR _6570_/Q sky130_fd_sc_hd__dfrtp_2
XFILLER_73_1192 VGND VGND VPWR VPWR sky130_fd_sc_hd__decap_3
X_3782_ _4283_/A _4065_/B _3764_/X _4123_/B2 VGND VGND VPWR VPWR _3782_/X sky130_fd_sc_hd__o2bb2a_2
X_5521_ _6610_/Q _6617_/Q VGND VGND VPWR VPWR _5521_/Y sky130_fd_sc_hd__nand2_2
XFILLER_9_783 VGND VGND VPWR VPWR sky130_fd_sc_hd__fill_1
XFILLER_30_1029 VGND VGND VPWR VPWR sky130_fd_sc_hd__decap_3
XFILLER_34_1198 VGND VGND VPWR VPWR sky130_fd_sc_hd__decap_3
XFILLER_12_1441 VGND VGND VPWR VPWR sky130_fd_sc_hd__decap_3
X_5452_ _5452_/A1 _5484_/A2 _4037_/X VGND VGND VPWR VPWR _6564_/D sky130_fd_sc_hd__a21o_2
XFILLER_69_1228 VGND VGND VPWR VPWR sky130_fd_sc_hd__decap_3
XFILLER_69_1239 VGND VGND VPWR VPWR sky130_fd_sc_hd__decap_3
X_4403_ _4403_/A _4760_/B VGND VGND VPWR VPWR _4403_/Y sky130_fd_sc_hd__nor2_2
X_5383_ _5383_/A1 _5479_/A2 _4351_/X VGND VGND VPWR VPWR _6495_/D sky130_fd_sc_hd__a21o_2
XFILLER_5_60 VGND VGND VPWR VPWR sky130_fd_sc_hd__decap_3
X_4334_ _3915_/A _3915_/B _4586_/C _4386_/A VGND VGND VPWR VPWR _4532_/C sky130_fd_sc_hd__o211a_2
XTAP_TAPCELL_ROW_35_1104 VGND VPWR sky130_fd_sc_hd__tapvpwrvgnd_1
XTAP_TAPCELL_ROW_35_1115 VGND VPWR sky130_fd_sc_hd__tapvpwrvgnd_1
X_7053_ clkload7/A _7053_/D wire639/X VGND VGND VPWR VPWR _7053_/Q sky130_fd_sc_hd__dfrtp_2
Xfanout239 _5479_/A2 VGND VGND VPWR VPWR _5464_/A2 sky130_fd_sc_hd__clkdlybuf4s25_1
X_4265_ _4369_/B _4265_/B VGND VGND VPWR VPWR _4265_/Y sky130_fd_sc_hd__nor2_2
XFILLER_80_1130 VGND VGND VPWR VPWR sky130_fd_sc_hd__decap_3
XFILLER_80_1152 VGND VGND VPWR VPWR sky130_fd_sc_hd__decap_3
XFILLER_45_1272 VGND VGND VPWR VPWR sky130_fd_sc_hd__decap_3
X_6004_ hold961/X _7008_/Q _6033_/S VGND VGND VPWR VPWR _6004_/X sky130_fd_sc_hd__mux2_1
X_3216_ _7001_/Q wire419/X _3223_/C1 _3215_/X VGND VGND VPWR VPWR _3217_/C sky130_fd_sc_hd__a211o_2
X_4196_ _6304_/Q _4868_/A2 _3242_/X _4789_/B2 VGND VGND VPWR VPWR _4196_/X sky130_fd_sc_hd__a22o_2
XFILLER_67_473 VGND VGND VPWR VPWR sky130_fd_sc_hd__fill_1
XFILLER_27_315 VGND VGND VPWR VPWR sky130_fd_sc_hd__decap_3
X_3147_ _3212_/A1 _7028_/Q _7036_/Q _3219_/B2 VGND VGND VPWR VPWR _3147_/X sky130_fd_sc_hd__a22o_2
XFILLER_28_849 VGND VGND VPWR VPWR sky130_fd_sc_hd__decap_3
XFILLER_39_186 VGND VGND VPWR VPWR sky130_fd_sc_hd__decap_3
XFILLER_27_337 VGND VGND VPWR VPWR sky130_fd_sc_hd__fill_2
X_3078_ _3078_/A VGND VGND VPWR VPWR _3078_/Y sky130_fd_sc_hd__inv_2
XFILLER_42_307 VGND VGND VPWR VPWR sky130_fd_sc_hd__fill_1
XFILLER_78_1070 VGND VGND VPWR VPWR sky130_fd_sc_hd__decap_3
XFILLER_36_882 VGND VGND VPWR VPWR sky130_fd_sc_hd__fill_1
XFILLER_42_318 VGND VGND VPWR VPWR sky130_fd_sc_hd__fill_1
XFILLER_54_178 VGND VGND VPWR VPWR sky130_fd_sc_hd__decap_3
XTAP_TAPCELL_ROW_69_1992 VGND VPWR sky130_fd_sc_hd__tapvpwrvgnd_1
X_6906_ _7072_/CLK _6906_/D fanout688/X VGND VGND VPWR VPWR _6906_/Q sky130_fd_sc_hd__dfrtp_2
XFILLER_39_1054 VGND VGND VPWR VPWR sky130_fd_sc_hd__decap_3
XFILLER_51_841 VGND VGND VPWR VPWR sky130_fd_sc_hd__fill_1
XFILLER_39_1065 VGND VGND VPWR VPWR sky130_fd_sc_hd__decap_3
XTAP_TAPCELL_ROW_65_1878 VGND VPWR sky130_fd_sc_hd__tapvpwrvgnd_1
XFILLER_23_554 VGND VGND VPWR VPWR sky130_fd_sc_hd__decap_3
X_6837_ _7037_/CLK _6837_/D load_slew694/X VGND VGND VPWR VPWR _6837_/Q sky130_fd_sc_hd__dfrtp_2
XTAP_TAPCELL_ROW_65_1889 VGND VPWR sky130_fd_sc_hd__tapvpwrvgnd_1
XFILLER_24_58 VGND VGND VPWR VPWR sky130_fd_sc_hd__decap_3
XFILLER_11_727 VGND VGND VPWR VPWR sky130_fd_sc_hd__fill_1
XFILLER_50_384 VGND VGND VPWR VPWR sky130_fd_sc_hd__fill_2
XFILLER_10_226 VGND VGND VPWR VPWR sky130_fd_sc_hd__decap_3
X_6768_ _7056_/CLK _6768_/D load_slew700/X VGND VGND VPWR VPWR _6768_/Q sky130_fd_sc_hd__dfrtp_2
XFILLER_17_1363 VGND VGND VPWR VPWR sky130_fd_sc_hd__decap_3
XFILLER_52_1243 VGND VGND VPWR VPWR sky130_fd_sc_hd__decap_3
XTAP_TAPCELL_ROW_21_744 VGND VPWR sky130_fd_sc_hd__tapvpwrvgnd_1
XTAP_TAPCELL_ROW_21_755 VGND VPWR sky130_fd_sc_hd__tapvpwrvgnd_1
XFILLER_13_1227 VGND VGND VPWR VPWR sky130_fd_sc_hd__decap_3
X_5719_ _5912_/A0 _5719_/A1 wire88/X VGND VGND VPWR VPWR _6767_/D sky130_fd_sc_hd__mux2_1
XFILLER_17_1396 VGND VGND VPWR VPWR sky130_fd_sc_hd__decap_3
XFILLER_52_1276 VGND VGND VPWR VPWR sky130_fd_sc_hd__decap_3
X_6699_ _7051_/CLK _6699_/D fanout816/X VGND VGND VPWR VPWR _6699_/Q sky130_fd_sc_hd__dfrtp_2
XFILLER_40_24 VGND VGND VPWR VPWR sky130_fd_sc_hd__decap_3
XFILLER_3_915 VGND VGND VPWR VPWR sky130_fd_sc_hd__decap_3
XFILLER_3_948 VGND VGND VPWR VPWR sky130_fd_sc_hd__decap_3
XFILLER_3_959 VGND VGND VPWR VPWR sky130_fd_sc_hd__decap_3
XFILLER_49_55 VGND VGND VPWR VPWR sky130_fd_sc_hd__fill_1
Xfanout740 fanout848/X VGND VGND VPWR VPWR fanout740/X sky130_fd_sc_hd__clkdlybuf4s25_1
XFILLER_24_1312 VGND VGND VPWR VPWR sky130_fd_sc_hd__decap_3
XFILLER_24_1323 VGND VGND VPWR VPWR sky130_fd_sc_hd__decap_3
XFILLER_63_1372 VGND VGND VPWR VPWR sky130_fd_sc_hd__decap_3
XFILLER_4_1406 VGND VGND VPWR VPWR sky130_fd_sc_hd__decap_3
XFILLER_1_18 VGND VGND VPWR VPWR sky130_fd_sc_hd__decap_3
XFILLER_74_911 VGND VGND VPWR VPWR sky130_fd_sc_hd__decap_3
Xfanout795 fanout803/X VGND VGND VPWR VPWR wire796/A sky130_fd_sc_hd__clkdlybuf4s25_1
XFILLER_24_1356 VGND VGND VPWR VPWR sky130_fd_sc_hd__decap_3
XFILLER_46_602 VGND VGND VPWR VPWR sky130_fd_sc_hd__decap_3
XFILLER_58_462 VGND VGND VPWR VPWR sky130_fd_sc_hd__fill_1
XFILLER_19_827 VGND VGND VPWR VPWR sky130_fd_sc_hd__decap_3
XFILLER_59_996 VGND VGND VPWR VPWR sky130_fd_sc_hd__decap_3
XFILLER_65_21 VGND VGND VPWR VPWR sky130_fd_sc_hd__decap_3
XFILLER_18_315 VGND VGND VPWR VPWR sky130_fd_sc_hd__decap_3
XFILLER_59_1419 VGND VGND VPWR VPWR sky130_fd_sc_hd__decap_3
XFILLER_2_1141 VGND VGND VPWR VPWR sky130_fd_sc_hd__decap_3
XFILLER_2_1152 VGND VGND VPWR VPWR sky130_fd_sc_hd__decap_3
XFILLER_2_1185 VGND VGND VPWR VPWR sky130_fd_sc_hd__decap_3
XFILLER_57_1121 VGND VGND VPWR VPWR sky130_fd_sc_hd__decap_3
XFILLER_14_510 VGND VGND VPWR VPWR sky130_fd_sc_hd__fill_1
XFILLER_41_340 VGND VGND VPWR VPWR sky130_fd_sc_hd__fill_2
XFILLER_53_1007 VGND VGND VPWR VPWR sky130_fd_sc_hd__fill_1
XFILLER_41_351 VGND VGND VPWR VPWR sky130_fd_sc_hd__fill_2
XFILLER_53_1018 VGND VGND VPWR VPWR sky130_fd_sc_hd__decap_3
XFILLER_18_1149 VGND VGND VPWR VPWR sky130_fd_sc_hd__decap_3
XFILLER_42_896 VGND VGND VPWR VPWR sky130_fd_sc_hd__decap_3
XFILLER_41_384 VGND VGND VPWR VPWR sky130_fd_sc_hd__decap_3
XFILLER_70_1332 VGND VGND VPWR VPWR sky130_fd_sc_hd__decap_3
XFILLER_35_1452 VGND VGND VPWR VPWR sky130_fd_sc_hd__decap_3
XFILLER_35_1463 VGND VGND VPWR VPWR sky130_fd_sc_hd__decap_3
XFILLER_70_1365 VGND VGND VPWR VPWR sky130_fd_sc_hd__decap_3
XFILLER_14_80 VGND VGND VPWR VPWR sky130_fd_sc_hd__decap_3
XFILLER_31_1316 VGND VGND VPWR VPWR sky130_fd_sc_hd__decap_3
XFILLER_70_1376 VGND VGND VPWR VPWR sky130_fd_sc_hd__decap_3
XFILLER_6_742 VGND VGND VPWR VPWR sky130_fd_sc_hd__fill_2
XTAP_TAPCELL_ROW_75_2141 VGND VPWR sky130_fd_sc_hd__tapvpwrvgnd_1
XTAP_TAPCELL_ROW_75_2152 VGND VPWR sky130_fd_sc_hd__tapvpwrvgnd_1
XTAP_TAPCELL_ROW_75_2163 VGND VPWR sky130_fd_sc_hd__tapvpwrvgnd_1
XFILLER_68_1250 VGND VGND VPWR VPWR sky130_fd_sc_hd__decap_3
XFILLER_68_1261 VGND VGND VPWR VPWR sky130_fd_sc_hd__decap_3
XFILLER_46_6 VGND VGND VPWR VPWR sky130_fd_sc_hd__fill_1
XTAP_TAPCELL_ROW_71_2038 VGND VPWR sky130_fd_sc_hd__tapvpwrvgnd_1
XFILLER_64_1114 VGND VGND VPWR VPWR sky130_fd_sc_hd__decap_3
XTAP_TAPCELL_ROW_71_2049 VGND VPWR sky130_fd_sc_hd__tapvpwrvgnd_1
XFILLER_29_1245 VGND VGND VPWR VPWR sky130_fd_sc_hd__decap_3
XFILLER_68_1294 VGND VGND VPWR VPWR sky130_fd_sc_hd__decap_3
XFILLER_9_1328 VGND VGND VPWR VPWR sky130_fd_sc_hd__decap_3
XFILLER_2_970 VGND VGND VPWR VPWR sky130_fd_sc_hd__decap_3
XFILLER_64_1147 VGND VGND VPWR VPWR sky130_fd_sc_hd__fill_1
XFILLER_2_981 VGND VGND VPWR VPWR sky130_fd_sc_hd__decap_3
XFILLER_29_1278 VGND VGND VPWR VPWR sky130_fd_sc_hd__decap_3
XFILLER_64_1158 VGND VGND VPWR VPWR sky130_fd_sc_hd__decap_3
XFILLER_29_1289 VGND VGND VPWR VPWR sky130_fd_sc_hd__decap_3
XFILLER_42_1412 VGND VGND VPWR VPWR sky130_fd_sc_hd__decap_3
XFILLER_68_248 VGND VGND VPWR VPWR sky130_fd_sc_hd__decap_3
X_4050_ _3414_/X _4773_/B2 _4774_/A2 _6904_/Q _4104_/C1 VGND VGND VPWR VPWR _4050_/X
+ sky130_fd_sc_hd__a221o_2
XFILLER_65_900 VGND VGND VPWR VPWR sky130_fd_sc_hd__decap_3
XFILLER_42_1456 VGND VGND VPWR VPWR sky130_fd_sc_hd__decap_3
Xinput6 ui_in[4] VGND VGND VPWR VPWR input6/X sky130_fd_sc_hd__clkdlybuf4s25_1
XFILLER_49_473 VGND VGND VPWR VPWR sky130_fd_sc_hd__decap_3
XFILLER_64_421 VGND VGND VPWR VPWR sky130_fd_sc_hd__fill_1
XFILLER_80_914 VGND VGND VPWR VPWR sky130_fd_sc_hd__fill_2
XFILLER_80_925 VGND VGND VPWR VPWR sky130_fd_sc_hd__decap_3
XFILLER_75_1210 VGND VGND VPWR VPWR sky130_fd_sc_hd__decap_3
XFILLER_79_1390 VGND VGND VPWR VPWR sky130_fd_sc_hd__decap_3
XFILLER_36_189 VGND VGND VPWR VPWR sky130_fd_sc_hd__decap_3
X_4952_ _6415_/Q _4952_/B VGND VGND VPWR VPWR _5219_/B sky130_fd_sc_hd__xnor2_2
XFILLER_51_126 VGND VGND VPWR VPWR sky130_fd_sc_hd__decap_3
XFILLER_33_841 VGND VGND VPWR VPWR sky130_fd_sc_hd__fill_1
XFILLER_75_1254 VGND VGND VPWR VPWR sky130_fd_sc_hd__decap_3
XFILLER_36_1205 VGND VGND VPWR VPWR sky130_fd_sc_hd__decap_3
X_3903_ _6333_/Q _3903_/A2 _3901_/X _3902_/X VGND VGND VPWR VPWR _3905_/B sky130_fd_sc_hd__o22a_2
X_4883_ _6927_/Q _4883_/A2 _4883_/B1 _4882_/X VGND VGND VPWR VPWR _4883_/X sky130_fd_sc_hd__a211o_2
XFILLER_75_1287 VGND VGND VPWR VPWR sky130_fd_sc_hd__fill_1
XFILLER_20_502 VGND VGND VPWR VPWR sky130_fd_sc_hd__decap_3
XFILLER_75_1298 VGND VGND VPWR VPWR sky130_fd_sc_hd__decap_3
XFILLER_71_1129 VGND VGND VPWR VPWR sky130_fd_sc_hd__decap_3
XFILLER_36_1249 VGND VGND VPWR VPWR sky130_fd_sc_hd__decap_3
XFILLER_60_671 VGND VGND VPWR VPWR sky130_fd_sc_hd__decap_3
X_3834_ _6331_/Q _4829_/A _3832_/X _3833_/X VGND VGND VPWR VPWR _4303_/B sky130_fd_sc_hd__o22a_2
X_6622_ _7025_/CLK _6622_/D wire764/X VGND VGND VPWR VPWR _6622_/Q sky130_fd_sc_hd__dfrtp_2
XTAP_TAPCELL_ROW_15_582 VGND VPWR sky130_fd_sc_hd__tapvpwrvgnd_1
XTAP_TAPCELL_ROW_15_593 VGND VPWR sky130_fd_sc_hd__tapvpwrvgnd_1
XTAP_TAPCELL_ROW_60_1753 VGND VPWR sky130_fd_sc_hd__tapvpwrvgnd_1
X_6553_ _6958_/CLK _6553_/D fanout759/A VGND VGND VPWR VPWR _6553_/Q sky130_fd_sc_hd__dfrtp_2
XTAP_TAPCELL_ROW_60_1764 VGND VPWR sky130_fd_sc_hd__tapvpwrvgnd_1
Xtt_um_aes128_optimized_854 VGND VGND VPWR VPWR tt_um_aes128_optimized_854/HI uio_out[1]
+ sky130_fd_sc_hd__conb_1
X_3765_ _3927_/A_N _6297_/Q VGND VGND VPWR VPWR _3765_/X sky130_fd_sc_hd__and2b_2
XFILLER_9_580 VGND VGND VPWR VPWR sky130_fd_sc_hd__decap_3
X_5504_ _5512_/B VGND VGND VPWR VPWR _5504_/Y sky130_fd_sc_hd__inv_2
X_6484_ _6958_/CLK _6484_/D fanout752/X VGND VGND VPWR VPWR _6484_/Q sky130_fd_sc_hd__dfrtp_2
X_3696_ _3652_/C _3652_/D _3658_/Y _3687_/B _3695_/Y VGND VGND VPWR VPWR _3882_/A
+ sky130_fd_sc_hd__a221o_2
X_5435_ _5435_/A1 _5470_/A2 _4633_/X VGND VGND VPWR VPWR _6547_/D sky130_fd_sc_hd__a21o_2
XFILLER_12_1282 VGND VGND VPWR VPWR sky130_fd_sc_hd__decap_3
XFILLER_10_27 VGND VGND VPWR VPWR sky130_fd_sc_hd__fill_1
XFILLER_10_49 VGND VGND VPWR VPWR sky130_fd_sc_hd__decap_3
XFILLER_47_1301 VGND VGND VPWR VPWR sky130_fd_sc_hd__decap_3
X_5366_ _5366_/A1 _5456_/A2 _4175_/X VGND VGND VPWR VPWR _6478_/D sky130_fd_sc_hd__a21o_2
XFILLER_47_1334 VGND VGND VPWR VPWR sky130_fd_sc_hd__decap_3
XFILLER_47_1345 VGND VGND VPWR VPWR sky130_fd_sc_hd__decap_3
XFILLER_0_918 VGND VGND VPWR VPWR sky130_fd_sc_hd__decap_3
X_4317_ _4317_/A _4317_/B VGND VGND VPWR VPWR _4872_/B sky130_fd_sc_hd__xnor2_2
XFILLER_47_1378 VGND VGND VPWR VPWR sky130_fd_sc_hd__decap_3
X_5297_ _6441_/Q _5296_/X _5331_/S VGND VGND VPWR VPWR _6441_/D sky130_fd_sc_hd__mux2_1
XFILLER_59_237 VGND VGND VPWR VPWR sky130_fd_sc_hd__fill_1
X_7036_ _7036_/CLK _7036_/D fanout835/X VGND VGND VPWR VPWR _7036_/Q sky130_fd_sc_hd__dfrtp_2
XFILLER_19_36 VGND VGND VPWR VPWR sky130_fd_sc_hd__fill_1
X_4248_ _5609_/A3 _6486_/Q _4257_/S VGND VGND VPWR VPWR _4248_/X sky130_fd_sc_hd__mux2_1
XFILLER_68_793 VGND VGND VPWR VPWR sky130_fd_sc_hd__fill_1
X_4179_ _6479_/Q _5581_/B _4265_/B VGND VGND VPWR VPWR _4179_/X sky130_fd_sc_hd__mux2_1
XFILLER_55_421 VGND VGND VPWR VPWR sky130_fd_sc_hd__decap_3
XTAP_TAPCELL_ROW_2_244 VGND VPWR sky130_fd_sc_hd__tapvpwrvgnd_1
XFILLER_67_281 VGND VGND VPWR VPWR sky130_fd_sc_hd__decap_3
XFILLER_28_657 VGND VGND VPWR VPWR sky130_fd_sc_hd__decap_3
XFILLER_56_966 VGND VGND VPWR VPWR sky130_fd_sc_hd__decap_3
XTAP_TAPCELL_ROW_2_255 VGND VPWR sky130_fd_sc_hd__tapvpwrvgnd_1
XFILLER_27_134 VGND VGND VPWR VPWR sky130_fd_sc_hd__fill_2
XFILLER_71_903 VGND VGND VPWR VPWR sky130_fd_sc_hd__decap_3
XFILLER_76_1018 VGND VGND VPWR VPWR sky130_fd_sc_hd__decap_3
XFILLER_15_318 VGND VGND VPWR VPWR sky130_fd_sc_hd__fill_1
XFILLER_70_435 VGND VGND VPWR VPWR sky130_fd_sc_hd__decap_3
XFILLER_35_57 VGND VGND VPWR VPWR sky130_fd_sc_hd__decap_3
XFILLER_58_1441 VGND VGND VPWR VPWR sky130_fd_sc_hd__decap_3
XFILLER_19_1425 VGND VGND VPWR VPWR sky130_fd_sc_hd__decap_3
XTAP_TAPCELL_ROW_26_869 VGND VPWR sky130_fd_sc_hd__tapvpwrvgnd_1
XFILLER_42_159 VGND VGND VPWR VPWR sky130_fd_sc_hd__fill_1
XFILLER_23_340 VGND VGND VPWR VPWR sky130_fd_sc_hd__decap_3
XFILLER_11_502 VGND VGND VPWR VPWR sky130_fd_sc_hd__fill_2
XFILLER_54_1338 VGND VGND VPWR VPWR sky130_fd_sc_hd__decap_3
XFILLER_11_524 VGND VGND VPWR VPWR sky130_fd_sc_hd__decap_3
XPHY_EDGE_ROW_14_Right_14 VGND VGND VPWR VPWR sky130_fd_sc_hd__decap_3
XFILLER_50_192 VGND VGND VPWR VPWR sky130_fd_sc_hd__decap_3
XFILLER_11_557 VGND VGND VPWR VPWR sky130_fd_sc_hd__decap_3
XFILLER_51_45 VGND VGND VPWR VPWR sky130_fd_sc_hd__decap_3
XFILLER_52_1040 VGND VGND VPWR VPWR sky130_fd_sc_hd__decap_3
XFILLER_52_1073 VGND VGND VPWR VPWR sky130_fd_sc_hd__decap_3
Xwire437 wire437/A VGND VGND VPWR VPWR _5123_/A sky130_fd_sc_hd__clkbuf_4
XFILLER_13_1046 VGND VGND VPWR VPWR sky130_fd_sc_hd__decap_3
XFILLER_13_1068 VGND VGND VPWR VPWR sky130_fd_sc_hd__decap_3
XFILLER_3_712 VGND VGND VPWR VPWR sky130_fd_sc_hd__decap_3
XFILLER_30_1371 VGND VGND VPWR VPWR sky130_fd_sc_hd__fill_1
XFILLER_2_200 VGND VGND VPWR VPWR sky130_fd_sc_hd__decap_3
XFILLER_30_1382 VGND VGND VPWR VPWR sky130_fd_sc_hd__decap_3
XFILLER_65_1401 VGND VGND VPWR VPWR sky130_fd_sc_hd__decap_3
XFILLER_2_233 VGND VGND VPWR VPWR sky130_fd_sc_hd__decap_3
XFILLER_65_1434 VGND VGND VPWR VPWR sky130_fd_sc_hd__decap_3
XFILLER_26_1418 VGND VGND VPWR VPWR sky130_fd_sc_hd__decap_3
XFILLER_2_288 VGND VGND VPWR VPWR sky130_fd_sc_hd__decap_3
XPHY_EDGE_ROW_23_Right_23 VGND VGND VPWR VPWR sky130_fd_sc_hd__decap_3
XFILLER_26_1429 VGND VGND VPWR VPWR sky130_fd_sc_hd__decap_3
XFILLER_8_1350 VGND VGND VPWR VPWR sky130_fd_sc_hd__decap_3
XFILLER_76_53 VGND VGND VPWR VPWR sky130_fd_sc_hd__decap_3
XFILLER_4_1203 VGND VGND VPWR VPWR sky130_fd_sc_hd__fill_1
Xfanout570 _7070_/Q VGND VGND VPWR VPWR _5801_/A_N sky130_fd_sc_hd__clkdlybuf4s25_1
XFILLER_63_1180 VGND VGND VPWR VPWR sky130_fd_sc_hd__fill_1
XFILLER_65_207 VGND VGND VPWR VPWR sky130_fd_sc_hd__decap_3
XFILLER_4_1214 VGND VGND VPWR VPWR sky130_fd_sc_hd__decap_3
XFILLER_24_1142 VGND VGND VPWR VPWR sky130_fd_sc_hd__decap_3
Xfanout581 _4532_/B VGND VGND VPWR VPWR _4608_/B sky130_fd_sc_hd__clkdlybuf4s25_1
Xfanout592 _6604_/Q VGND VGND VPWR VPWR _5505_/A sky130_fd_sc_hd__clkdlybuf4s25_1
XFILLER_59_782 VGND VGND VPWR VPWR sky130_fd_sc_hd__fill_2
XFILLER_8_1394 VGND VGND VPWR VPWR sky130_fd_sc_hd__decap_3
XFILLER_20_1006 VGND VGND VPWR VPWR sky130_fd_sc_hd__decap_3
XFILLER_47_944 VGND VGND VPWR VPWR sky130_fd_sc_hd__decap_3
XFILLER_4_1247 VGND VGND VPWR VPWR sky130_fd_sc_hd__decap_3
XFILLER_19_646 VGND VGND VPWR VPWR sky130_fd_sc_hd__decap_3
XFILLER_46_432 VGND VGND VPWR VPWR sky130_fd_sc_hd__decap_3
XFILLER_74_763 VGND VGND VPWR VPWR sky130_fd_sc_hd__fill_2
XFILLER_61_402 VGND VGND VPWR VPWR sky130_fd_sc_hd__fill_1
XFILLER_15_841 VGND VGND VPWR VPWR sky130_fd_sc_hd__decap_3
XFILLER_33_148 VGND VGND VPWR VPWR sky130_fd_sc_hd__decap_3
XFILLER_61_457 VGND VGND VPWR VPWR sky130_fd_sc_hd__decap_3
XPHY_EDGE_ROW_32_Right_32 VGND VGND VPWR VPWR sky130_fd_sc_hd__decap_3
XFILLER_72_1427 VGND VGND VPWR VPWR sky130_fd_sc_hd__fill_1
XFILLER_42_660 VGND VGND VPWR VPWR sky130_fd_sc_hd__fill_2
XFILLER_72_1438 VGND VGND VPWR VPWR sky130_fd_sc_hd__decap_3
XFILLER_41_181 VGND VGND VPWR VPWR sky130_fd_sc_hd__decap_3
XFILLER_35_1260 VGND VGND VPWR VPWR sky130_fd_sc_hd__decap_3
XTAP_TAPCELL_ROW_77_2203 VGND VPWR sky130_fd_sc_hd__tapvpwrvgnd_1
XTAP_TAPCELL_ROW_77_2214 VGND VPWR sky130_fd_sc_hd__tapvpwrvgnd_1
XFILLER_70_1173 VGND VGND VPWR VPWR sky130_fd_sc_hd__decap_3
XFILLER_31_1146 VGND VGND VPWR VPWR sky130_fd_sc_hd__fill_1
X_3550_ _3601_/A _3550_/B _6619_/Q VGND VGND VPWR VPWR _3550_/X sky130_fd_sc_hd__and3_2
X_3481_ hold995/X _3480_/X _3481_/S VGND VGND VPWR VPWR _6214_/D sky130_fd_sc_hd__mux2_1
X_5220_ _6753_/Q _5356_/S wire127/A _5219_/Y VGND VGND VPWR VPWR _5220_/X sky130_fd_sc_hd__o211a_2
XPHY_EDGE_ROW_41_Right_41 VGND VGND VPWR VPWR sky130_fd_sc_hd__decap_3
XFILLER_44_3 VGND VGND VPWR VPWR sky130_fd_sc_hd__decap_3
XFILLER_68_1091 VGND VGND VPWR VPWR sky130_fd_sc_hd__fill_1
XFILLER_9_1114 VGND VGND VPWR VPWR sky130_fd_sc_hd__decap_3
X_5151_ _6384_/Q _5151_/A2 _4964_/S _5150_/X VGND VGND VPWR VPWR _6384_/D sky130_fd_sc_hd__a22o_2
XFILLER_9_1136 VGND VGND VPWR VPWR sky130_fd_sc_hd__decap_3
X_4102_ _6599_/Q _4777_/A _4779_/A1 VGND VGND VPWR VPWR _4102_/X sky130_fd_sc_hd__a21bo_2
XFILLER_9_1169 VGND VGND VPWR VPWR sky130_fd_sc_hd__decap_3
X_5082_ _5276_/A _5083_/B _5278_/A2 VGND VGND VPWR VPWR _5082_/X sky130_fd_sc_hd__a21o_2
XFILLER_69_579 VGND VGND VPWR VPWR sky130_fd_sc_hd__fill_2
XFILLER_2_50 VGND VGND VPWR VPWR sky130_fd_sc_hd__decap_3
XTAP_TAPCELL_ROW_53_1590 VGND VPWR sky130_fd_sc_hd__tapvpwrvgnd_1
X_4033_ _6235_/Q _4081_/A2 _4031_/X _4032_/X VGND VGND VPWR VPWR _6235_/D sky130_fd_sc_hd__o22a_2
XFILLER_42_1264 VGND VGND VPWR VPWR sky130_fd_sc_hd__decap_3
XFILLER_2_83 VGND VGND VPWR VPWR sky130_fd_sc_hd__fill_1
XFILLER_38_944 VGND VGND VPWR VPWR sky130_fd_sc_hd__decap_3
XFILLER_49_281 VGND VGND VPWR VPWR sky130_fd_sc_hd__decap_3
XFILLER_2_94 VGND VGND VPWR VPWR sky130_fd_sc_hd__decap_3
XFILLER_42_1297 VGND VGND VPWR VPWR sky130_fd_sc_hd__decap_3
XFILLER_77_1316 VGND VGND VPWR VPWR sky130_fd_sc_hd__decap_3
XFILLER_53_914 VGND VGND VPWR VPWR sky130_fd_sc_hd__decap_3
XFILLER_80_722 VGND VGND VPWR VPWR sky130_fd_sc_hd__decap_3
XFILLER_37_498 VGND VGND VPWR VPWR sky130_fd_sc_hd__decap_3
XFILLER_52_424 VGND VGND VPWR VPWR sky130_fd_sc_hd__decap_3
XFILLER_64_284 VGND VGND VPWR VPWR sky130_fd_sc_hd__decap_3
XFILLER_80_744 VGND VGND VPWR VPWR sky130_fd_sc_hd__decap_3
XFILLER_25_649 VGND VGND VPWR VPWR sky130_fd_sc_hd__decap_3
XPHY_EDGE_ROW_50_Right_50 VGND VGND VPWR VPWR sky130_fd_sc_hd__decap_3
X_5984_ _5984_/A0 _5984_/A1 _6048_/S VGND VGND VPWR VPWR _6988_/D sky130_fd_sc_hd__mux2_1
XFILLER_24_137 VGND VGND VPWR VPWR sky130_fd_sc_hd__decap_3
XFILLER_80_766 VGND VGND VPWR VPWR sky130_fd_sc_hd__decap_3
XFILLER_24_148 VGND VGND VPWR VPWR sky130_fd_sc_hd__decap_3
XTAP_TAPCELL_ROW_62_1804 VGND VPWR sky130_fd_sc_hd__tapvpwrvgnd_1
XTAP_TAPCELL_ROW_23_806 VGND VPWR sky130_fd_sc_hd__tapvpwrvgnd_1
XTAP_TAPCELL_ROW_62_1815 VGND VPWR sky130_fd_sc_hd__tapvpwrvgnd_1
XFILLER_36_1013 VGND VGND VPWR VPWR sky130_fd_sc_hd__decap_3
X_4935_ _6686_/Q _3052_/Y _5210_/A VGND VGND VPWR VPWR _4935_/X sky130_fd_sc_hd__mux2_1
XFILLER_75_1084 VGND VGND VPWR VPWR sky130_fd_sc_hd__decap_3
XFILLER_33_682 VGND VGND VPWR VPWR sky130_fd_sc_hd__decap_3
XFILLER_36_1035 VGND VGND VPWR VPWR sky130_fd_sc_hd__fill_1
XFILLER_21_844 VGND VGND VPWR VPWR sky130_fd_sc_hd__decap_3
XANTENNA_11 _3202_/A VGND VGND VPWR VPWR sky130_fd_sc_hd__diode_2
X_4866_ _6587_/Q _4894_/A _4888_/C1 VGND VGND VPWR VPWR _4866_/X sky130_fd_sc_hd__a21bo_2
XANTENNA_22 _5813_/S VGND VGND VPWR VPWR sky130_fd_sc_hd__diode_2
XFILLER_14_1300 VGND VGND VPWR VPWR sky130_fd_sc_hd__decap_3
XANTENNA_33 input3/X VGND VGND VPWR VPWR sky130_fd_sc_hd__diode_2
XANTENNA_44 _5748_/S VGND VGND VPWR VPWR sky130_fd_sc_hd__diode_2
XFILLER_53_1360 VGND VGND VPWR VPWR sky130_fd_sc_hd__decap_3
X_6605_ _7041_/CLK _6605_/D fanout725/X VGND VGND VPWR VPWR _6605_/Q sky130_fd_sc_hd__dfrtp_2
XFILLER_20_365 VGND VGND VPWR VPWR sky130_fd_sc_hd__decap_3
XANTENNA_55 _5627_/S VGND VGND VPWR VPWR sky130_fd_sc_hd__diode_2
X_3817_ _3278_/X _4743_/B2 _4744_/A2 _6836_/Q _4092_/C1 VGND VGND VPWR VPWR _3817_/X
+ sky130_fd_sc_hd__a221o_2
X_4797_ _6281_/Q _4854_/A2 _3436_/X _4854_/B2 VGND VGND VPWR VPWR _4797_/X sky130_fd_sc_hd__a22o_2
XANTENNA_66 _5502_/D VGND VGND VPWR VPWR sky130_fd_sc_hd__diode_2
XFILLER_14_1344 VGND VGND VPWR VPWR sky130_fd_sc_hd__decap_3
XFILLER_53_1393 VGND VGND VPWR VPWR sky130_fd_sc_hd__decap_3
XANTENNA_77 _5581_/A VGND VGND VPWR VPWR sky130_fd_sc_hd__diode_2
XFILLER_21_15 VGND VGND VPWR VPWR sky130_fd_sc_hd__decap_3
XANTENNA_88 _6059_/S VGND VGND VPWR VPWR sky130_fd_sc_hd__diode_2
X_3748_ _3748_/A _3748_/B VGND VGND VPWR VPWR _3822_/B sky130_fd_sc_hd__nand2_2
X_6536_ _7040_/CLK _6536_/D load_slew718/X VGND VGND VPWR VPWR _6536_/Q sky130_fd_sc_hd__dfrtp_2
XFILLER_10_1208 VGND VGND VPWR VPWR sky130_fd_sc_hd__decap_3
XFILLER_14_1388 VGND VGND VPWR VPWR sky130_fd_sc_hd__decap_3
XFILLER_49_1407 VGND VGND VPWR VPWR sky130_fd_sc_hd__decap_3
X_6467_ _7095_/CLK _6467_/D load_slew696/X VGND VGND VPWR VPWR _6467_/Q sky130_fd_sc_hd__dfrtp_2
X_3679_ _3648_/X _3748_/B _3748_/A VGND VGND VPWR VPWR _3679_/X sky130_fd_sc_hd__a21o_2
X_5418_ _5418_/A1 _5453_/A2 _3975_/X VGND VGND VPWR VPWR _6530_/D sky130_fd_sc_hd__a21o_2
X_6398_ _7056_/CLK _6398_/D load_slew700/X VGND VGND VPWR VPWR _6398_/Q sky130_fd_sc_hd__dfrtp_2
XFILLER_0_704 VGND VGND VPWR VPWR sky130_fd_sc_hd__decap_3
X_5349_ _6467_/Q _5348_/X _5355_/S VGND VGND VPWR VPWR _6467_/D sky130_fd_sc_hd__mux2_1
XFILLER_47_1175 VGND VGND VPWR VPWR sky130_fd_sc_hd__fill_1
XFILLER_75_505 VGND VGND VPWR VPWR sky130_fd_sc_hd__decap_3
XFILLER_25_1440 VGND VGND VPWR VPWR sky130_fd_sc_hd__decap_3
XFILLER_29_900 VGND VGND VPWR VPWR sky130_fd_sc_hd__decap_3
XFILLER_60_1320 VGND VGND VPWR VPWR sky130_fd_sc_hd__decap_3
XFILLER_21_1304 VGND VGND VPWR VPWR sky130_fd_sc_hd__decap_3
X_7019_ _7019_/CLK _7019_/D load_slew837/X VGND VGND VPWR VPWR _7019_/Q sky130_fd_sc_hd__dfrtp_2
XFILLER_60_1353 VGND VGND VPWR VPWR sky130_fd_sc_hd__decap_3
XFILLER_21_1337 VGND VGND VPWR VPWR sky130_fd_sc_hd__decap_3
XFILLER_28_443 VGND VGND VPWR VPWR sky130_fd_sc_hd__fill_1
XFILLER_21_1348 VGND VGND VPWR VPWR sky130_fd_sc_hd__decap_3
XFILLER_60_1397 VGND VGND VPWR VPWR sky130_fd_sc_hd__decap_3
XFILLER_56_774 VGND VGND VPWR VPWR sky130_fd_sc_hd__decap_3
XFILLER_44_925 VGND VGND VPWR VPWR sky130_fd_sc_hd__fill_2
XFILLER_71_711 VGND VGND VPWR VPWR sky130_fd_sc_hd__decap_3
XFILLER_55_273 VGND VGND VPWR VPWR sky130_fd_sc_hd__decap_3
Xmax_cap79 _3489_/Y VGND VGND VPWR VPWR fanout78/A sky130_fd_sc_hd__clkbuf_2
XFILLER_43_457 VGND VGND VPWR VPWR sky130_fd_sc_hd__decap_3
XFILLER_12_800 VGND VGND VPWR VPWR sky130_fd_sc_hd__decap_3
XFILLER_19_1233 VGND VGND VPWR VPWR sky130_fd_sc_hd__decap_3
XFILLER_58_1282 VGND VGND VPWR VPWR sky130_fd_sc_hd__decap_3
XFILLER_12_833 VGND VGND VPWR VPWR sky130_fd_sc_hd__decap_3
XFILLER_19_1266 VGND VGND VPWR VPWR sky130_fd_sc_hd__decap_3
XFILLER_54_1157 VGND VGND VPWR VPWR sky130_fd_sc_hd__decap_3
Xclkbuf_leaf_50_clk clkbuf_leaf_54_clk/A VGND VGND VPWR VPWR _7004_/CLK sky130_fd_sc_hd__clkbuf_8
XFILLER_11_332 VGND VGND VPWR VPWR sky130_fd_sc_hd__decap_3
XFILLER_32_1400 VGND VGND VPWR VPWR sky130_fd_sc_hd__decap_3
XFILLER_71_1460 VGND VGND VPWR VPWR sky130_fd_sc_hd__decap_3
XFILLER_8_848 VGND VGND VPWR VPWR sky130_fd_sc_hd__decap_3
XFILLER_32_1444 VGND VGND VPWR VPWR sky130_fd_sc_hd__decap_3
XFILLER_3_520 VGND VGND VPWR VPWR sky130_fd_sc_hd__decap_3
XFILLER_11_70 VGND VGND VPWR VPWR sky130_fd_sc_hd__decap_3
XFILLER_3_553 VGND VGND VPWR VPWR sky130_fd_sc_hd__decap_3
XFILLER_3_564 VGND VGND VPWR VPWR sky130_fd_sc_hd__decap_3
XFILLER_65_1231 VGND VGND VPWR VPWR sky130_fd_sc_hd__fill_1
Xload_slew206 _6017_/S VGND VGND VPWR VPWR _6049_/S sky130_fd_sc_hd__buf_4
XFILLER_65_1242 VGND VGND VPWR VPWR sky130_fd_sc_hd__decap_3
Xload_slew217 fanout216/X VGND VGND VPWR VPWR _6061_/S sky130_fd_sc_hd__buf_4
XFILLER_3_586 VGND VGND VPWR VPWR sky130_fd_sc_hd__fill_1
XFILLER_79_844 VGND VGND VPWR VPWR sky130_fd_sc_hd__fill_1
XFILLER_30_9 VGND VGND VPWR VPWR sky130_fd_sc_hd__decap_3
Xload_slew228 _5955_/S VGND VGND VPWR VPWR _6051_/S sky130_fd_sc_hd__buf_2
XFILLER_26_1226 VGND VGND VPWR VPWR sky130_fd_sc_hd__decap_3
XFILLER_65_1275 VGND VGND VPWR VPWR sky130_fd_sc_hd__decap_3
XFILLER_79_866 VGND VGND VPWR VPWR sky130_fd_sc_hd__decap_3
XFILLER_6_1309 VGND VGND VPWR VPWR sky130_fd_sc_hd__decap_3
XFILLER_26_1259 VGND VGND VPWR VPWR sky130_fd_sc_hd__fill_1
XFILLER_66_527 VGND VGND VPWR VPWR sky130_fd_sc_hd__fill_1
XFILLER_4_1011 VGND VGND VPWR VPWR sky130_fd_sc_hd__fill_2
XFILLER_8_1191 VGND VGND VPWR VPWR sky130_fd_sc_hd__decap_3
XFILLER_4_1022 VGND VGND VPWR VPWR sky130_fd_sc_hd__fill_1
XFILLER_4_1088 VGND VGND VPWR VPWR sky130_fd_sc_hd__decap_3
XFILLER_19_476 VGND VGND VPWR VPWR sky130_fd_sc_hd__fill_2
XFILLER_34_413 VGND VGND VPWR VPWR sky130_fd_sc_hd__decap_3
XFILLER_4_1099 VGND VGND VPWR VPWR sky130_fd_sc_hd__decap_3
XFILLER_19_498 VGND VGND VPWR VPWR sky130_fd_sc_hd__decap_3
XFILLER_62_733 VGND VGND VPWR VPWR sky130_fd_sc_hd__decap_3
XTAP_TAPCELL_ROW_17_633 VGND VPWR sky130_fd_sc_hd__tapvpwrvgnd_1
XTAP_TAPCELL_ROW_17_644 VGND VPWR sky130_fd_sc_hd__tapvpwrvgnd_1
XFILLER_34_457 VGND VGND VPWR VPWR sky130_fd_sc_hd__decap_3
XTAP_TAPCELL_ROW_17_655 VGND VPWR sky130_fd_sc_hd__tapvpwrvgnd_1
XFILLER_22_608 VGND VGND VPWR VPWR sky130_fd_sc_hd__decap_3
XFILLER_50_917 VGND VGND VPWR VPWR sky130_fd_sc_hd__decap_3
XFILLER_76_1371 VGND VGND VPWR VPWR sky130_fd_sc_hd__fill_1
XFILLER_37_1322 VGND VGND VPWR VPWR sky130_fd_sc_hd__decap_3
XFILLER_76_1382 VGND VGND VPWR VPWR sky130_fd_sc_hd__decap_3
XFILLER_43_980 VGND VGND VPWR VPWR sky130_fd_sc_hd__fill_2
XFILLER_61_276 VGND VGND VPWR VPWR sky130_fd_sc_hd__decap_3
XFILLER_72_1235 VGND VGND VPWR VPWR sky130_fd_sc_hd__decap_3
X_4720_ _6295_/Q wire503/X _3400_/X wire383/X VGND VGND VPWR VPWR _4720_/X sky130_fd_sc_hd__a22o_2
XFILLER_37_1366 VGND VGND VPWR VPWR sky130_fd_sc_hd__decap_3
Xclkbuf_leaf_41_clk clkload6/A VGND VGND VPWR VPWR _7060_/CLK sky130_fd_sc_hd__clkbuf_8
XFILLER_72_1279 VGND VGND VPWR VPWR sky130_fd_sc_hd__decap_3
XFILLER_37_1399 VGND VGND VPWR VPWR sky130_fd_sc_hd__fill_1
X_4651_ _5609_/A3 _6550_/Q _4658_/S VGND VGND VPWR VPWR _4651_/X sky130_fd_sc_hd__mux2_1
XFILLER_35_1090 VGND VGND VPWR VPWR sky130_fd_sc_hd__decap_3
X_3602_ _6631_/Q _4312_/A _5607_/A2 _6639_/Q _5574_/A2 VGND VGND VPWR VPWR _3602_/X
+ sky130_fd_sc_hd__a221o_2
XTAP_TAPCELL_ROW_42_1280 VGND VPWR sky130_fd_sc_hd__tapvpwrvgnd_1
XTAP_TAPCELL_ROW_42_1291 VGND VPWR sky130_fd_sc_hd__tapvpwrvgnd_1
X_4582_ _4582_/A _4582_/B _4582_/C VGND VGND VPWR VPWR _4582_/X sky130_fd_sc_hd__and3_2
XFILLER_7_870 VGND VGND VPWR VPWR sky130_fd_sc_hd__fill_2
X_3533_ _6230_/Q _5591_/A2 _3533_/B1 _6278_/Q _4783_/B VGND VGND VPWR VPWR _3533_/X
+ sky130_fd_sc_hd__a221o_2
X_6321_ _7039_/CLK _6321_/D fanout821/X VGND VGND VPWR VPWR _6321_/Q sky130_fd_sc_hd__dfrtp_2
X_6252_ _6819_/CLK _6252_/D load_slew767/X VGND VGND VPWR VPWR _6252_/Q sky130_fd_sc_hd__dfrtp_2
X_3464_ _6343_/Q _6463_/Q VGND VGND VPWR VPWR _3464_/X sky130_fd_sc_hd__xor2_2
XTAP_TAPCELL_ROW_55_1630 VGND VPWR sky130_fd_sc_hd__tapvpwrvgnd_1
XTAP_TAPCELL_ROW_55_1641 VGND VPWR sky130_fd_sc_hd__tapvpwrvgnd_1
X_5203_ _6409_/Q _5215_/A2 _5202_/X VGND VGND VPWR VPWR _6409_/D sky130_fd_sc_hd__a21o_2
XFILLER_48_1462 VGND VGND VPWR VPWR sky130_fd_sc_hd__decap_3
X_6183_ _7072_/CLK _6183_/D load_slew684/X VGND VGND VPWR VPWR _6183_/Q sky130_fd_sc_hd__dfrtp_2
X_3395_ hold957/X _3394_/X _3459_/S VGND VGND VPWR VPWR _6171_/D sky130_fd_sc_hd__mux2_1
XFILLER_44_1315 VGND VGND VPWR VPWR sky130_fd_sc_hd__fill_1
XFILLER_44_1326 VGND VGND VPWR VPWR sky130_fd_sc_hd__decap_3
XTAP_TAPCELL_ROW_51_1516 VGND VPWR sky130_fd_sc_hd__tapvpwrvgnd_1
XTAP_TAPCELL_ROW_4_306 VGND VPWR sky130_fd_sc_hd__tapvpwrvgnd_1
X_5134_ _6714_/Q _5216_/A VGND VGND VPWR VPWR _5134_/X sky130_fd_sc_hd__or2_2
XTAP_TAPCELL_ROW_51_1527 VGND VPWR sky130_fd_sc_hd__tapvpwrvgnd_1
XTAP_TAPCELL_ROW_4_317 VGND VPWR sky130_fd_sc_hd__tapvpwrvgnd_1
Xload_slew751 fanout750/X VGND VGND VPWR VPWR load_slew751/X sky130_fd_sc_hd__clkbuf_2
XTAP_TAPCELL_ROW_51_1538 VGND VPWR sky130_fd_sc_hd__tapvpwrvgnd_1
Xload_slew762 fanout761/X VGND VGND VPWR VPWR fanout759/A sky130_fd_sc_hd__clkbuf_2
XFILLER_44_1359 VGND VGND VPWR VPWR sky130_fd_sc_hd__decap_3
XFILLER_57_505 VGND VGND VPWR VPWR sky130_fd_sc_hd__fill_1
Xhold1504 _6560_/Q VGND VGND VPWR VPWR _5448_/A1 sky130_fd_sc_hd__dlygate4sd3_1
Xhold1515 _6590_/Q VGND VGND VPWR VPWR _5478_/A1 sky130_fd_sc_hd__dlygate4sd3_1
Xload_slew773 fanout772/X VGND VGND VPWR VPWR load_slew773/X sky130_fd_sc_hd__buf_2
Xload_slew784 fanout783/X VGND VGND VPWR VPWR load_slew784/X sky130_fd_sc_hd__clkbuf_4
Xhold1526 _6577_/Q VGND VGND VPWR VPWR _5465_/A1 sky130_fd_sc_hd__dlygate4sd3_1
X_5065_ _6399_/Q _5267_/B VGND VGND VPWR VPWR _5065_/X sky130_fd_sc_hd__or2_2
Xhold1537 _6632_/Q VGND VGND VPWR VPWR _5549_/B1 sky130_fd_sc_hd__dlygate4sd3_1
Xhold1548 _6671_/Q VGND VGND VPWR VPWR _5599_/B2 sky130_fd_sc_hd__dlygate4sd3_1
Xhold1559 _6675_/Q VGND VGND VPWR VPWR _5604_/B2 sky130_fd_sc_hd__dlygate4sd3_1
X_4016_ _4040_/A1 _4694_/B _4277_/B _4008_/Y _6561_/Q VGND VGND VPWR VPWR _4016_/X
+ sky130_fd_sc_hd__a32o_2
XFILLER_72_519 VGND VGND VPWR VPWR sky130_fd_sc_hd__decap_3
XFILLER_37_240 VGND VGND VPWR VPWR sky130_fd_sc_hd__fill_2
XFILLER_77_1113 VGND VGND VPWR VPWR sky130_fd_sc_hd__decap_3
XFILLER_25_402 VGND VGND VPWR VPWR sky130_fd_sc_hd__decap_3
XFILLER_26_925 VGND VGND VPWR VPWR sky130_fd_sc_hd__decap_3
XFILLER_37_262 VGND VGND VPWR VPWR sky130_fd_sc_hd__decap_3
XFILLER_38_785 VGND VGND VPWR VPWR sky130_fd_sc_hd__fill_1
XFILLER_77_1124 VGND VGND VPWR VPWR sky130_fd_sc_hd__decap_3
XFILLER_37_284 VGND VGND VPWR VPWR sky130_fd_sc_hd__decap_3
XFILLER_52_221 VGND VGND VPWR VPWR sky130_fd_sc_hd__decap_3
XFILLER_53_744 VGND VGND VPWR VPWR sky130_fd_sc_hd__decap_3
XFILLER_77_1157 VGND VGND VPWR VPWR sky130_fd_sc_hd__decap_3
XTAP_TAPCELL_ROW_49_1467 VGND VPWR sky130_fd_sc_hd__tapvpwrvgnd_1
XFILLER_0_1453 VGND VGND VPWR VPWR sky130_fd_sc_hd__decap_3
XFILLER_16_59 VGND VGND VPWR VPWR sky130_fd_sc_hd__decap_3
XTAP_TAPCELL_ROW_49_1478 VGND VPWR sky130_fd_sc_hd__tapvpwrvgnd_1
XFILLER_52_265 VGND VGND VPWR VPWR sky130_fd_sc_hd__decap_3
XFILLER_55_1422 VGND VGND VPWR VPWR sky130_fd_sc_hd__decap_3
X_5967_ hold924/X _6971_/Q _6015_/S VGND VGND VPWR VPWR _5967_/X sky130_fd_sc_hd__mux2_1
XFILLER_16_1406 VGND VGND VPWR VPWR sky130_fd_sc_hd__decap_3
XFILLER_55_1455 VGND VGND VPWR VPWR sky130_fd_sc_hd__fill_1
X_4918_ _6378_/Q _5204_/B VGND VGND VPWR VPWR _4918_/X sky130_fd_sc_hd__or2_2
XFILLER_55_1466 VGND VGND VPWR VPWR sky130_fd_sc_hd__decap_3
Xclkbuf_leaf_32_clk clkbuf_4_6__f_clk/X VGND VGND VPWR VPWR _7041_/CLK sky130_fd_sc_hd__clkbuf_8
X_5898_ input2/X _5898_/A1 _5905_/S VGND VGND VPWR VPWR _6906_/D sky130_fd_sc_hd__mux2_1
XFILLER_51_1319 VGND VGND VPWR VPWR sky130_fd_sc_hd__decap_3
XFILLER_21_685 VGND VGND VPWR VPWR sky130_fd_sc_hd__fill_1
X_4849_ _6336_/Q _4848_/X _4849_/S VGND VGND VPWR VPWR _6336_/D sky130_fd_sc_hd__mux2_1
XFILLER_14_1130 VGND VGND VPWR VPWR sky130_fd_sc_hd__decap_3
XFILLER_20_162 VGND VGND VPWR VPWR sky130_fd_sc_hd__decap_3
X_6519_ _6993_/CLK _6519_/D load_slew710/X VGND VGND VPWR VPWR _6519_/Q sky130_fd_sc_hd__dfrtp_2
XFILLER_49_1204 VGND VGND VPWR VPWR sky130_fd_sc_hd__decap_3
XFILLER_4_339 VGND VGND VPWR VPWR sky130_fd_sc_hd__decap_3
XFILLER_49_1248 VGND VGND VPWR VPWR sky130_fd_sc_hd__decap_3
XFILLER_0_501 VGND VGND VPWR VPWR sky130_fd_sc_hd__decap_3
XFILLER_0_523 VGND VGND VPWR VPWR sky130_fd_sc_hd__decap_3
XFILLER_62_1415 VGND VGND VPWR VPWR sky130_fd_sc_hd__decap_3
XFILLER_0_545 VGND VGND VPWR VPWR sky130_fd_sc_hd__decap_3
XFILLER_0_567 VGND VGND VPWR VPWR sky130_fd_sc_hd__decap_3
XFILLER_48_505 VGND VGND VPWR VPWR sky130_fd_sc_hd__fill_1
XFILLER_62_1459 VGND VGND VPWR VPWR sky130_fd_sc_hd__decap_3
XFILLER_76_836 VGND VGND VPWR VPWR sky130_fd_sc_hd__decap_3
XFILLER_0_589 VGND VGND VPWR VPWR sky130_fd_sc_hd__decap_3
XFILLER_48_527 VGND VGND VPWR VPWR sky130_fd_sc_hd__decap_3
XFILLER_5_1331 VGND VGND VPWR VPWR sky130_fd_sc_hd__decap_3
XFILLER_76_869 VGND VGND VPWR VPWR sky130_fd_sc_hd__decap_3
XFILLER_25_1281 VGND VGND VPWR VPWR sky130_fd_sc_hd__decap_3
XFILLER_25_1292 VGND VGND VPWR VPWR sky130_fd_sc_hd__decap_3
XFILLER_17_903 VGND VGND VPWR VPWR sky130_fd_sc_hd__fill_2
XFILLER_28_240 VGND VGND VPWR VPWR sky130_fd_sc_hd__decap_3
XFILLER_63_508 VGND VGND VPWR VPWR sky130_fd_sc_hd__decap_3
XFILLER_5_1375 VGND VGND VPWR VPWR sky130_fd_sc_hd__decap_3
XFILLER_29_785 VGND VGND VPWR VPWR sky130_fd_sc_hd__decap_3
XFILLER_1_1228 VGND VGND VPWR VPWR sky130_fd_sc_hd__decap_3
XFILLER_16_402 VGND VGND VPWR VPWR sky130_fd_sc_hd__decap_3
XFILLER_1_1239 VGND VGND VPWR VPWR sky130_fd_sc_hd__decap_3
XFILLER_73_21 VGND VGND VPWR VPWR sky130_fd_sc_hd__decap_3
XFILLER_17_947 VGND VGND VPWR VPWR sky130_fd_sc_hd__decap_3
XFILLER_44_733 VGND VGND VPWR VPWR sky130_fd_sc_hd__decap_3
XFILLER_43_221 VGND VGND VPWR VPWR sky130_fd_sc_hd__decap_3
XFILLER_73_54 VGND VGND VPWR VPWR sky130_fd_sc_hd__fill_2
XFILLER_31_405 VGND VGND VPWR VPWR sky130_fd_sc_hd__decap_3
XFILLER_32_928 VGND VGND VPWR VPWR sky130_fd_sc_hd__decap_3
XFILLER_44_788 VGND VGND VPWR VPWR sky130_fd_sc_hd__decap_3
XFILLER_43_287 VGND VGND VPWR VPWR sky130_fd_sc_hd__decap_3
Xclkbuf_leaf_23_clk clkload2/A VGND VGND VPWR VPWR _7095_/CLK sky130_fd_sc_hd__clkbuf_8
XFILLER_19_1063 VGND VGND VPWR VPWR sky130_fd_sc_hd__fill_1
XFILLER_24_490 VGND VGND VPWR VPWR sky130_fd_sc_hd__decap_3
XFILLER_40_961 VGND VGND VPWR VPWR sky130_fd_sc_hd__decap_3
XFILLER_12_663 VGND VGND VPWR VPWR sky130_fd_sc_hd__decap_3
XFILLER_78_9 VGND VGND VPWR VPWR sky130_fd_sc_hd__decap_3
XFILLER_8_645 VGND VGND VPWR VPWR sky130_fd_sc_hd__decap_3
XFILLER_32_1241 VGND VGND VPWR VPWR sky130_fd_sc_hd__decap_3
XFILLER_11_184 VGND VGND VPWR VPWR sky130_fd_sc_hd__decap_3
XFILLER_8_667 VGND VGND VPWR VPWR sky130_fd_sc_hd__decap_3
XFILLER_32_1285 VGND VGND VPWR VPWR sky130_fd_sc_hd__decap_3
XFILLER_67_1304 VGND VGND VPWR VPWR sky130_fd_sc_hd__decap_3
XFILLER_7_199 VGND VGND VPWR VPWR sky130_fd_sc_hd__decap_3
XFILLER_4_840 VGND VGND VPWR VPWR sky130_fd_sc_hd__decap_3
XFILLER_67_1337 VGND VGND VPWR VPWR sky130_fd_sc_hd__decap_3
XFILLER_67_1348 VGND VGND VPWR VPWR sky130_fd_sc_hd__decap_3
XFILLER_3_361 VGND VGND VPWR VPWR sky130_fd_sc_hd__decap_3
XFILLER_65_1083 VGND VGND VPWR VPWR sky130_fd_sc_hd__decap_3
XFILLER_26_1045 VGND VGND VPWR VPWR sky130_fd_sc_hd__decap_3
X_3180_ _3180_/A1 _3178_/X _3179_/X _3220_/C1 VGND VGND VPWR VPWR _3180_/X sky130_fd_sc_hd__a211o_2
XFILLER_6_1117 VGND VGND VPWR VPWR sky130_fd_sc_hd__decap_3
XFILLER_66_302 VGND VGND VPWR VPWR sky130_fd_sc_hd__decap_3
XFILLER_67_847 VGND VGND VPWR VPWR sky130_fd_sc_hd__decap_3
XFILLER_43_1381 VGND VGND VPWR VPWR sky130_fd_sc_hd__decap_3
XFILLER_66_357 VGND VGND VPWR VPWR sky130_fd_sc_hd__fill_2
XFILLER_78_1400 VGND VGND VPWR VPWR sky130_fd_sc_hd__decap_3
XFILLER_19_240 VGND VGND VPWR VPWR sky130_fd_sc_hd__decap_3
XFILLER_66_379 VGND VGND VPWR VPWR sky130_fd_sc_hd__decap_3
XFILLER_35_700 VGND VGND VPWR VPWR sky130_fd_sc_hd__fill_1
XFILLER_35_722 VGND VGND VPWR VPWR sky130_fd_sc_hd__decap_3
XFILLER_78_1444 VGND VGND VPWR VPWR sky130_fd_sc_hd__decap_3
XFILLER_74_390 VGND VGND VPWR VPWR sky130_fd_sc_hd__decap_3
X_6870_ _7001_/CLK _6870_/D load_slew769/X VGND VGND VPWR VPWR _6870_/Q sky130_fd_sc_hd__dfrtp_2
XFILLER_34_232 VGND VGND VPWR VPWR sky130_fd_sc_hd__decap_3
XFILLER_39_1428 VGND VGND VPWR VPWR sky130_fd_sc_hd__decap_3
XFILLER_35_788 VGND VGND VPWR VPWR sky130_fd_sc_hd__decap_3
X_5821_ _5821_/A0 _5904_/A0 _5822_/S VGND VGND VPWR VPWR _6840_/D sky130_fd_sc_hd__mux2_1
XFILLER_22_416 VGND VGND VPWR VPWR sky130_fd_sc_hd__decap_3
XFILLER_72_1032 VGND VGND VPWR VPWR sky130_fd_sc_hd__decap_3
X_5752_ _5909_/A0 _5752_/A1 _5757_/S VGND VGND VPWR VPWR _6796_/D sky130_fd_sc_hd__mux2_1
XTAP_TAPCELL_ROW_44_1342 VGND VPWR sky130_fd_sc_hd__tapvpwrvgnd_1
XTAP_TAPCELL_ROW_44_1353 VGND VPWR sky130_fd_sc_hd__tapvpwrvgnd_1
Xclkbuf_leaf_14_clk clkload0/A VGND VGND VPWR VPWR _7073_/CLK sky130_fd_sc_hd__clkbuf_8
XFILLER_37_1174 VGND VGND VPWR VPWR sky130_fd_sc_hd__fill_2
XFILLER_33_1016 VGND VGND VPWR VPWR sky130_fd_sc_hd__fill_1
X_4703_ _4703_/A _4703_/B VGND VGND VPWR VPWR _4703_/Y sky130_fd_sc_hd__nor2_2
XFILLER_30_460 VGND VGND VPWR VPWR sky130_fd_sc_hd__decap_3
XFILLER_72_1087 VGND VGND VPWR VPWR sky130_fd_sc_hd__decap_3
X_5683_ hold898/X _5913_/A0 wire90/X VGND VGND VPWR VPWR _6736_/D sky130_fd_sc_hd__mux2_1
XTAP_TAPCELL_ROW_40_1228 VGND VPWR sky130_fd_sc_hd__tapvpwrvgnd_1
XTAP_TAPCELL_ROW_40_1239 VGND VPWR sky130_fd_sc_hd__tapvpwrvgnd_1
XFILLER_8_71 VGND VGND VPWR VPWR sky130_fd_sc_hd__decap_3
XFILLER_50_1341 VGND VGND VPWR VPWR sky130_fd_sc_hd__decap_3
X_4634_ _6259_/Q _4868_/A2 _3376_/X _4868_/B2 VGND VGND VPWR VPWR _4634_/X sky130_fd_sc_hd__a22o_2
XFILLER_11_1325 VGND VGND VPWR VPWR sky130_fd_sc_hd__decap_3
XFILLER_50_1385 VGND VGND VPWR VPWR sky130_fd_sc_hd__decap_3
X_4565_ _4564_/B _4133_/B _4564_/Y _4741_/C1 VGND VGND VPWR VPWR _4565_/Y sky130_fd_sc_hd__o211ai_2
XFILLER_11_1369 VGND VGND VPWR VPWR sky130_fd_sc_hd__decap_3
X_6304_ _6882_/CLK _6304_/D fanout661/X VGND VGND VPWR VPWR _6304_/Q sky130_fd_sc_hd__dfrtp_2
X_3516_ _4403_/A _3515_/X _3486_/A VGND VGND VPWR VPWR _3516_/Y sky130_fd_sc_hd__o21ai_2
X_4496_ _4518_/A _4851_/B VGND VGND VPWR VPWR _4496_/Y sky130_fd_sc_hd__nor2_2
XPHY_EDGE_ROW_4_Right_4 VGND VGND VPWR VPWR sky130_fd_sc_hd__decap_3
X_3447_ hold921/X _3446_/X _3447_/S VGND VGND VPWR VPWR _6197_/D sky130_fd_sc_hd__mux2_1
X_6235_ _7032_/CLK _6235_/D load_slew694/X VGND VGND VPWR VPWR _6235_/Q sky130_fd_sc_hd__dfrtp_2
XTAP_TAPCELL_ROW_38_1179 VGND VPWR sky130_fd_sc_hd__tapvpwrvgnd_1
XFILLER_48_1270 VGND VGND VPWR VPWR sky130_fd_sc_hd__decap_3
X_3378_ _6308_/Q _6420_/Q VGND VGND VPWR VPWR _3378_/X sky130_fd_sc_hd__xor2_2
XFILLER_44_1145 VGND VGND VPWR VPWR sky130_fd_sc_hd__decap_3
X_6166_ _7025_/CLK _6166_/D wire764/X VGND VGND VPWR VPWR _6166_/Q sky130_fd_sc_hd__dfrtp_2
XFILLER_58_825 VGND VGND VPWR VPWR sky130_fd_sc_hd__decap_3
Xhold1301 _6988_/Q VGND VGND VPWR VPWR _5984_/A1 sky130_fd_sc_hd__dlygate4sd3_1
Xhold1312 _6816_/Q VGND VGND VPWR VPWR _5781_/A0 sky130_fd_sc_hd__dlygate4sd3_1
X_5117_ _6373_/Q _5114_/X _5116_/X _5286_/B1 VGND VGND VPWR VPWR _6373_/D sky130_fd_sc_hd__a22o_2
Xhold1323 _6827_/Q VGND VGND VPWR VPWR _5807_/A1 sky130_fd_sc_hd__dlygate4sd3_1
X_6097_ _7012_/CLK _6097_/D load_slew810/X VGND VGND VPWR VPWR _6097_/Q sky130_fd_sc_hd__dfrtp_2
Xhold1334 _6908_/Q VGND VGND VPWR VPWR _5900_/A1 sky130_fd_sc_hd__dlygate4sd3_1
XFILLER_22_1421 VGND VGND VPWR VPWR sky130_fd_sc_hd__decap_3
Xhold1345 _6891_/Q VGND VGND VPWR VPWR _5881_/A1 sky130_fd_sc_hd__dlygate4sd3_1
XFILLER_57_346 VGND VGND VPWR VPWR sky130_fd_sc_hd__decap_3
XFILLER_22_1432 VGND VGND VPWR VPWR sky130_fd_sc_hd__decap_3
XFILLER_79_1219 VGND VGND VPWR VPWR sky130_fd_sc_hd__decap_3
XFILLER_73_817 VGND VGND VPWR VPWR sky130_fd_sc_hd__fill_2
Xhold1356 _6937_/Q VGND VGND VPWR VPWR _5932_/A1 sky130_fd_sc_hd__dlygate4sd3_1
XFILLER_45_508 VGND VGND VPWR VPWR sky130_fd_sc_hd__decap_3
X_5048_ _6364_/Q _5047_/X _5048_/S VGND VGND VPWR VPWR _6364_/D sky130_fd_sc_hd__mux2_1
Xhold1367 _6889_/Q VGND VGND VPWR VPWR _5878_/A1 sky130_fd_sc_hd__dlygate4sd3_1
XFILLER_72_305 VGND VGND VPWR VPWR sky130_fd_sc_hd__decap_3
Xhold1378 _6640_/Q VGND VGND VPWR VPWR _5557_/B1 sky130_fd_sc_hd__dlygate4sd3_1
Xhold1389 _6764_/Q VGND VGND VPWR VPWR _5716_/A1 sky130_fd_sc_hd__dlygate4sd3_1
XFILLER_22_1465 VGND VGND VPWR VPWR sky130_fd_sc_hd__decap_3
XFILLER_27_69 VGND VGND VPWR VPWR sky130_fd_sc_hd__decap_3
XFILLER_25_210 VGND VGND VPWR VPWR sky130_fd_sc_hd__decap_3
XFILLER_65_390 VGND VGND VPWR VPWR sky130_fd_sc_hd__fill_2
XFILLER_14_928 VGND VGND VPWR VPWR sky130_fd_sc_hd__fill_1
XFILLER_0_1261 VGND VGND VPWR VPWR sky130_fd_sc_hd__decap_3
XFILLER_43_24 VGND VGND VPWR VPWR sky130_fd_sc_hd__fill_1
X_6999_ _6999_/CLK _6999_/D wire827/X VGND VGND VPWR VPWR _6999_/Q sky130_fd_sc_hd__dfrtp_2
XFILLER_25_298 VGND VGND VPWR VPWR sky130_fd_sc_hd__decap_3
XFILLER_13_449 VGND VGND VPWR VPWR sky130_fd_sc_hd__fill_2
XFILLER_43_57 VGND VGND VPWR VPWR sky130_fd_sc_hd__decap_3
XFILLER_16_1214 VGND VGND VPWR VPWR sky130_fd_sc_hd__decap_3
XFILLER_55_1263 VGND VGND VPWR VPWR sky130_fd_sc_hd__decap_3
XFILLER_16_1247 VGND VGND VPWR VPWR sky130_fd_sc_hd__decap_3
XFILLER_21_493 VGND VGND VPWR VPWR sky130_fd_sc_hd__decap_3
XFILLER_5_626 VGND VGND VPWR VPWR sky130_fd_sc_hd__decap_3
XFILLER_4_103 VGND VGND VPWR VPWR sky130_fd_sc_hd__fill_2
XFILLER_5_648 VGND VGND VPWR VPWR sky130_fd_sc_hd__decap_3
XFILLER_4_125 VGND VGND VPWR VPWR sky130_fd_sc_hd__decap_3
XFILLER_49_1012 VGND VGND VPWR VPWR sky130_fd_sc_hd__fill_2
XFILLER_49_1023 VGND VGND VPWR VPWR sky130_fd_sc_hd__decap_3
XFILLER_4_18 VGND VGND VPWR VPWR sky130_fd_sc_hd__decap_3
XFILLER_4_29 VGND VGND VPWR VPWR sky130_fd_sc_hd__decap_3
XTAP_TAPCELL_ROW_8_420 VGND VPWR sky130_fd_sc_hd__tapvpwrvgnd_1
XFILLER_1_821 VGND VGND VPWR VPWR sky130_fd_sc_hd__decap_3
XFILLER_68_21 VGND VGND VPWR VPWR sky130_fd_sc_hd__decap_3
XFILLER_27_1310 VGND VGND VPWR VPWR sky130_fd_sc_hd__decap_3
XFILLER_68_32 VGND VGND VPWR VPWR sky130_fd_sc_hd__decap_3
XFILLER_7_1404 VGND VGND VPWR VPWR sky130_fd_sc_hd__decap_3
XFILLER_1_865 VGND VGND VPWR VPWR sky130_fd_sc_hd__decap_3
XFILLER_27_1343 VGND VGND VPWR VPWR sky130_fd_sc_hd__fill_1
XFILLER_62_1223 VGND VGND VPWR VPWR sky130_fd_sc_hd__decap_3
XFILLER_68_65 VGND VGND VPWR VPWR sky130_fd_sc_hd__decap_3
XFILLER_27_1354 VGND VGND VPWR VPWR sky130_fd_sc_hd__decap_3
XFILLER_7_1437 VGND VGND VPWR VPWR sky130_fd_sc_hd__decap_3
XFILLER_49_836 VGND VGND VPWR VPWR sky130_fd_sc_hd__decap_3
XFILLER_62_1256 VGND VGND VPWR VPWR sky130_fd_sc_hd__decap_3
XFILLER_62_1267 VGND VGND VPWR VPWR sky130_fd_sc_hd__decap_3
XFILLER_75_110 VGND VGND VPWR VPWR sky130_fd_sc_hd__fill_2
XFILLER_0_386 VGND VGND VPWR VPWR sky130_fd_sc_hd__decap_3
XFILLER_27_1387 VGND VGND VPWR VPWR sky130_fd_sc_hd__decap_3
XFILLER_64_806 VGND VGND VPWR VPWR sky130_fd_sc_hd__decap_3
XTAP_TAPCELL_ROW_19_706 VGND VPWR sky130_fd_sc_hd__tapvpwrvgnd_1
XFILLER_48_368 VGND VGND VPWR VPWR sky130_fd_sc_hd__decap_3
XFILLER_76_699 VGND VGND VPWR VPWR sky130_fd_sc_hd__fill_1
XFILLER_5_1172 VGND VGND VPWR VPWR sky130_fd_sc_hd__decap_3
XFILLER_64_839 VGND VGND VPWR VPWR sky130_fd_sc_hd__decap_3
XFILLER_5_1183 VGND VGND VPWR VPWR sky130_fd_sc_hd__decap_3
XFILLER_63_327 VGND VGND VPWR VPWR sky130_fd_sc_hd__fill_1
XFILLER_16_210 VGND VGND VPWR VPWR sky130_fd_sc_hd__decap_3
XFILLER_1_1036 VGND VGND VPWR VPWR sky130_fd_sc_hd__decap_3
XFILLER_17_744 VGND VGND VPWR VPWR sky130_fd_sc_hd__fill_1
XFILLER_17_755 VGND VGND VPWR VPWR sky130_fd_sc_hd__decap_3
XFILLER_16_265 VGND VGND VPWR VPWR sky130_fd_sc_hd__decap_3
XFILLER_44_574 VGND VGND VPWR VPWR sky130_fd_sc_hd__decap_3
XFILLER_56_1027 VGND VGND VPWR VPWR sky130_fd_sc_hd__decap_3
XFILLER_71_393 VGND VGND VPWR VPWR sky130_fd_sc_hd__decap_3
XFILLER_38_1450 VGND VGND VPWR VPWR sky130_fd_sc_hd__decap_3
XTAP_TAPCELL_ROW_80_2276 VGND VPWR sky130_fd_sc_hd__tapvpwrvgnd_1
XTAP_TAPCELL_ROW_80_2287 VGND VPWR sky130_fd_sc_hd__tapvpwrvgnd_1
XFILLER_13_950 VGND VGND VPWR VPWR sky130_fd_sc_hd__fill_2
XFILLER_34_1303 VGND VGND VPWR VPWR sky130_fd_sc_hd__decap_3
XTAP_TAPCELL_ROW_80_2298 VGND VPWR sky130_fd_sc_hd__tapvpwrvgnd_1
XFILLER_73_1363 VGND VGND VPWR VPWR sky130_fd_sc_hd__decap_3
XFILLER_31_268 VGND VGND VPWR VPWR sky130_fd_sc_hd__decap_3
XFILLER_73_1396 VGND VGND VPWR VPWR sky130_fd_sc_hd__decap_3
XFILLER_34_1347 VGND VGND VPWR VPWR sky130_fd_sc_hd__decap_3
XFILLER_76_6 VGND VGND VPWR VPWR sky130_fd_sc_hd__decap_3
XFILLER_8_442 VGND VGND VPWR VPWR sky130_fd_sc_hd__decap_3
X_4350_ _4338_/A _4894_/B _4346_/X _4896_/A1 VGND VGND VPWR VPWR _4350_/X sky130_fd_sc_hd__o2bb2a_2
XFILLER_4_670 VGND VGND VPWR VPWR sky130_fd_sc_hd__decap_3
X_3301_ _5971_/A0 _3300_/X _3429_/S VGND VGND VPWR VPWR _6124_/D sky130_fd_sc_hd__mux2_1
XFILLER_10_1391 VGND VGND VPWR VPWR sky130_fd_sc_hd__decap_3
XFILLER_28_1129 VGND VGND VPWR VPWR sky130_fd_sc_hd__decap_3
X_4281_ _4281_/A _4281_/B VGND VGND VPWR VPWR _4282_/B sky130_fd_sc_hd__xor2_2
XFILLER_63_1009 VGND VGND VPWR VPWR sky130_fd_sc_hd__decap_3
XFILLER_45_1410 VGND VGND VPWR VPWR sky130_fd_sc_hd__decap_3
XFILLER_67_1189 VGND VGND VPWR VPWR sky130_fd_sc_hd__decap_3
XFILLER_80_1301 VGND VGND VPWR VPWR sky130_fd_sc_hd__decap_3
XFILLER_3_180 VGND VGND VPWR VPWR sky130_fd_sc_hd__decap_3
XFILLER_80_1323 VGND VGND VPWR VPWR sky130_fd_sc_hd__decap_3
X_6020_ _6020_/A0 _7024_/Q _6052_/S VGND VGND VPWR VPWR _6020_/X sky130_fd_sc_hd__mux2_1
X_3232_ _6251_/Q _6347_/Q VGND VGND VPWR VPWR _3232_/X sky130_fd_sc_hd__xor2_2
Xclkbuf_leaf_3_clk clkbuf_leaf_3_clk/A VGND VGND VPWR VPWR _7016_/CLK sky130_fd_sc_hd__clkbuf_8
XFILLER_45_1443 VGND VGND VPWR VPWR sky130_fd_sc_hd__decap_3
XFILLER_80_1345 VGND VGND VPWR VPWR sky130_fd_sc_hd__decap_3
XFILLER_39_302 VGND VGND VPWR VPWR sky130_fd_sc_hd__decap_3
XFILLER_67_611 VGND VGND VPWR VPWR sky130_fd_sc_hd__decap_3
XFILLER_41_1307 VGND VGND VPWR VPWR sky130_fd_sc_hd__decap_3
XTAP_TAPCELL_ROW_33_1054 VGND VPWR sky130_fd_sc_hd__tapvpwrvgnd_1
X_3163_ _6076_/A1 _3161_/X _3162_/X _3213_/C1 VGND VGND VPWR VPWR _3163_/X sky130_fd_sc_hd__a211o_2
XTAP_TAPCELL_ROW_33_1065 VGND VPWR sky130_fd_sc_hd__tapvpwrvgnd_1
XFILLER_66_132 VGND VGND VPWR VPWR sky130_fd_sc_hd__fill_2
XFILLER_27_508 VGND VGND VPWR VPWR sky130_fd_sc_hd__decap_3
XFILLER_39_368 VGND VGND VPWR VPWR sky130_fd_sc_hd__decap_3
X_3094_ _5606_/A1 _3089_/B _5565_/A2 VGND VGND VPWR VPWR _7089_/D sky130_fd_sc_hd__a21o_2
X_6922_ _7016_/CLK _6922_/D load_slew662/X VGND VGND VPWR VPWR _6922_/Q sky130_fd_sc_hd__dfrtp_2
XFILLER_78_1241 VGND VGND VPWR VPWR sky130_fd_sc_hd__decap_3
XFILLER_63_850 VGND VGND VPWR VPWR sky130_fd_sc_hd__decap_3
XTAP_TAPCELL_ROW_46_1404 VGND VPWR sky130_fd_sc_hd__tapvpwrvgnd_1
XFILLER_74_1105 VGND VGND VPWR VPWR sky130_fd_sc_hd__decap_3
XFILLER_78_1285 VGND VGND VPWR VPWR sky130_fd_sc_hd__decap_3
XFILLER_39_1236 VGND VGND VPWR VPWR sky130_fd_sc_hd__decap_3
X_6853_ clkload9/A _6853_/D load_slew643/X VGND VGND VPWR VPWR _6853_/Q sky130_fd_sc_hd__dfrtp_2
XFILLER_23_725 VGND VGND VPWR VPWR sky130_fd_sc_hd__decap_3
XFILLER_50_511 VGND VGND VPWR VPWR sky130_fd_sc_hd__fill_1
XFILLER_63_894 VGND VGND VPWR VPWR sky130_fd_sc_hd__fill_2
XFILLER_74_1138 VGND VGND VPWR VPWR sky130_fd_sc_hd__decap_3
Xfanout17 _4562_/B VGND VGND VPWR VPWR _5605_/A3 sky130_fd_sc_hd__clkdlybuf4s25_1
XFILLER_74_1149 VGND VGND VPWR VPWR sky130_fd_sc_hd__decap_3
XFILLER_39_1269 VGND VGND VPWR VPWR sky130_fd_sc_hd__decap_3
X_5804_ _6069_/S _5879_/A _5906_/B VGND VGND VPWR VPWR _5804_/X sky130_fd_sc_hd__a21o_2
XFILLER_50_533 VGND VGND VPWR VPWR sky130_fd_sc_hd__decap_3
XFILLER_62_393 VGND VGND VPWR VPWR sky130_fd_sc_hd__decap_3
XFILLER_22_235 VGND VGND VPWR VPWR sky130_fd_sc_hd__fill_2
Xfanout39 _4855_/B1 VGND VGND VPWR VPWR _4862_/B1 sky130_fd_sc_hd__clkdlybuf4s25_1
X_6784_ _6970_/CLK _6784_/D load_slew671/X VGND VGND VPWR VPWR _6784_/Q sky130_fd_sc_hd__dfrtp_2
XFILLER_52_1403 VGND VGND VPWR VPWR sky130_fd_sc_hd__decap_3
X_3996_ _5512_/A _4002_/A2 _5609_/A3 _3958_/Y _6534_/Q VGND VGND VPWR VPWR _3996_/X
+ sky130_fd_sc_hd__a32o_2
XFILLER_13_27 VGND VGND VPWR VPWR sky130_fd_sc_hd__decap_3
XFILLER_22_279 VGND VGND VPWR VPWR sky130_fd_sc_hd__decap_3
X_5735_ _5928_/A0 _5735_/A1 _5738_/S VGND VGND VPWR VPWR _6781_/D sky130_fd_sc_hd__mux2_1
XFILLER_52_1447 VGND VGND VPWR VPWR sky130_fd_sc_hd__decap_3
XFILLER_31_791 VGND VGND VPWR VPWR sky130_fd_sc_hd__decap_3
X_5666_ _5932_/A0 _5666_/A1 _5666_/S VGND VGND VPWR VPWR _6721_/D sky130_fd_sc_hd__mux2_1
XFILLER_11_1111 VGND VGND VPWR VPWR sky130_fd_sc_hd__fill_1
X_4617_ _4624_/A _4617_/B VGND VGND VPWR VPWR _4617_/Y sky130_fd_sc_hd__nor2_2
X_5597_ _5606_/A1 _5600_/A2 _4300_/B _5601_/B1 _5597_/B2 VGND VGND VPWR VPWR _6669_/D
+ sky130_fd_sc_hd__a32o_2
XFILLER_50_1193 VGND VGND VPWR VPWR sky130_fd_sc_hd__decap_3
XFILLER_11_1177 VGND VGND VPWR VPWR sky130_fd_sc_hd__decap_3
Xmax_cap150 _3812_/B VGND VGND VPWR VPWR _4202_/B sky130_fd_sc_hd__clkbuf_2
X_4548_ _4359_/B _4444_/Y _4547_/X _6536_/Q _4769_/B1 VGND VGND VPWR VPWR _4551_/B
+ sky130_fd_sc_hd__a221o_2
Xmax_cap161 _5701_/S VGND VGND VPWR VPWR _5702_/S sky130_fd_sc_hd__buf_6
XFILLER_8_9 VGND VGND VPWR VPWR sky130_fd_sc_hd__decap_3
XFILLER_1_128 VGND VGND VPWR VPWR sky130_fd_sc_hd__decap_3
XFILLER_78_909 VGND VGND VPWR VPWR sky130_fd_sc_hd__decap_3
X_4479_ _6286_/Q wire52/X _4476_/X _4478_/X VGND VGND VPWR VPWR _6286_/D sky130_fd_sc_hd__o22a_2
XFILLER_77_408 VGND VGND VPWR VPWR sky130_fd_sc_hd__decap_3
X_6218_ _7039_/CLK _6218_/D load_slew829/X VGND VGND VPWR VPWR _6218_/Q sky130_fd_sc_hd__dfrtp_2
XFILLER_57_110 VGND VGND VPWR VPWR sky130_fd_sc_hd__fill_2
Xhold1120 _6137_/Q VGND VGND VPWR VPWR _5984_/A0 sky130_fd_sc_hd__dlygate4sd3_1
X_6149_ _7000_/CLK _6149_/D fanout693/X VGND VGND VPWR VPWR _6149_/Q sky130_fd_sc_hd__dfrtp_2
Xhold1131 _6688_/Q VGND VGND VPWR VPWR _5626_/A0 sky130_fd_sc_hd__dlygate4sd3_1
Xhold1142 _6790_/Q VGND VGND VPWR VPWR _5745_/A1 sky130_fd_sc_hd__dlygate4sd3_1
XFILLER_46_828 VGND VGND VPWR VPWR sky130_fd_sc_hd__decap_3
Xhold1153 _6839_/Q VGND VGND VPWR VPWR _5820_/A0 sky130_fd_sc_hd__dlygate4sd3_1
Xhold1164 _6869_/Q VGND VGND VPWR VPWR _5854_/A0 sky130_fd_sc_hd__dlygate4sd3_1
XFILLER_2_1312 VGND VGND VPWR VPWR sky130_fd_sc_hd__decap_3
XFILLER_22_1251 VGND VGND VPWR VPWR sky130_fd_sc_hd__decap_3
XFILLER_39_880 VGND VGND VPWR VPWR sky130_fd_sc_hd__fill_1
XPHY_EDGE_ROW_79_Right_79 VGND VGND VPWR VPWR sky130_fd_sc_hd__decap_3
XFILLER_2_1323 VGND VGND VPWR VPWR sky130_fd_sc_hd__decap_3
Xhold1175 _5966_/X VGND VGND VPWR VPWR _6970_/D sky130_fd_sc_hd__dlygate4sd3_1
Xhold1186 _6994_/Q VGND VGND VPWR VPWR _5990_/A1 sky130_fd_sc_hd__dlygate4sd3_1
XFILLER_22_1273 VGND VGND VPWR VPWR sky130_fd_sc_hd__decap_3
Xhold1197 _6179_/Q VGND VGND VPWR VPWR _6026_/A0 sky130_fd_sc_hd__dlygate4sd3_1
XFILLER_2_1356 VGND VGND VPWR VPWR sky130_fd_sc_hd__decap_3
XFILLER_26_530 VGND VGND VPWR VPWR sky130_fd_sc_hd__fill_2
XFILLER_54_12 VGND VGND VPWR VPWR sky130_fd_sc_hd__decap_3
XFILLER_54_861 VGND VGND VPWR VPWR sky130_fd_sc_hd__decap_3
XFILLER_54_872 VGND VGND VPWR VPWR sky130_fd_sc_hd__decap_3
XFILLER_57_1325 VGND VGND VPWR VPWR sky130_fd_sc_hd__decap_3
XTAP_TAPCELL_ROW_0_172 VGND VPWR sky130_fd_sc_hd__tapvpwrvgnd_1
XFILLER_53_360 VGND VGND VPWR VPWR sky130_fd_sc_hd__fill_2
XTAP_TAPCELL_ROW_0_183 VGND VPWR sky130_fd_sc_hd__tapvpwrvgnd_1
XFILLER_26_585 VGND VGND VPWR VPWR sky130_fd_sc_hd__decap_3
XFILLER_41_511 VGND VGND VPWR VPWR sky130_fd_sc_hd__decap_3
XFILLER_54_67 VGND VGND VPWR VPWR sky130_fd_sc_hd__decap_3
XFILLER_54_894 VGND VGND VPWR VPWR sky130_fd_sc_hd__decap_3
XFILLER_13_213 VGND VGND VPWR VPWR sky130_fd_sc_hd__decap_3
XTAP_TAPCELL_ROW_0_194 VGND VPWR sky130_fd_sc_hd__tapvpwrvgnd_1
XFILLER_18_1309 VGND VGND VPWR VPWR sky130_fd_sc_hd__decap_3
XFILLER_0_1080 VGND VGND VPWR VPWR sky130_fd_sc_hd__decap_3
XFILLER_41_533 VGND VGND VPWR VPWR sky130_fd_sc_hd__fill_2
XFILLER_57_1369 VGND VGND VPWR VPWR sky130_fd_sc_hd__decap_3
XFILLER_13_279 VGND VGND VPWR VPWR sky130_fd_sc_hd__fill_1
XFILLER_9_228 VGND VGND VPWR VPWR sky130_fd_sc_hd__decap_3
XFILLER_10_920 VGND VGND VPWR VPWR sky130_fd_sc_hd__decap_3
XFILLER_70_44 VGND VGND VPWR VPWR sky130_fd_sc_hd__decap_3
XFILLER_16_1088 VGND VGND VPWR VPWR sky130_fd_sc_hd__decap_3
XFILLER_5_423 VGND VGND VPWR VPWR sky130_fd_sc_hd__decap_3
XFILLER_6_968 VGND VGND VPWR VPWR sky130_fd_sc_hd__decap_3
XFILLER_68_1421 VGND VGND VPWR VPWR sky130_fd_sc_hd__decap_3
XFILLER_68_1432 VGND VGND VPWR VPWR sky130_fd_sc_hd__decap_3
XFILLER_5_467 VGND VGND VPWR VPWR sky130_fd_sc_hd__decap_3
XFILLER_79_42 VGND VGND VPWR VPWR sky130_fd_sc_hd__decap_3
XFILLER_29_1416 VGND VGND VPWR VPWR sky130_fd_sc_hd__decap_3
XFILLER_68_1465 VGND VGND VPWR VPWR sky130_fd_sc_hd__decap_3
XFILLER_79_75 VGND VGND VPWR VPWR sky130_fd_sc_hd__decap_3
XFILLER_79_97 VGND VGND VPWR VPWR sky130_fd_sc_hd__decap_3
XFILLER_29_1449 VGND VGND VPWR VPWR sky130_fd_sc_hd__decap_3
XFILLER_64_1329 VGND VGND VPWR VPWR sky130_fd_sc_hd__decap_3
XTAP_TAPCELL_ROW_73_2091 VGND VPWR sky130_fd_sc_hd__tapvpwrvgnd_1
XFILLER_1_651 VGND VGND VPWR VPWR sky130_fd_sc_hd__decap_3
XFILLER_7_1201 VGND VGND VPWR VPWR sky130_fd_sc_hd__decap_3
XFILLER_1_673 VGND VGND VPWR VPWR sky130_fd_sc_hd__decap_3
XFILLER_0_150 VGND VGND VPWR VPWR sky130_fd_sc_hd__decap_3
XFILLER_7_1245 VGND VGND VPWR VPWR sky130_fd_sc_hd__decap_3
XFILLER_0_172 VGND VGND VPWR VPWR sky130_fd_sc_hd__decap_3
XFILLER_23_1015 VGND VGND VPWR VPWR sky130_fd_sc_hd__fill_1
XFILLER_77_975 VGND VGND VPWR VPWR sky130_fd_sc_hd__decap_3
XFILLER_62_1086 VGND VGND VPWR VPWR sky130_fd_sc_hd__decap_3
XFILLER_76_452 VGND VGND VPWR VPWR sky130_fd_sc_hd__decap_3
XFILLER_7_1278 VGND VGND VPWR VPWR sky130_fd_sc_hd__decap_3
XFILLER_37_817 VGND VGND VPWR VPWR sky130_fd_sc_hd__decap_3
XFILLER_7_1289 VGND VGND VPWR VPWR sky130_fd_sc_hd__decap_3
XFILLER_40_1362 VGND VGND VPWR VPWR sky130_fd_sc_hd__decap_3
XFILLER_48_187 VGND VGND VPWR VPWR sky130_fd_sc_hd__decap_3
XFILLER_40_1373 VGND VGND VPWR VPWR sky130_fd_sc_hd__decap_3
XFILLER_75_1425 VGND VGND VPWR VPWR sky130_fd_sc_hd__decap_3
XFILLER_36_1409 VGND VGND VPWR VPWR sky130_fd_sc_hd__decap_3
XFILLER_32_533 VGND VGND VPWR VPWR sky130_fd_sc_hd__fill_1
X_3850_ _3933_/A _4077_/B _3831_/X _4049_/A1 VGND VGND VPWR VPWR _3850_/X sky130_fd_sc_hd__o2bb2a_2
XFILLER_32_555 VGND VGND VPWR VPWR sky130_fd_sc_hd__decap_3
XFILLER_73_1160 VGND VGND VPWR VPWR sky130_fd_sc_hd__decap_3
XFILLER_20_728 VGND VGND VPWR VPWR sky130_fd_sc_hd__decap_3
XFILLER_38_1291 VGND VGND VPWR VPWR sky130_fd_sc_hd__decap_3
X_3781_ _3781_/A _3781_/B VGND VGND VPWR VPWR _4065_/B sky130_fd_sc_hd__xnor2_2
XFILLER_34_1133 VGND VGND VPWR VPWR sky130_fd_sc_hd__decap_3
XFILLER_34_1155 VGND VGND VPWR VPWR sky130_fd_sc_hd__fill_2
X_5520_ _6610_/Q _6617_/Q VGND VGND VPWR VPWR _5520_/X sky130_fd_sc_hd__or2_2
XFILLER_74_3 VGND VGND VPWR VPWR sky130_fd_sc_hd__decap_3
XFILLER_34_1177 VGND VGND VPWR VPWR sky130_fd_sc_hd__fill_1
XFILLER_69_1207 VGND VGND VPWR VPWR sky130_fd_sc_hd__decap_3
X_5451_ _5451_/A1 _5480_/A2 _4031_/X VGND VGND VPWR VPWR _6563_/D sky130_fd_sc_hd__a21o_2
XFILLER_12_1453 VGND VGND VPWR VPWR sky130_fd_sc_hd__decap_3
X_4402_ _3889_/A _3889_/B _4562_/C _4768_/B _4586_/A VGND VGND VPWR VPWR _4760_/B
+ sky130_fd_sc_hd__o2111ai_2
X_5382_ _5382_/A1 _5470_/A2 _4340_/X VGND VGND VPWR VPWR _6494_/D sky130_fd_sc_hd__a21o_2
X_4333_ _6269_/Q wire63/A _4330_/X _4332_/X VGND VGND VPWR VPWR _6269_/D sky130_fd_sc_hd__o22a_2
XTAP_TAPCELL_ROW_35_1105 VGND VPWR sky130_fd_sc_hd__tapvpwrvgnd_1
XFILLER_5_83 VGND VGND VPWR VPWR sky130_fd_sc_hd__decap_3
XTAP_TAPCELL_ROW_35_1116 VGND VPWR sky130_fd_sc_hd__tapvpwrvgnd_1
XFILLER_8_1009 VGND VGND VPWR VPWR sky130_fd_sc_hd__decap_3
Xfanout207 _6044_/S VGND VGND VPWR VPWR _6046_/S sky130_fd_sc_hd__clkdlybuf4s25_1
Xfanout218 _5997_/S VGND VGND VPWR VPWR _5970_/S sky130_fd_sc_hd__clkdlybuf4s25_1
X_7052_ _7052_/CLK _7052_/D fanout806/X VGND VGND VPWR VPWR _7052_/Q sky130_fd_sc_hd__dfrtp_2
X_4264_ _6263_/Q _4427_/S _4261_/X _4263_/X VGND VGND VPWR VPWR _6263_/D sky130_fd_sc_hd__o22a_2
Xfanout229 _6035_/S VGND VGND VPWR VPWR _6032_/S sky130_fd_sc_hd__clkdlybuf4s25_1
XFILLER_45_1251 VGND VGND VPWR VPWR sky130_fd_sc_hd__decap_3
XFILLER_80_1142 VGND VGND VPWR VPWR sky130_fd_sc_hd__decap_3
XFILLER_68_931 VGND VGND VPWR VPWR sky130_fd_sc_hd__decap_3
X_3215_ _7009_/Q _3219_/B2 _3223_/A1 _3214_/X VGND VGND VPWR VPWR _3215_/X sky130_fd_sc_hd__a22o_2
X_6003_ hold970/X _6003_/A1 _6035_/S VGND VGND VPWR VPWR _7007_/D sky130_fd_sc_hd__mux2_1
XFILLER_80_1164 VGND VGND VPWR VPWR sky130_fd_sc_hd__decap_3
X_4195_ _6480_/Q _3483_/A _4788_/A _4194_/X VGND VGND VPWR VPWR _4195_/X sky130_fd_sc_hd__o211a_2
XFILLER_45_1284 VGND VGND VPWR VPWR sky130_fd_sc_hd__decap_3
XFILLER_45_1295 VGND VGND VPWR VPWR sky130_fd_sc_hd__decap_3
XFILLER_80_1186 VGND VGND VPWR VPWR sky130_fd_sc_hd__decap_3
XPHY_EDGE_ROW_19_Left_100 VGND VGND VPWR VPWR sky130_fd_sc_hd__decap_3
X_3146_ _7044_/Q _7052_/Q _3149_/S VGND VGND VPWR VPWR _3146_/X sky130_fd_sc_hd__mux2_1
XFILLER_67_485 VGND VGND VPWR VPWR sky130_fd_sc_hd__decap_3
XFILLER_54_113 VGND VGND VPWR VPWR sky130_fd_sc_hd__decap_3
XFILLER_39_198 VGND VGND VPWR VPWR sky130_fd_sc_hd__decap_3
X_3077_ _7082_/Q _3077_/B VGND VGND VPWR VPWR _3078_/A sky130_fd_sc_hd__nand2_2
XFILLER_36_861 VGND VGND VPWR VPWR sky130_fd_sc_hd__fill_1
XTAP_TAPCELL_ROW_69_1982 VGND VPWR sky130_fd_sc_hd__tapvpwrvgnd_1
XFILLER_70_628 VGND VGND VPWR VPWR sky130_fd_sc_hd__fill_1
X_6905_ _6905_/CLK _6905_/D wire734/X VGND VGND VPWR VPWR _6905_/Q sky130_fd_sc_hd__dfrtp_2
XTAP_TAPCELL_ROW_69_1993 VGND VPWR sky130_fd_sc_hd__tapvpwrvgnd_1
XFILLER_78_1082 VGND VGND VPWR VPWR sky130_fd_sc_hd__decap_3
XFILLER_51_820 VGND VGND VPWR VPWR sky130_fd_sc_hd__decap_3
XFILLER_78_1093 VGND VGND VPWR VPWR sky130_fd_sc_hd__decap_3
XFILLER_24_15 VGND VGND VPWR VPWR sky130_fd_sc_hd__decap_3
XFILLER_35_393 VGND VGND VPWR VPWR sky130_fd_sc_hd__decap_3
X_6836_ _7039_/CLK _6836_/D load_slew829/X VGND VGND VPWR VPWR _6836_/Q sky130_fd_sc_hd__dfrtp_2
XTAP_TAPCELL_ROW_65_1879 VGND VPWR sky130_fd_sc_hd__tapvpwrvgnd_1
XFILLER_39_1088 VGND VGND VPWR VPWR sky130_fd_sc_hd__decap_3
XFILLER_51_875 VGND VGND VPWR VPWR sky130_fd_sc_hd__decap_3
XFILLER_23_577 VGND VGND VPWR VPWR sky130_fd_sc_hd__decap_3
XFILLER_52_1200 VGND VGND VPWR VPWR sky130_fd_sc_hd__decap_3
XFILLER_17_1331 VGND VGND VPWR VPWR sky130_fd_sc_hd__decap_3
XFILLER_50_374 VGND VGND VPWR VPWR sky130_fd_sc_hd__decap_3
X_6767_ _6991_/CLK _6767_/D load_slew792/X VGND VGND VPWR VPWR _6767_/Q sky130_fd_sc_hd__dfrtp_2
XFILLER_56_1391 VGND VGND VPWR VPWR sky130_fd_sc_hd__decap_3
Xwire608 wire608/A VGND VGND VPWR VPWR _5797_/C sky130_fd_sc_hd__buf_4
X_3979_ _4077_/B _4388_/A VGND VGND VPWR VPWR _3979_/Y sky130_fd_sc_hd__nor2_2
XTAP_TAPCELL_ROW_21_734 VGND VPWR sky130_fd_sc_hd__tapvpwrvgnd_1
XFILLER_13_1206 VGND VGND VPWR VPWR sky130_fd_sc_hd__decap_3
XFILLER_17_1375 VGND VGND VPWR VPWR sky130_fd_sc_hd__decap_3
XTAP_TAPCELL_ROW_21_745 VGND VPWR sky130_fd_sc_hd__tapvpwrvgnd_1
XFILLER_52_1255 VGND VGND VPWR VPWR sky130_fd_sc_hd__decap_3
X_5718_ _5911_/A0 _5718_/A1 wire88/X VGND VGND VPWR VPWR _6766_/D sky130_fd_sc_hd__mux2_1
XTAP_TAPCELL_ROW_21_756 VGND VPWR sky130_fd_sc_hd__tapvpwrvgnd_1
X_6698_ _6858_/CLK _6698_/D fanout646/X VGND VGND VPWR VPWR _6698_/Q sky130_fd_sc_hd__dfrtp_2
XFILLER_13_1239 VGND VGND VPWR VPWR sky130_fd_sc_hd__decap_3
XFILLER_52_1288 VGND VGND VPWR VPWR sky130_fd_sc_hd__decap_3
X_5649_ _5749_/A _7068_/Q _5740_/C _5685_/C VGND VGND VPWR VPWR _5657_/S sky130_fd_sc_hd__and4_2
XFILLER_3_927 VGND VGND VPWR VPWR sky130_fd_sc_hd__decap_3
XFILLER_2_404 VGND VGND VPWR VPWR sky130_fd_sc_hd__decap_3
XFILLER_6_6 VGND VGND VPWR VPWR sky130_fd_sc_hd__decap_3
XFILLER_2_448 VGND VGND VPWR VPWR sky130_fd_sc_hd__decap_3
XFILLER_49_12 VGND VGND VPWR VPWR sky130_fd_sc_hd__fill_1
XFILLER_78_739 VGND VGND VPWR VPWR sky130_fd_sc_hd__decap_3
Xfanout730 fanout739/X VGND VGND VPWR VPWR fanout730/X sky130_fd_sc_hd__clkdlybuf4s25_1
XFILLER_63_1340 VGND VGND VPWR VPWR sky130_fd_sc_hd__decap_3
Xfanout741 fanout746/X VGND VGND VPWR VPWR fanout741/X sky130_fd_sc_hd__clkdlybuf4s25_1
XFILLER_63_1351 VGND VGND VPWR VPWR sky130_fd_sc_hd__decap_3
Xfanout752 fanout790/X VGND VGND VPWR VPWR fanout752/X sky130_fd_sc_hd__clkdlybuf4s25_1
Xfanout763 fanout766/X VGND VGND VPWR VPWR wire764/A sky130_fd_sc_hd__clkdlybuf4s25_1
Xfanout774 fanout776/X VGND VGND VPWR VPWR fanout774/X sky130_fd_sc_hd__clkdlybuf4s25_1
XFILLER_24_1335 VGND VGND VPWR VPWR sky130_fd_sc_hd__decap_3
XFILLER_63_1384 VGND VGND VPWR VPWR sky130_fd_sc_hd__decap_3
Xfanout785 fanout788/X VGND VGND VPWR VPWR fanout785/X sky130_fd_sc_hd__clkdlybuf4s25_1
XFILLER_4_1418 VGND VGND VPWR VPWR sky130_fd_sc_hd__decap_3
XFILLER_4_1429 VGND VGND VPWR VPWR sky130_fd_sc_hd__decap_3
XFILLER_24_1368 VGND VGND VPWR VPWR sky130_fd_sc_hd__decap_3
XFILLER_73_411 VGND VGND VPWR VPWR sky130_fd_sc_hd__fill_1
XFILLER_24_1379 VGND VGND VPWR VPWR sky130_fd_sc_hd__decap_3
XFILLER_65_33 VGND VGND VPWR VPWR sky130_fd_sc_hd__fill_2
XFILLER_18_327 VGND VGND VPWR VPWR sky130_fd_sc_hd__decap_3
XFILLER_45_113 VGND VGND VPWR VPWR sky130_fd_sc_hd__decap_3
XFILLER_2_1120 VGND VGND VPWR VPWR sky130_fd_sc_hd__decap_3
XFILLER_65_66 VGND VGND VPWR VPWR sky130_fd_sc_hd__decap_3
XFILLER_27_850 VGND VGND VPWR VPWR sky130_fd_sc_hd__fill_1
XFILLER_46_669 VGND VGND VPWR VPWR sky130_fd_sc_hd__decap_3
XFILLER_2_1164 VGND VGND VPWR VPWR sky130_fd_sc_hd__decap_3
XFILLER_61_617 VGND VGND VPWR VPWR sky130_fd_sc_hd__fill_1
XFILLER_27_883 VGND VGND VPWR VPWR sky130_fd_sc_hd__decap_3
XFILLER_33_319 VGND VGND VPWR VPWR sky130_fd_sc_hd__decap_3
XFILLER_60_105 VGND VGND VPWR VPWR sky130_fd_sc_hd__fill_1
XFILLER_2_1197 VGND VGND VPWR VPWR sky130_fd_sc_hd__decap_3
XFILLER_26_371 VGND VGND VPWR VPWR sky130_fd_sc_hd__decap_3
XFILLER_60_127 VGND VGND VPWR VPWR sky130_fd_sc_hd__fill_1
XFILLER_42_831 VGND VGND VPWR VPWR sky130_fd_sc_hd__decap_3
XFILLER_26_393 VGND VGND VPWR VPWR sky130_fd_sc_hd__decap_3
XFILLER_18_1117 VGND VGND VPWR VPWR sky130_fd_sc_hd__decap_3
XFILLER_14_555 VGND VGND VPWR VPWR sky130_fd_sc_hd__decap_3
XFILLER_42_864 VGND VGND VPWR VPWR sky130_fd_sc_hd__decap_3
XFILLER_42_875 VGND VGND VPWR VPWR sky130_fd_sc_hd__fill_2
XFILLER_57_1177 VGND VGND VPWR VPWR sky130_fd_sc_hd__decap_3
XFILLER_70_1300 VGND VGND VPWR VPWR sky130_fd_sc_hd__decap_3
XFILLER_35_1431 VGND VGND VPWR VPWR sky130_fd_sc_hd__decap_3
XFILLER_41_396 VGND VGND VPWR VPWR sky130_fd_sc_hd__fill_2
XFILLER_70_1344 VGND VGND VPWR VPWR sky130_fd_sc_hd__decap_3
XFILLER_31_1328 VGND VGND VPWR VPWR sky130_fd_sc_hd__decap_3
XFILLER_70_1388 VGND VGND VPWR VPWR sky130_fd_sc_hd__decap_3
XFILLER_6_710 VGND VGND VPWR VPWR sky130_fd_sc_hd__decap_3
XFILLER_60_9 VGND VGND VPWR VPWR sky130_fd_sc_hd__fill_2
XTAP_TAPCELL_ROW_75_2142 VGND VPWR sky130_fd_sc_hd__tapvpwrvgnd_1
XTAP_TAPCELL_ROW_75_2153 VGND VPWR sky130_fd_sc_hd__tapvpwrvgnd_1
XFILLER_6_798 VGND VGND VPWR VPWR sky130_fd_sc_hd__decap_3
XTAP_TAPCELL_ROW_71_2039 VGND VPWR sky130_fd_sc_hd__tapvpwrvgnd_1
XFILLER_68_1273 VGND VGND VPWR VPWR sky130_fd_sc_hd__decap_3
XFILLER_9_1307 VGND VGND VPWR VPWR sky130_fd_sc_hd__decap_3
XFILLER_64_1126 VGND VGND VPWR VPWR sky130_fd_sc_hd__decap_3
XFILLER_29_1257 VGND VGND VPWR VPWR sky130_fd_sc_hd__decap_3
XFILLER_39_6 VGND VGND VPWR VPWR sky130_fd_sc_hd__decap_3
XFILLER_2_993 VGND VGND VPWR VPWR sky130_fd_sc_hd__decap_3
XFILLER_1_481 VGND VGND VPWR VPWR sky130_fd_sc_hd__decap_3
XFILLER_42_1424 VGND VGND VPWR VPWR sky130_fd_sc_hd__decap_3
XFILLER_7_1053 VGND VGND VPWR VPWR sky130_fd_sc_hd__decap_3
XFILLER_42_1435 VGND VGND VPWR VPWR sky130_fd_sc_hd__decap_3
XFILLER_42_1468 VGND VGND VPWR VPWR sky130_fd_sc_hd__fill_1
XFILLER_65_923 VGND VGND VPWR VPWR sky130_fd_sc_hd__decap_3
Xinput7 ui_in[5] VGND VGND VPWR VPWR input7/X sky130_fd_sc_hd__buf_1
XFILLER_7_1086 VGND VGND VPWR VPWR sky130_fd_sc_hd__decap_3
XFILLER_49_485 VGND VGND VPWR VPWR sky130_fd_sc_hd__decap_3
XFILLER_64_433 VGND VGND VPWR VPWR sky130_fd_sc_hd__decap_3
XFILLER_65_967 VGND VGND VPWR VPWR sky130_fd_sc_hd__decap_3
XFILLER_40_1170 VGND VGND VPWR VPWR sky130_fd_sc_hd__decap_3
XFILLER_36_157 VGND VGND VPWR VPWR sky130_fd_sc_hd__fill_1
XFILLER_51_105 VGND VGND VPWR VPWR sky130_fd_sc_hd__decap_3
XFILLER_75_1222 VGND VGND VPWR VPWR sky130_fd_sc_hd__decap_3
X_4951_ _6447_/Q _6665_/Q VGND VGND VPWR VPWR _4952_/B sky130_fd_sc_hd__xor2_2
XFILLER_75_1233 VGND VGND VPWR VPWR sky130_fd_sc_hd__decap_3
X_3902_ _6285_/Q _4010_/B _3902_/B1 _6261_/Q _3902_/C1 VGND VGND VPWR VPWR _3902_/X
+ sky130_fd_sc_hd__a221o_2
XFILLER_75_1266 VGND VGND VPWR VPWR sky130_fd_sc_hd__decap_3
XFILLER_36_1217 VGND VGND VPWR VPWR sky130_fd_sc_hd__decap_3
X_4882_ _6317_/Q _4882_/A2 _3460_/X _4882_/B2 VGND VGND VPWR VPWR _4882_/X sky130_fd_sc_hd__a22o_2
XFILLER_36_1228 VGND VGND VPWR VPWR sky130_fd_sc_hd__decap_3
XFILLER_33_875 VGND VGND VPWR VPWR sky130_fd_sc_hd__decap_3
X_6621_ _7073_/CLK _6621_/D load_slew684/X VGND VGND VPWR VPWR _6621_/Q sky130_fd_sc_hd__dfrtp_2
X_3833_ _6283_/Q _3960_/B _3921_/B1 _6259_/Q _3921_/C1 VGND VGND VPWR VPWR _3833_/X
+ sky130_fd_sc_hd__a221o_2
XFILLER_60_694 VGND VGND VPWR VPWR sky130_fd_sc_hd__decap_3
XTAP_TAPCELL_ROW_15_583 VGND VPWR sky130_fd_sc_hd__tapvpwrvgnd_1
XFILLER_20_536 VGND VGND VPWR VPWR sky130_fd_sc_hd__decap_3
XTAP_TAPCELL_ROW_15_594 VGND VPWR sky130_fd_sc_hd__tapvpwrvgnd_1
XTAP_TAPCELL_ROW_60_1754 VGND VPWR sky130_fd_sc_hd__tapvpwrvgnd_1
X_6552_ _6888_/CLK _6552_/D load_slew705/X VGND VGND VPWR VPWR _6552_/Q sky130_fd_sc_hd__dfrtp_2
XTAP_TAPCELL_ROW_60_1765 VGND VPWR sky130_fd_sc_hd__tapvpwrvgnd_1
X_3764_ _4008_/B wire154/X _4277_/B _3089_/B _6497_/Q VGND VGND VPWR VPWR _3764_/X
+ sky130_fd_sc_hd__a32o_2
Xtt_um_aes128_optimized_855 VGND VGND VPWR VPWR tt_um_aes128_optimized_855/HI uio_out[2]
+ sky130_fd_sc_hd__conb_1
X_5503_ _5569_/A _5511_/B VGND VGND VPWR VPWR _5512_/B sky130_fd_sc_hd__nand2_2
XFILLER_9_592 VGND VGND VPWR VPWR sky130_fd_sc_hd__decap_3
X_6483_ _6888_/CLK _6483_/D fanout704/X VGND VGND VPWR VPWR _6483_/Q sky130_fd_sc_hd__dfrtp_2
X_3695_ wire26/X _3687_/B _3648_/X VGND VGND VPWR VPWR _3695_/Y sky130_fd_sc_hd__a21oi_2
XFILLER_12_1250 VGND VGND VPWR VPWR sky130_fd_sc_hd__decap_3
XFILLER_12_1261 VGND VGND VPWR VPWR sky130_fd_sc_hd__decap_3
X_5434_ _5434_/A1 _5474_/A2 _4626_/X VGND VGND VPWR VPWR _6546_/D sky130_fd_sc_hd__a21o_2
XFILLER_12_1294 VGND VGND VPWR VPWR sky130_fd_sc_hd__decap_3
XFILLER_47_1313 VGND VGND VPWR VPWR sky130_fd_sc_hd__decap_3
X_5365_ _5365_/A1 _5461_/A2 _4165_/X VGND VGND VPWR VPWR _6477_/D sky130_fd_sc_hd__a21o_2
XFILLER_47_1357 VGND VGND VPWR VPWR sky130_fd_sc_hd__decap_3
X_4316_ _4316_/A _4316_/B VGND VGND VPWR VPWR _4317_/B sky130_fd_sc_hd__xor2_2
X_5296_ _6779_/Q _4910_/B _5298_/S VGND VGND VPWR VPWR _5296_/X sky130_fd_sc_hd__mux2_1
X_7035_ _7035_/CLK _7035_/D load_slew843/X VGND VGND VPWR VPWR _7035_/Q sky130_fd_sc_hd__dfrtp_2
X_4247_ _6261_/Q wire63/X _4244_/X _4246_/X VGND VGND VPWR VPWR _6261_/D sky130_fd_sc_hd__o22a_2
XFILLER_19_48 VGND VGND VPWR VPWR sky130_fd_sc_hd__fill_2
X_4178_ _6254_/Q wire54/X _4175_/X _4177_/X VGND VGND VPWR VPWR _6254_/D sky130_fd_sc_hd__o22a_2
XFILLER_27_102 VGND VGND VPWR VPWR sky130_fd_sc_hd__decap_3
XFILLER_67_271 VGND VGND VPWR VPWR sky130_fd_sc_hd__fill_1
XTAP_TAPCELL_ROW_2_245 VGND VPWR sky130_fd_sc_hd__tapvpwrvgnd_1
XFILLER_3_1440 VGND VGND VPWR VPWR sky130_fd_sc_hd__decap_3
XTAP_TAPCELL_ROW_2_256 VGND VPWR sky130_fd_sc_hd__tapvpwrvgnd_1
XFILLER_16_809 VGND VGND VPWR VPWR sky130_fd_sc_hd__decap_3
XFILLER_28_669 VGND VGND VPWR VPWR sky130_fd_sc_hd__fill_1
X_3129_ _3212_/A1 _7027_/Q _7035_/Q _3136_/A VGND VGND VPWR VPWR _3129_/X sky130_fd_sc_hd__a22o_2
XFILLER_23_1390 VGND VGND VPWR VPWR sky130_fd_sc_hd__decap_3
XFILLER_43_617 VGND VGND VPWR VPWR sky130_fd_sc_hd__decap_3
XFILLER_70_447 VGND VGND VPWR VPWR sky130_fd_sc_hd__fill_2
XFILLER_19_1404 VGND VGND VPWR VPWR sky130_fd_sc_hd__decap_3
XFILLER_24_842 VGND VGND VPWR VPWR sky130_fd_sc_hd__fill_1
XFILLER_42_138 VGND VGND VPWR VPWR sky130_fd_sc_hd__fill_2
XFILLER_58_1453 VGND VGND VPWR VPWR sky130_fd_sc_hd__decap_3
XFILLER_70_458 VGND VGND VPWR VPWR sky130_fd_sc_hd__fill_2
XFILLER_23_330 VGND VGND VPWR VPWR sky130_fd_sc_hd__decap_3
XFILLER_54_1306 VGND VGND VPWR VPWR sky130_fd_sc_hd__decap_3
XFILLER_19_1437 VGND VGND VPWR VPWR sky130_fd_sc_hd__decap_3
XFILLER_54_1317 VGND VGND VPWR VPWR sky130_fd_sc_hd__decap_3
XFILLER_23_352 VGND VGND VPWR VPWR sky130_fd_sc_hd__decap_3
X_6819_ _6819_/CLK _6819_/D fanout749/X VGND VGND VPWR VPWR _6819_/Q sky130_fd_sc_hd__dfrtp_2
XFILLER_23_396 VGND VGND VPWR VPWR sky130_fd_sc_hd__decap_3
XFILLER_17_1172 VGND VGND VPWR VPWR sky130_fd_sc_hd__decap_3
XFILLER_51_57 VGND VGND VPWR VPWR sky130_fd_sc_hd__fill_2
XFILLER_13_1058 VGND VGND VPWR VPWR sky130_fd_sc_hd__decap_3
XFILLER_30_1350 VGND VGND VPWR VPWR sky130_fd_sc_hd__decap_3
XFILLER_3_735 VGND VGND VPWR VPWR sky130_fd_sc_hd__decap_3
XFILLER_2_212 VGND VGND VPWR VPWR sky130_fd_sc_hd__decap_3
XFILLER_30_1394 VGND VGND VPWR VPWR sky130_fd_sc_hd__decap_3
XFILLER_65_1413 VGND VGND VPWR VPWR sky130_fd_sc_hd__decap_3
XFILLER_4_3 VGND VGND VPWR VPWR sky130_fd_sc_hd__decap_3
XFILLER_2_245 VGND VGND VPWR VPWR sky130_fd_sc_hd__decap_3
XFILLER_2_256 VGND VGND VPWR VPWR sky130_fd_sc_hd__fill_2
XFILLER_65_1446 VGND VGND VPWR VPWR sky130_fd_sc_hd__decap_3
XFILLER_2_267 VGND VGND VPWR VPWR sky130_fd_sc_hd__decap_3
XFILLER_65_1457 VGND VGND VPWR VPWR sky130_fd_sc_hd__decap_3
XFILLER_78_536 VGND VGND VPWR VPWR sky130_fd_sc_hd__fill_1
XFILLER_78_558 VGND VGND VPWR VPWR sky130_fd_sc_hd__fill_2
XFILLER_76_21 VGND VGND VPWR VPWR sky130_fd_sc_hd__decap_3
XFILLER_76_32 VGND VGND VPWR VPWR sky130_fd_sc_hd__decap_3
XFILLER_8_1362 VGND VGND VPWR VPWR sky130_fd_sc_hd__decap_3
XFILLER_8_1373 VGND VGND VPWR VPWR sky130_fd_sc_hd__decap_3
Xfanout571 _3722_/A VGND VGND VPWR VPWR _3960_/A sky130_fd_sc_hd__clkdlybuf4s25_1
XFILLER_76_65 VGND VGND VPWR VPWR sky130_fd_sc_hd__decap_3
Xfanout582 _4355_/A VGND VGND VPWR VPWR _4532_/B sky130_fd_sc_hd__clkdlybuf4s25_1
XFILLER_4_1226 VGND VGND VPWR VPWR sky130_fd_sc_hd__decap_3
Xfanout593 _4369_/B VGND VGND VPWR VPWR _3601_/B sky130_fd_sc_hd__clkdlybuf4s25_1
XFILLER_46_400 VGND VGND VPWR VPWR sky130_fd_sc_hd__fill_2
XFILLER_20_1018 VGND VGND VPWR VPWR sky130_fd_sc_hd__decap_3
XFILLER_24_1187 VGND VGND VPWR VPWR sky130_fd_sc_hd__decap_3
XFILLER_4_1259 VGND VGND VPWR VPWR sky130_fd_sc_hd__fill_1
XFILLER_19_658 VGND VGND VPWR VPWR sky130_fd_sc_hd__decap_3
XFILLER_74_753 VGND VGND VPWR VPWR sky130_fd_sc_hd__decap_3
XFILLER_46_466 VGND VGND VPWR VPWR sky130_fd_sc_hd__fill_2
XFILLER_59_1228 VGND VGND VPWR VPWR sky130_fd_sc_hd__decap_3
XFILLER_46_477 VGND VGND VPWR VPWR sky130_fd_sc_hd__decap_3
XFILLER_59_1239 VGND VGND VPWR VPWR sky130_fd_sc_hd__decap_3
XFILLER_72_1406 VGND VGND VPWR VPWR sky130_fd_sc_hd__decap_3
XFILLER_70_981 VGND VGND VPWR VPWR sky130_fd_sc_hd__decap_3
XFILLER_14_374 VGND VGND VPWR VPWR sky130_fd_sc_hd__decap_3
XFILLER_15_897 VGND VGND VPWR VPWR sky130_fd_sc_hd__decap_3
XTAP_TAPCELL_ROW_12_520 VGND VPWR sky130_fd_sc_hd__tapvpwrvgnd_1
XFILLER_41_193 VGND VGND VPWR VPWR sky130_fd_sc_hd__decap_3
XFILLER_70_1141 VGND VGND VPWR VPWR sky130_fd_sc_hd__decap_3
XFILLER_30_867 VGND VGND VPWR VPWR sky130_fd_sc_hd__fill_1
XTAP_TAPCELL_ROW_77_2204 VGND VPWR sky130_fd_sc_hd__tapvpwrvgnd_1
XFILLER_70_1152 VGND VGND VPWR VPWR sky130_fd_sc_hd__decap_3
XTAP_TAPCELL_ROW_77_2215 VGND VPWR sky130_fd_sc_hd__tapvpwrvgnd_1
XFILLER_35_1272 VGND VGND VPWR VPWR sky130_fd_sc_hd__decap_3
XFILLER_70_1185 VGND VGND VPWR VPWR sky130_fd_sc_hd__decap_3
XFILLER_31_1169 VGND VGND VPWR VPWR sky130_fd_sc_hd__decap_3
XFILLER_41_90 VGND VGND VPWR VPWR sky130_fd_sc_hd__decap_3
X_3480_ _6247_/Q _6471_/Q VGND VGND VPWR VPWR _3480_/X sky130_fd_sc_hd__xor2_2
XFILLER_6_562 VGND VGND VPWR VPWR sky130_fd_sc_hd__decap_3
XFILLER_69_503 VGND VGND VPWR VPWR sky130_fd_sc_hd__fill_1
X_5150_ _6722_/Q _5326_/S VGND VGND VPWR VPWR _5150_/X sky130_fd_sc_hd__or2_2
XFILLER_69_514 VGND VGND VPWR VPWR sky130_fd_sc_hd__decap_3
XFILLER_37_3 VGND VGND VPWR VPWR sky130_fd_sc_hd__decap_3
XFILLER_29_1076 VGND VGND VPWR VPWR sky130_fd_sc_hd__decap_3
XFILLER_9_1148 VGND VGND VPWR VPWR sky130_fd_sc_hd__decap_3
X_4101_ _4777_/A _4101_/B VGND VGND VPWR VPWR _4101_/Y sky130_fd_sc_hd__nor2_2
X_5081_ _6401_/Q _5273_/B VGND VGND VPWR VPWR _5083_/B sky130_fd_sc_hd__xor2_2
XFILLER_69_558 VGND VGND VPWR VPWR sky130_fd_sc_hd__fill_2
XTAP_TAPCELL_ROW_53_1580 VGND VPWR sky130_fd_sc_hd__tapvpwrvgnd_1
XFILLER_42_1243 VGND VGND VPWR VPWR sky130_fd_sc_hd__decap_3
XTAP_TAPCELL_ROW_53_1591 VGND VPWR sky130_fd_sc_hd__tapvpwrvgnd_1
X_4032_ _3408_/X _4080_/A2 _4080_/B1 _6901_/Q _4080_/C1 VGND VGND VPWR VPWR _4032_/X
+ sky130_fd_sc_hd__a221o_2
XFILLER_2_62 VGND VGND VPWR VPWR sky130_fd_sc_hd__decap_3
XFILLER_77_591 VGND VGND VPWR VPWR sky130_fd_sc_hd__decap_3
XFILLER_38_956 VGND VGND VPWR VPWR sky130_fd_sc_hd__fill_1
XFILLER_42_1276 VGND VGND VPWR VPWR sky130_fd_sc_hd__decap_3
XFILLER_49_293 VGND VGND VPWR VPWR sky130_fd_sc_hd__decap_3
XFILLER_37_455 VGND VGND VPWR VPWR sky130_fd_sc_hd__decap_3
XFILLER_38_978 VGND VGND VPWR VPWR sky130_fd_sc_hd__fill_2
XFILLER_80_701 VGND VGND VPWR VPWR sky130_fd_sc_hd__decap_3
XFILLER_77_1328 VGND VGND VPWR VPWR sky130_fd_sc_hd__decap_3
XFILLER_25_617 VGND VGND VPWR VPWR sky130_fd_sc_hd__decap_3
XFILLER_64_263 VGND VGND VPWR VPWR sky130_fd_sc_hd__decap_3
XFILLER_18_680 VGND VGND VPWR VPWR sky130_fd_sc_hd__decap_3
X_5983_ _5983_/A0 _5983_/A1 _6047_/S VGND VGND VPWR VPWR _6987_/D sky130_fd_sc_hd__mux2_1
XFILLER_53_959 VGND VGND VPWR VPWR sky130_fd_sc_hd__decap_3
XFILLER_64_296 VGND VGND VPWR VPWR sky130_fd_sc_hd__decap_3
XFILLER_80_778 VGND VGND VPWR VPWR sky130_fd_sc_hd__decap_3
X_4934_ _4932_/X _4933_/Y _5284_/A2 VGND VGND VPWR VPWR _4936_/S sky130_fd_sc_hd__a21oi_2
XTAP_TAPCELL_ROW_62_1805 VGND VPWR sky130_fd_sc_hd__tapvpwrvgnd_1
XFILLER_75_1052 VGND VGND VPWR VPWR sky130_fd_sc_hd__decap_3
XTAP_TAPCELL_ROW_23_807 VGND VPWR sky130_fd_sc_hd__tapvpwrvgnd_1
XTAP_TAPCELL_ROW_62_1816 VGND VPWR sky130_fd_sc_hd__tapvpwrvgnd_1
XFILLER_61_992 VGND VGND VPWR VPWR sky130_fd_sc_hd__decap_3
XFILLER_75_1096 VGND VGND VPWR VPWR sky130_fd_sc_hd__decap_3
XFILLER_20_300 VGND VGND VPWR VPWR sky130_fd_sc_hd__decap_3
X_4865_ _4894_/A _4865_/B VGND VGND VPWR VPWR _4865_/Y sky130_fd_sc_hd__nor2_2
XFILLER_32_182 VGND VGND VPWR VPWR sky130_fd_sc_hd__decap_3
XANTENNA_12 _3202_/A VGND VGND VPWR VPWR sky130_fd_sc_hd__diode_2
XANTENNA_23 _5813_/S VGND VGND VPWR VPWR sky130_fd_sc_hd__diode_2
XANTENNA_34 input5/X VGND VGND VPWR VPWR sky130_fd_sc_hd__diode_2
X_6604_ _7041_/CLK _6604_/D fanout725/X VGND VGND VPWR VPWR _6604_/Q sky130_fd_sc_hd__dfrtp_2
XFILLER_14_1312 VGND VGND VPWR VPWR sky130_fd_sc_hd__decap_3
X_3816_ _4123_/B2 _3797_/X _3815_/X VGND VGND VPWR VPWR _3816_/X sky130_fd_sc_hd__o21a_2
XFILLER_14_1323 VGND VGND VPWR VPWR sky130_fd_sc_hd__decap_3
XANTENNA_45 _5748_/S VGND VGND VPWR VPWR sky130_fd_sc_hd__diode_2
XFILLER_53_1372 VGND VGND VPWR VPWR sky130_fd_sc_hd__decap_3
X_4796_ _4796_/A _4796_/B _4796_/C VGND VGND VPWR VPWR _4796_/X sky130_fd_sc_hd__or3_2
XANTENNA_56 _5627_/S VGND VGND VPWR VPWR sky130_fd_sc_hd__diode_2
XANTENNA_67 wire331/X VGND VGND VPWR VPWR sky130_fd_sc_hd__diode_2
XANTENNA_78 _3203_/S VGND VGND VPWR VPWR sky130_fd_sc_hd__diode_2
XFILLER_14_1356 VGND VGND VPWR VPWR sky130_fd_sc_hd__decap_3
XANTENNA_89 fanout395/X VGND VGND VPWR VPWR sky130_fd_sc_hd__diode_2
X_6535_ _6905_/CLK _6535_/D wire738/X VGND VGND VPWR VPWR _6535_/Q sky130_fd_sc_hd__dfrtp_2
X_3747_ _3882_/B VGND VGND VPWR VPWR _3753_/B sky130_fd_sc_hd__inv_2
X_6466_ _7060_/CLK _6466_/D load_slew786/X VGND VGND VPWR VPWR _6466_/Q sky130_fd_sc_hd__dfrtp_2
XFILLER_49_1419 VGND VGND VPWR VPWR sky130_fd_sc_hd__decap_3
X_3678_ _3648_/X _3748_/B _3748_/A VGND VGND VPWR VPWR _3678_/Y sky130_fd_sc_hd__a21oi_2
X_5417_ _5417_/A1 _5485_/A2 _3969_/X VGND VGND VPWR VPWR _6529_/D sky130_fd_sc_hd__a21o_2
X_6397_ _7054_/CLK _6397_/D load_slew757/X VGND VGND VPWR VPWR _6397_/Q sky130_fd_sc_hd__dfrtp_2
XFILLER_47_1121 VGND VGND VPWR VPWR sky130_fd_sc_hd__fill_1
XFILLER_0_716 VGND VGND VPWR VPWR sky130_fd_sc_hd__decap_3
X_5348_ _6805_/Q _5096_/B _5348_/S VGND VGND VPWR VPWR _5348_/X sky130_fd_sc_hd__mux2_1
XFILLER_0_738 VGND VGND VPWR VPWR sky130_fd_sc_hd__decap_3
XFILLER_43_1007 VGND VGND VPWR VPWR sky130_fd_sc_hd__fill_1
X_5279_ _5342_/S _5279_/B VGND VGND VPWR VPWR _5279_/Y sky130_fd_sc_hd__nand2_2
XFILLER_75_517 VGND VGND VPWR VPWR sky130_fd_sc_hd__decap_3
XFILLER_25_1452 VGND VGND VPWR VPWR sky130_fd_sc_hd__decap_3
XFILLER_60_1332 VGND VGND VPWR VPWR sky130_fd_sc_hd__decap_3
XFILLER_25_1463 VGND VGND VPWR VPWR sky130_fd_sc_hd__decap_3
X_7018_ _7050_/CLK _7018_/D load_slew645/X VGND VGND VPWR VPWR _7018_/Q sky130_fd_sc_hd__dfrtp_2
XFILLER_47_219 VGND VGND VPWR VPWR sky130_fd_sc_hd__decap_3
XFILLER_28_400 VGND VGND VPWR VPWR sky130_fd_sc_hd__decap_3
XFILLER_21_1316 VGND VGND VPWR VPWR sky130_fd_sc_hd__decap_3
XFILLER_56_731 VGND VGND VPWR VPWR sky130_fd_sc_hd__decap_3
XFILLER_60_1365 VGND VGND VPWR VPWR sky130_fd_sc_hd__decap_3
XFILLER_60_1376 VGND VGND VPWR VPWR sky130_fd_sc_hd__decap_3
XFILLER_28_455 VGND VGND VPWR VPWR sky130_fd_sc_hd__decap_3
XFILLER_28_466 VGND VGND VPWR VPWR sky130_fd_sc_hd__fill_1
XFILLER_71_723 VGND VGND VPWR VPWR sky130_fd_sc_hd__decap_3
XFILLER_3_1281 VGND VGND VPWR VPWR sky130_fd_sc_hd__decap_3
XFILLER_70_211 VGND VGND VPWR VPWR sky130_fd_sc_hd__fill_1
XFILLER_3_1292 VGND VGND VPWR VPWR sky130_fd_sc_hd__decap_3
XFILLER_70_233 VGND VGND VPWR VPWR sky130_fd_sc_hd__fill_2
XFILLER_58_1261 VGND VGND VPWR VPWR sky130_fd_sc_hd__decap_3
XFILLER_70_244 VGND VGND VPWR VPWR sky130_fd_sc_hd__decap_3
XFILLER_43_469 VGND VGND VPWR VPWR sky130_fd_sc_hd__decap_3
XFILLER_19_1223 VGND VGND VPWR VPWR sky130_fd_sc_hd__decap_3
XFILLER_19_1245 VGND VGND VPWR VPWR sky130_fd_sc_hd__decap_3
XFILLER_58_1294 VGND VGND VPWR VPWR sky130_fd_sc_hd__decap_3
XFILLER_70_288 VGND VGND VPWR VPWR sky130_fd_sc_hd__decap_3
XFILLER_52_992 VGND VGND VPWR VPWR sky130_fd_sc_hd__decap_3
XFILLER_70_299 VGND VGND VPWR VPWR sky130_fd_sc_hd__fill_1
XFILLER_19_1278 VGND VGND VPWR VPWR sky130_fd_sc_hd__decap_3
XFILLER_19_1289 VGND VGND VPWR VPWR sky130_fd_sc_hd__decap_3
XFILLER_7_304 VGND VGND VPWR VPWR sky130_fd_sc_hd__decap_3
XFILLER_32_1412 VGND VGND VPWR VPWR sky130_fd_sc_hd__decap_3
XFILLER_7_18 VGND VGND VPWR VPWR sky130_fd_sc_hd__decap_3
XFILLER_7_348 VGND VGND VPWR VPWR sky130_fd_sc_hd__fill_1
XFILLER_32_1456 VGND VGND VPWR VPWR sky130_fd_sc_hd__decap_3
Xwire257 _4549_/B VGND VGND VPWR VPWR _4572_/B sky130_fd_sc_hd__clkbuf_4
XFILLER_11_82 VGND VGND VPWR VPWR sky130_fd_sc_hd__decap_3
XFILLER_3_543 VGND VGND VPWR VPWR sky130_fd_sc_hd__decap_3
XFILLER_65_1210 VGND VGND VPWR VPWR sky130_fd_sc_hd__decap_3
XFILLER_69_1390 VGND VGND VPWR VPWR sky130_fd_sc_hd__decap_3
XFILLER_3_576 VGND VGND VPWR VPWR sky130_fd_sc_hd__decap_3
XFILLER_65_1254 VGND VGND VPWR VPWR sky130_fd_sc_hd__decap_3
XFILLER_26_1238 VGND VGND VPWR VPWR sky130_fd_sc_hd__decap_3
XFILLER_65_1287 VGND VGND VPWR VPWR sky130_fd_sc_hd__fill_1
XFILLER_23_9 VGND VGND VPWR VPWR sky130_fd_sc_hd__decap_3
XFILLER_65_1298 VGND VGND VPWR VPWR sky130_fd_sc_hd__decap_3
XFILLER_8_1170 VGND VGND VPWR VPWR sky130_fd_sc_hd__decap_3
XFILLER_78_399 VGND VGND VPWR VPWR sky130_fd_sc_hd__decap_3
XFILLER_19_422 VGND VGND VPWR VPWR sky130_fd_sc_hd__decap_3
Xfanout390 _4735_/B2 VGND VGND VPWR VPWR fanout390/X sky130_fd_sc_hd__clkdlybuf4s25_1
XFILLER_4_1034 VGND VGND VPWR VPWR sky130_fd_sc_hd__fill_2
XFILLER_46_230 VGND VGND VPWR VPWR sky130_fd_sc_hd__fill_1
XFILLER_35_937 VGND VGND VPWR VPWR sky130_fd_sc_hd__decap_3
XFILLER_47_797 VGND VGND VPWR VPWR sky130_fd_sc_hd__decap_3
XFILLER_34_436 VGND VGND VPWR VPWR sky130_fd_sc_hd__decap_3
XFILLER_35_959 VGND VGND VPWR VPWR sky130_fd_sc_hd__decap_3
XFILLER_46_296 VGND VGND VPWR VPWR sky130_fd_sc_hd__decap_3
XFILLER_62_745 VGND VGND VPWR VPWR sky130_fd_sc_hd__decap_3
XTAP_TAPCELL_ROW_17_634 VGND VPWR sky130_fd_sc_hd__tapvpwrvgnd_1
XTAP_TAPCELL_ROW_17_645 VGND VPWR sky130_fd_sc_hd__tapvpwrvgnd_1
XFILLER_61_233 VGND VGND VPWR VPWR sky130_fd_sc_hd__decap_3
XFILLER_76_1350 VGND VGND VPWR VPWR sky130_fd_sc_hd__decap_3
XFILLER_37_1301 VGND VGND VPWR VPWR sky130_fd_sc_hd__decap_3
XFILLER_62_767 VGND VGND VPWR VPWR sky130_fd_sc_hd__decap_3
XFILLER_72_1203 VGND VGND VPWR VPWR sky130_fd_sc_hd__fill_1
XFILLER_72_1214 VGND VGND VPWR VPWR sky130_fd_sc_hd__decap_3
XFILLER_37_1334 VGND VGND VPWR VPWR sky130_fd_sc_hd__decap_3
XFILLER_76_1394 VGND VGND VPWR VPWR sky130_fd_sc_hd__decap_3
XFILLER_37_1345 VGND VGND VPWR VPWR sky130_fd_sc_hd__decap_3
XFILLER_72_1247 VGND VGND VPWR VPWR sky130_fd_sc_hd__decap_3
XFILLER_37_1378 VGND VGND VPWR VPWR sky130_fd_sc_hd__decap_3
X_4650_ _6309_/Q wire63/X _4647_/X _4649_/X VGND VGND VPWR VPWR _6309_/D sky130_fd_sc_hd__o22a_2
XFILLER_30_664 VGND VGND VPWR VPWR sky130_fd_sc_hd__fill_1
Xinput10 uio_in[0] VGND VGND VPWR VPWR _7091_/D sky130_fd_sc_hd__clkdlybuf4s25_1
X_3601_ _3601_/A _3601_/B _6623_/Q VGND VGND VPWR VPWR _3601_/X sky130_fd_sc_hd__and3_2
XTAP_TAPCELL_ROW_42_1281 VGND VPWR sky130_fd_sc_hd__tapvpwrvgnd_1
XTAP_TAPCELL_ROW_42_1292 VGND VPWR sky130_fd_sc_hd__tapvpwrvgnd_1
X_4581_ _4580_/B _4754_/B _4580_/Y _3486_/B VGND VGND VPWR VPWR _4582_/C sky130_fd_sc_hd__o211ai_2
X_6320_ _7072_/CLK _6320_/D wire687/X VGND VGND VPWR VPWR _6320_/Q sky130_fd_sc_hd__dfrtp_2
X_3532_ _3532_/A _3532_/B VGND VGND VPWR VPWR _3532_/X sky130_fd_sc_hd__or2_2
X_6251_ _7034_/CLK _6251_/D fanout675/X VGND VGND VPWR VPWR _6251_/Q sky130_fd_sc_hd__dfrtp_2
X_3463_ _6052_/A0 _3462_/X _3463_/S VGND VGND VPWR VPWR _6205_/D sky130_fd_sc_hd__mux2_1
XTAP_TAPCELL_ROW_55_1620 VGND VPWR sky130_fd_sc_hd__tapvpwrvgnd_1
XFILLER_48_1441 VGND VGND VPWR VPWR sky130_fd_sc_hd__decap_3
XTAP_TAPCELL_ROW_55_1631 VGND VPWR sky130_fd_sc_hd__tapvpwrvgnd_1
X_5202_ _6747_/Q _5298_/S _5305_/S _5201_/Y VGND VGND VPWR VPWR _5202_/X sky130_fd_sc_hd__o211a_2
XTAP_TAPCELL_ROW_55_1642 VGND VPWR sky130_fd_sc_hd__tapvpwrvgnd_1
X_6182_ _7089_/CLK _6182_/D wire738/X VGND VGND VPWR VPWR _6182_/Q sky130_fd_sc_hd__dfrtp_2
X_3394_ _6316_/Q _6428_/Q VGND VGND VPWR VPWR _3394_/X sky130_fd_sc_hd__xor2_2
XTAP_TAPCELL_ROW_51_1517 VGND VPWR sky130_fd_sc_hd__tapvpwrvgnd_1
X_5133_ _6375_/Q _5130_/X _5132_/X wire127/A VGND VGND VPWR VPWR _6375_/D sky130_fd_sc_hd__a22o_2
XFILLER_44_1338 VGND VGND VPWR VPWR sky130_fd_sc_hd__decap_3
XTAP_TAPCELL_ROW_51_1528 VGND VPWR sky130_fd_sc_hd__tapvpwrvgnd_1
XTAP_TAPCELL_ROW_4_307 VGND VPWR sky130_fd_sc_hd__tapvpwrvgnd_1
XTAP_TAPCELL_ROW_51_1539 VGND VPWR sky130_fd_sc_hd__tapvpwrvgnd_1
XFILLER_29_208 VGND VGND VPWR VPWR sky130_fd_sc_hd__decap_3
XFILLER_57_517 VGND VGND VPWR VPWR sky130_fd_sc_hd__decap_3
Xhold1505 _6624_/Q VGND VGND VPWR VPWR _5541_/B1 sky130_fd_sc_hd__dlygate4sd3_1
Xhold1516 _6506_/Q VGND VGND VPWR VPWR _5394_/A1 sky130_fd_sc_hd__dlygate4sd3_1
Xhold1527 _6586_/Q VGND VGND VPWR VPWR _5474_/A1 sky130_fd_sc_hd__dlygate4sd3_1
Xhold1538 _6654_/Q VGND VGND VPWR VPWR _5576_/B2 sky130_fd_sc_hd__dlygate4sd3_1
X_5064_ _6431_/Q _5064_/B VGND VGND VPWR VPWR _5267_/B sky130_fd_sc_hd__xnor2_2
XFILLER_42_1040 VGND VGND VPWR VPWR sky130_fd_sc_hd__decap_3
Xhold1549 _6673_/Q VGND VGND VPWR VPWR _5601_/B2 sky130_fd_sc_hd__dlygate4sd3_1
X_4015_ _6232_/Q _4081_/A2 _4013_/X _4014_/X VGND VGND VPWR VPWR _6232_/D sky130_fd_sc_hd__o22a_2
XFILLER_65_572 VGND VGND VPWR VPWR sky130_fd_sc_hd__decap_3
XFILLER_0_1410 VGND VGND VPWR VPWR sky130_fd_sc_hd__decap_3
XFILLER_77_1136 VGND VGND VPWR VPWR sky130_fd_sc_hd__decap_3
XFILLER_80_520 VGND VGND VPWR VPWR sky130_fd_sc_hd__decap_3
XFILLER_0_1432 VGND VGND VPWR VPWR sky130_fd_sc_hd__decap_3
XFILLER_25_436 VGND VGND VPWR VPWR sky130_fd_sc_hd__decap_3
XFILLER_20_1371 VGND VGND VPWR VPWR sky130_fd_sc_hd__fill_1
XFILLER_37_296 VGND VGND VPWR VPWR sky130_fd_sc_hd__decap_3
XFILLER_20_1382 VGND VGND VPWR VPWR sky130_fd_sc_hd__decap_3
XTAP_TAPCELL_ROW_49_1468 VGND VPWR sky130_fd_sc_hd__tapvpwrvgnd_1
XFILLER_52_233 VGND VGND VPWR VPWR sky130_fd_sc_hd__decap_3
XFILLER_53_756 VGND VGND VPWR VPWR sky130_fd_sc_hd__fill_1
XFILLER_77_1169 VGND VGND VPWR VPWR sky130_fd_sc_hd__decap_3
XTAP_TAPCELL_ROW_49_1479 VGND VPWR sky130_fd_sc_hd__tapvpwrvgnd_1
XFILLER_13_609 VGND VGND VPWR VPWR sky130_fd_sc_hd__decap_3
XFILLER_55_1401 VGND VGND VPWR VPWR sky130_fd_sc_hd__decap_3
X_5966_ _5966_/A0 _6970_/Q _5998_/S VGND VGND VPWR VPWR _5966_/X sky130_fd_sc_hd__mux2_1
XFILLER_12_108 VGND VGND VPWR VPWR sky130_fd_sc_hd__decap_3
XFILLER_55_1434 VGND VGND VPWR VPWR sky130_fd_sc_hd__decap_3
XFILLER_12_119 VGND VGND VPWR VPWR sky130_fd_sc_hd__fill_1
XFILLER_40_439 VGND VGND VPWR VPWR sky130_fd_sc_hd__decap_3
X_4917_ _6410_/Q _4917_/B VGND VGND VPWR VPWR _5204_/B sky130_fd_sc_hd__xnor2_2
XFILLER_52_299 VGND VGND VPWR VPWR sky130_fd_sc_hd__decap_3
XFILLER_16_1418 VGND VGND VPWR VPWR sky130_fd_sc_hd__decap_3
X_5897_ _5924_/A _5915_/B _5924_/C VGND VGND VPWR VPWR _5905_/S sky130_fd_sc_hd__or3_2
XFILLER_16_1429 VGND VGND VPWR VPWR sky130_fd_sc_hd__decap_3
XFILLER_21_653 VGND VGND VPWR VPWR sky130_fd_sc_hd__decap_3
XFILLER_20_141 VGND VGND VPWR VPWR sky130_fd_sc_hd__fill_2
X_4848_ _6922_/Q _4869_/A2 _4846_/X _4847_/X VGND VGND VPWR VPWR _4848_/X sky130_fd_sc_hd__a211o_2
XFILLER_32_37 VGND VGND VPWR VPWR sky130_fd_sc_hd__decap_3
XFILLER_20_152 VGND VGND VPWR VPWR sky130_fd_sc_hd__decap_3
XFILLER_14_1142 VGND VGND VPWR VPWR sky130_fd_sc_hd__fill_1
X_4779_ _4779_/A1 _4776_/X _4777_/Y _4778_/X _4604_/A VGND VGND VPWR VPWR _4779_/X
+ sky130_fd_sc_hd__o221a_2
X_6518_ _7024_/CLK _6518_/D fanout659/X VGND VGND VPWR VPWR _6518_/Q sky130_fd_sc_hd__dfrtp_2
X_6449_ _7051_/CLK _6449_/D load_slew815/X VGND VGND VPWR VPWR _6449_/Q sky130_fd_sc_hd__dfrtp_2
XFILLER_62_1427 VGND VGND VPWR VPWR sky130_fd_sc_hd__fill_1
XFILLER_0_557 VGND VGND VPWR VPWR sky130_fd_sc_hd__decap_3
XFILLER_57_12 VGND VGND VPWR VPWR sky130_fd_sc_hd__decap_3
XFILLER_62_1438 VGND VGND VPWR VPWR sky130_fd_sc_hd__decap_3
XFILLER_0_579 VGND VGND VPWR VPWR sky130_fd_sc_hd__decap_3
XFILLER_5_1310 VGND VGND VPWR VPWR sky130_fd_sc_hd__decap_3
XFILLER_57_45 VGND VGND VPWR VPWR sky130_fd_sc_hd__decap_3
XFILLER_48_539 VGND VGND VPWR VPWR sky130_fd_sc_hd__decap_3
XFILLER_25_1260 VGND VGND VPWR VPWR sky130_fd_sc_hd__decap_3
XFILLER_57_78 VGND VGND VPWR VPWR sky130_fd_sc_hd__decap_3
XFILLER_5_1343 VGND VGND VPWR VPWR sky130_fd_sc_hd__fill_1
XFILLER_29_742 VGND VGND VPWR VPWR sky130_fd_sc_hd__fill_1
XFILLER_5_1354 VGND VGND VPWR VPWR sky130_fd_sc_hd__decap_3
XFILLER_1_1207 VGND VGND VPWR VPWR sky130_fd_sc_hd__decap_3
XFILLER_21_1135 VGND VGND VPWR VPWR sky130_fd_sc_hd__decap_3
XFILLER_5_1387 VGND VGND VPWR VPWR sky130_fd_sc_hd__decap_3
XFILLER_44_701 VGND VGND VPWR VPWR sky130_fd_sc_hd__fill_2
XFILLER_56_561 VGND VGND VPWR VPWR sky130_fd_sc_hd__decap_3
XFILLER_17_926 VGND VGND VPWR VPWR sky130_fd_sc_hd__decap_3
XFILLER_16_414 VGND VGND VPWR VPWR sky130_fd_sc_hd__decap_3
XTAP_TAPCELL_ROW_27_910 VGND VPWR sky130_fd_sc_hd__tapvpwrvgnd_1
XFILLER_29_797 VGND VGND VPWR VPWR sky130_fd_sc_hd__decap_3
XFILLER_73_33 VGND VGND VPWR VPWR sky130_fd_sc_hd__decap_3
XFILLER_71_520 VGND VGND VPWR VPWR sky130_fd_sc_hd__decap_3
XFILLER_17_959 VGND VGND VPWR VPWR sky130_fd_sc_hd__decap_3
XFILLER_43_211 VGND VGND VPWR VPWR sky130_fd_sc_hd__fill_2
XFILLER_44_745 VGND VGND VPWR VPWR sky130_fd_sc_hd__decap_3
XFILLER_16_447 VGND VGND VPWR VPWR sky130_fd_sc_hd__fill_2
XFILLER_16_458 VGND VGND VPWR VPWR sky130_fd_sc_hd__decap_3
XFILLER_32_907 VGND VGND VPWR VPWR sky130_fd_sc_hd__decap_3
XFILLER_44_767 VGND VGND VPWR VPWR sky130_fd_sc_hd__decap_3
XFILLER_73_66 VGND VGND VPWR VPWR sky130_fd_sc_hd__decap_3
XFILLER_19_1031 VGND VGND VPWR VPWR sky130_fd_sc_hd__decap_3
XFILLER_25_992 VGND VGND VPWR VPWR sky130_fd_sc_hd__fill_1
XFILLER_40_995 VGND VGND VPWR VPWR sky130_fd_sc_hd__decap_3
XFILLER_32_1253 VGND VGND VPWR VPWR sky130_fd_sc_hd__decap_3
XFILLER_32_1264 VGND VGND VPWR VPWR sky130_fd_sc_hd__decap_3
XFILLER_7_167 VGND VGND VPWR VPWR sky130_fd_sc_hd__fill_1
XFILLER_32_1297 VGND VGND VPWR VPWR sky130_fd_sc_hd__decap_3
XFILLER_67_1316 VGND VGND VPWR VPWR sky130_fd_sc_hd__decap_3
XFILLER_4_852 VGND VGND VPWR VPWR sky130_fd_sc_hd__decap_3
XFILLER_3_340 VGND VGND VPWR VPWR sky130_fd_sc_hd__decap_3
XFILLER_4_885 VGND VGND VPWR VPWR sky130_fd_sc_hd__decap_3
XFILLER_79_620 VGND VGND VPWR VPWR sky130_fd_sc_hd__decap_3
XFILLER_65_1040 VGND VGND VPWR VPWR sky130_fd_sc_hd__decap_3
XFILLER_65_1062 VGND VGND VPWR VPWR sky130_fd_sc_hd__fill_2
XFILLER_78_130 VGND VGND VPWR VPWR sky130_fd_sc_hd__decap_3
XFILLER_26_1035 VGND VGND VPWR VPWR sky130_fd_sc_hd__fill_1
XFILLER_21_6 VGND VGND VPWR VPWR sky130_fd_sc_hd__decap_3
XFILLER_67_826 VGND VGND VPWR VPWR sky130_fd_sc_hd__decap_3
XFILLER_6_1129 VGND VGND VPWR VPWR sky130_fd_sc_hd__decap_3
XFILLER_26_1079 VGND VGND VPWR VPWR sky130_fd_sc_hd__decap_3
XFILLER_43_1360 VGND VGND VPWR VPWR sky130_fd_sc_hd__decap_3
XFILLER_67_859 VGND VGND VPWR VPWR sky130_fd_sc_hd__fill_2
XFILLER_43_1393 VGND VGND VPWR VPWR sky130_fd_sc_hd__decap_3
XFILLER_47_550 VGND VGND VPWR VPWR sky130_fd_sc_hd__decap_3
XFILLER_78_1412 VGND VGND VPWR VPWR sky130_fd_sc_hd__decap_3
XFILLER_47_572 VGND VGND VPWR VPWR sky130_fd_sc_hd__decap_3
XFILLER_19_274 VGND VGND VPWR VPWR sky130_fd_sc_hd__decap_3
XFILLER_34_200 VGND VGND VPWR VPWR sky130_fd_sc_hd__decap_3
XFILLER_47_583 VGND VGND VPWR VPWR sky130_fd_sc_hd__decap_3
XFILLER_78_1456 VGND VGND VPWR VPWR sky130_fd_sc_hd__decap_3
XFILLER_39_1407 VGND VGND VPWR VPWR sky130_fd_sc_hd__decap_3
XFILLER_35_756 VGND VGND VPWR VPWR sky130_fd_sc_hd__decap_3
XFILLER_62_531 VGND VGND VPWR VPWR sky130_fd_sc_hd__fill_1
XFILLER_74_1309 VGND VGND VPWR VPWR sky130_fd_sc_hd__decap_3
X_5820_ _5820_/A0 _5930_/A0 _5822_/S VGND VGND VPWR VPWR _6839_/D sky130_fd_sc_hd__mux2_1
XFILLER_35_778 VGND VGND VPWR VPWR sky130_fd_sc_hd__decap_3
XFILLER_50_704 VGND VGND VPWR VPWR sky130_fd_sc_hd__decap_3
XFILLER_23_929 VGND VGND VPWR VPWR sky130_fd_sc_hd__decap_3
XFILLER_62_575 VGND VGND VPWR VPWR sky130_fd_sc_hd__decap_3
XFILLER_16_970 VGND VGND VPWR VPWR sky130_fd_sc_hd__decap_3
XFILLER_16_981 VGND VGND VPWR VPWR sky130_fd_sc_hd__decap_3
XFILLER_72_1011 VGND VGND VPWR VPWR sky130_fd_sc_hd__decap_3
XFILLER_50_737 VGND VGND VPWR VPWR sky130_fd_sc_hd__decap_3
XFILLER_76_1191 VGND VGND VPWR VPWR sky130_fd_sc_hd__decap_3
X_5751_ _5908_/A0 _5751_/A1 _5757_/S VGND VGND VPWR VPWR _6795_/D sky130_fd_sc_hd__mux2_1
XTAP_TAPCELL_ROW_44_1332 VGND VPWR sky130_fd_sc_hd__tapvpwrvgnd_1
XTAP_TAPCELL_ROW_44_1343 VGND VPWR sky130_fd_sc_hd__tapvpwrvgnd_1
XTAP_TAPCELL_ROW_44_1354 VGND VPWR sky130_fd_sc_hd__tapvpwrvgnd_1
X_4702_ _4694_/B _4324_/X _4665_/X _6557_/Q VGND VGND VPWR VPWR _4702_/X sky130_fd_sc_hd__a22o_2
X_5682_ _5682_/A0 _5797_/C wire90/X VGND VGND VPWR VPWR _6735_/D sky130_fd_sc_hd__mux2_1
XTAP_TAPCELL_ROW_40_1229 VGND VPWR sky130_fd_sc_hd__tapvpwrvgnd_1
XFILLER_15_1440 VGND VGND VPWR VPWR sky130_fd_sc_hd__decap_3
XFILLER_50_1320 VGND VGND VPWR VPWR sky130_fd_sc_hd__decap_3
X_4633_ _4654_/A1 _4630_/X _4631_/Y _4632_/X _4831_/C1 VGND VGND VPWR VPWR _4633_/X
+ sky130_fd_sc_hd__o221a_2
XFILLER_11_1304 VGND VGND VPWR VPWR sky130_fd_sc_hd__decap_3
XFILLER_50_1353 VGND VGND VPWR VPWR sky130_fd_sc_hd__decap_3
XFILLER_11_1337 VGND VGND VPWR VPWR sky130_fd_sc_hd__decap_3
X_4564_ _6538_/Q _4564_/B VGND VGND VPWR VPWR _4564_/Y sky130_fd_sc_hd__nand2_2
XFILLER_11_1348 VGND VGND VPWR VPWR sky130_fd_sc_hd__decap_3
XFILLER_50_1397 VGND VGND VPWR VPWR sky130_fd_sc_hd__decap_3
X_6303_ _6913_/CLK _6303_/D fanout727/X VGND VGND VPWR VPWR _6303_/Q sky130_fd_sc_hd__dfrtp_2
X_3515_ _3513_/X _3514_/X _4723_/B VGND VGND VPWR VPWR _3515_/X sky130_fd_sc_hd__mux2_1
X_4495_ _5514_/A _4355_/A _4277_/X _4487_/X _6521_/Q VGND VGND VPWR VPWR _4495_/X
+ sky130_fd_sc_hd__a32o_2
X_6234_ _6999_/CLK _6234_/D load_slew825/X VGND VGND VPWR VPWR _6234_/Q sky130_fd_sc_hd__dfrtp_2
X_3446_ _6334_/Q _6454_/Q VGND VGND VPWR VPWR _3446_/X sky130_fd_sc_hd__xor2_2
XFILLER_48_1282 VGND VGND VPWR VPWR sky130_fd_sc_hd__decap_3
XFILLER_69_130 VGND VGND VPWR VPWR sky130_fd_sc_hd__decap_3
X_6165_ clkload9/A _6165_/D fanout659/X VGND VGND VPWR VPWR _6165_/Q sky130_fd_sc_hd__dfrtp_2
X_3377_ hold997/X _3376_/X _3377_/S VGND VGND VPWR VPWR _6162_/D sky130_fd_sc_hd__mux2_1
Xload_slew560 _3191_/S VGND VGND VPWR VPWR _3149_/S sky130_fd_sc_hd__buf_4
Xhold1302 _6907_/Q VGND VGND VPWR VPWR _5899_/A1 sky130_fd_sc_hd__dlygate4sd3_1
Xhold1313 _6772_/Q VGND VGND VPWR VPWR _5725_/A1 sky130_fd_sc_hd__dlygate4sd3_1
X_5116_ _6373_/Q _5115_/X _5107_/A _6711_/Q VGND VGND VPWR VPWR _5116_/X sky130_fd_sc_hd__a2bb2o_2
XFILLER_22_1400 VGND VGND VPWR VPWR sky130_fd_sc_hd__decap_3
XFILLER_44_1179 VGND VGND VPWR VPWR sky130_fd_sc_hd__decap_3
Xhold1324 _6873_/Q VGND VGND VPWR VPWR _5858_/A0 sky130_fd_sc_hd__dlygate4sd3_1
X_6096_ _6987_/CLK _6096_/D load_slew834/X VGND VGND VPWR VPWR _6096_/Q sky130_fd_sc_hd__dfrtp_2
Xhold1335 _6912_/Q VGND VGND VPWR VPWR _5904_/A1 sky130_fd_sc_hd__dlygate4sd3_1
XFILLER_61_1460 VGND VGND VPWR VPWR sky130_fd_sc_hd__decap_3
Xhold1346 _6528_/Q VGND VGND VPWR VPWR _5416_/A1 sky130_fd_sc_hd__dlygate4sd3_1
Xhold1357 _6934_/Q VGND VGND VPWR VPWR _5929_/A1 sky130_fd_sc_hd__dlygate4sd3_1
XFILLER_57_358 VGND VGND VPWR VPWR sky130_fd_sc_hd__decap_3
X_5047_ _6702_/Q _3068_/Y _5334_/S VGND VGND VPWR VPWR _5047_/X sky130_fd_sc_hd__mux2_1
XFILLER_22_1444 VGND VGND VPWR VPWR sky130_fd_sc_hd__decap_3
Xhold1368 _6508_/Q VGND VGND VPWR VPWR _5396_/A1 sky130_fd_sc_hd__dlygate4sd3_1
XFILLER_26_701 VGND VGND VPWR VPWR sky130_fd_sc_hd__decap_3
Xhold1379 _6910_/Q VGND VGND VPWR VPWR _5902_/A1 sky130_fd_sc_hd__dlygate4sd3_1
XFILLER_66_892 VGND VGND VPWR VPWR sky130_fd_sc_hd__decap_3
XFILLER_26_745 VGND VGND VPWR VPWR sky130_fd_sc_hd__decap_3
XFILLER_53_553 VGND VGND VPWR VPWR sky130_fd_sc_hd__fill_1
XFILLER_0_1251 VGND VGND VPWR VPWR sky130_fd_sc_hd__decap_3
XFILLER_20_1190 VGND VGND VPWR VPWR sky130_fd_sc_hd__fill_2
XFILLER_26_789 VGND VGND VPWR VPWR sky130_fd_sc_hd__decap_3
XFILLER_25_266 VGND VGND VPWR VPWR sky130_fd_sc_hd__fill_1
X_6998_ _7088_/CLK _6998_/D load_slew773/X VGND VGND VPWR VPWR _6998_/Q sky130_fd_sc_hd__dfrtp_2
XFILLER_0_1273 VGND VGND VPWR VPWR sky130_fd_sc_hd__decap_3
XFILLER_13_428 VGND VGND VPWR VPWR sky130_fd_sc_hd__decap_3
XFILLER_0_1295 VGND VGND VPWR VPWR sky130_fd_sc_hd__decap_3
XFILLER_55_1231 VGND VGND VPWR VPWR sky130_fd_sc_hd__fill_1
XFILLER_43_47 VGND VGND VPWR VPWR sky130_fd_sc_hd__decap_3
X_5949_ hold913/X hold916/X _6021_/S VGND VGND VPWR VPWR _6953_/D sky130_fd_sc_hd__mux2_1
XFILLER_55_1242 VGND VGND VPWR VPWR sky130_fd_sc_hd__decap_3
XFILLER_16_1226 VGND VGND VPWR VPWR sky130_fd_sc_hd__decap_3
XFILLER_55_1275 VGND VGND VPWR VPWR sky130_fd_sc_hd__decap_3
XFILLER_51_1117 VGND VGND VPWR VPWR sky130_fd_sc_hd__decap_3
XFILLER_22_984 VGND VGND VPWR VPWR sky130_fd_sc_hd__decap_3
XFILLER_16_1259 VGND VGND VPWR VPWR sky130_fd_sc_hd__fill_1
XFILLER_49_1002 VGND VGND VPWR VPWR sky130_fd_sc_hd__decap_3
XFILLER_4_137 VGND VGND VPWR VPWR sky130_fd_sc_hd__decap_3
XFILLER_4_159 VGND VGND VPWR VPWR sky130_fd_sc_hd__decap_3
XFILLER_49_1035 VGND VGND VPWR VPWR sky130_fd_sc_hd__fill_2
XTAP_TAPCELL_ROW_8_410 VGND VPWR sky130_fd_sc_hd__tapvpwrvgnd_1
XFILLER_1_800 VGND VGND VPWR VPWR sky130_fd_sc_hd__decap_3
XTAP_TAPCELL_ROW_8_421 VGND VPWR sky130_fd_sc_hd__tapvpwrvgnd_1
XFILLER_1_833 VGND VGND VPWR VPWR sky130_fd_sc_hd__decap_3
XFILLER_49_1079 VGND VGND VPWR VPWR sky130_fd_sc_hd__decap_3
XFILLER_0_321 VGND VGND VPWR VPWR sky130_fd_sc_hd__decap_3
XFILLER_1_844 VGND VGND VPWR VPWR sky130_fd_sc_hd__decap_3
XFILLER_27_1322 VGND VGND VPWR VPWR sky130_fd_sc_hd__decap_3
XFILLER_62_1202 VGND VGND VPWR VPWR sky130_fd_sc_hd__fill_2
XFILLER_66_1371 VGND VGND VPWR VPWR sky130_fd_sc_hd__fill_1
XFILLER_68_44 VGND VGND VPWR VPWR sky130_fd_sc_hd__decap_3
XFILLER_66_1382 VGND VGND VPWR VPWR sky130_fd_sc_hd__decap_3
XFILLER_0_343 VGND VGND VPWR VPWR sky130_fd_sc_hd__decap_3
XFILLER_7_1416 VGND VGND VPWR VPWR sky130_fd_sc_hd__decap_3
XFILLER_1_877 VGND VGND VPWR VPWR sky130_fd_sc_hd__decap_3
XFILLER_62_1235 VGND VGND VPWR VPWR sky130_fd_sc_hd__decap_3
XFILLER_76_612 VGND VGND VPWR VPWR sky130_fd_sc_hd__fill_1
XFILLER_0_365 VGND VGND VPWR VPWR sky130_fd_sc_hd__decap_3
XFILLER_27_1366 VGND VGND VPWR VPWR sky130_fd_sc_hd__decap_3
XFILLER_48_303 VGND VGND VPWR VPWR sky130_fd_sc_hd__decap_3
XFILLER_68_88 VGND VGND VPWR VPWR sky130_fd_sc_hd__fill_1
XFILLER_7_1449 VGND VGND VPWR VPWR sky130_fd_sc_hd__decap_3
XFILLER_62_1279 VGND VGND VPWR VPWR sky130_fd_sc_hd__decap_3
XFILLER_76_645 VGND VGND VPWR VPWR sky130_fd_sc_hd__decap_3
XFILLER_75_122 VGND VGND VPWR VPWR sky130_fd_sc_hd__fill_2
XFILLER_27_1399 VGND VGND VPWR VPWR sky130_fd_sc_hd__fill_1
XFILLER_5_1151 VGND VGND VPWR VPWR sky130_fd_sc_hd__decap_3
XFILLER_36_509 VGND VGND VPWR VPWR sky130_fd_sc_hd__decap_3
XFILLER_75_155 VGND VGND VPWR VPWR sky130_fd_sc_hd__fill_2
XTAP_TAPCELL_ROW_19_707 VGND VPWR sky130_fd_sc_hd__tapvpwrvgnd_1
XFILLER_29_550 VGND VGND VPWR VPWR sky130_fd_sc_hd__decap_3
XFILLER_57_870 VGND VGND VPWR VPWR sky130_fd_sc_hd__decap_3
XFILLER_1_1004 VGND VGND VPWR VPWR sky130_fd_sc_hd__decap_3
XFILLER_29_572 VGND VGND VPWR VPWR sky130_fd_sc_hd__fill_1
XFILLER_1_1015 VGND VGND VPWR VPWR sky130_fd_sc_hd__decap_3
XFILLER_5_1195 VGND VGND VPWR VPWR sky130_fd_sc_hd__decap_3
XFILLER_16_200 VGND VGND VPWR VPWR sky130_fd_sc_hd__fill_2
XFILLER_1_1048 VGND VGND VPWR VPWR sky130_fd_sc_hd__decap_3
XFILLER_16_222 VGND VGND VPWR VPWR sky130_fd_sc_hd__decap_3
XFILLER_44_531 VGND VGND VPWR VPWR sky130_fd_sc_hd__fill_1
XFILLER_72_851 VGND VGND VPWR VPWR sky130_fd_sc_hd__decap_3
XFILLER_17_767 VGND VGND VPWR VPWR sky130_fd_sc_hd__decap_3
XFILLER_56_1006 VGND VGND VPWR VPWR sky130_fd_sc_hd__decap_3
XFILLER_44_586 VGND VGND VPWR VPWR sky130_fd_sc_hd__fill_2
XFILLER_73_1331 VGND VGND VPWR VPWR sky130_fd_sc_hd__decap_3
XFILLER_31_225 VGND VGND VPWR VPWR sky130_fd_sc_hd__decap_3
XFILLER_38_1462 VGND VGND VPWR VPWR sky130_fd_sc_hd__decap_3
XTAP_TAPCELL_ROW_80_2277 VGND VPWR sky130_fd_sc_hd__tapvpwrvgnd_1
XTAP_TAPCELL_ROW_80_2288 VGND VPWR sky130_fd_sc_hd__tapvpwrvgnd_1
XFILLER_9_900 VGND VGND VPWR VPWR sky130_fd_sc_hd__decap_3
XFILLER_34_1315 VGND VGND VPWR VPWR sky130_fd_sc_hd__fill_1
XTAP_TAPCELL_ROW_80_2299 VGND VPWR sky130_fd_sc_hd__tapvpwrvgnd_1
XFILLER_13_962 VGND VGND VPWR VPWR sky130_fd_sc_hd__fill_1
XFILLER_73_1375 VGND VGND VPWR VPWR sky130_fd_sc_hd__decap_3
XFILLER_34_1326 VGND VGND VPWR VPWR sky130_fd_sc_hd__decap_3
XFILLER_8_410 VGND VGND VPWR VPWR sky130_fd_sc_hd__decap_3
XFILLER_8_421 VGND VGND VPWR VPWR sky130_fd_sc_hd__decap_3
XFILLER_34_1359 VGND VGND VPWR VPWR sky130_fd_sc_hd__decap_3
XFILLER_8_454 VGND VGND VPWR VPWR sky130_fd_sc_hd__decap_3
XFILLER_69_6 VGND VGND VPWR VPWR sky130_fd_sc_hd__decap_3
X_3300_ _6277_/Q _6381_/Q VGND VGND VPWR VPWR _3300_/X sky130_fd_sc_hd__xor2_2
XFILLER_4_682 VGND VGND VPWR VPWR sky130_fd_sc_hd__decap_3
X_4280_ _4280_/A _4280_/B VGND VGND VPWR VPWR _4282_/A sky130_fd_sc_hd__xnor2_2
XFILLER_45_1422 VGND VGND VPWR VPWR sky130_fd_sc_hd__decap_3
XFILLER_80_1313 VGND VGND VPWR VPWR sky130_fd_sc_hd__decap_3
XFILLER_3_192 VGND VGND VPWR VPWR sky130_fd_sc_hd__decap_3
X_3231_ hold880/X _3230_/X _3423_/S VGND VGND VPWR VPWR _6089_/D sky130_fd_sc_hd__mux2_1
XFILLER_80_1335 VGND VGND VPWR VPWR sky130_fd_sc_hd__decap_3
XFILLER_79_461 VGND VGND VPWR VPWR sky130_fd_sc_hd__decap_3
XFILLER_45_1455 VGND VGND VPWR VPWR sky130_fd_sc_hd__fill_1
XFILLER_45_1466 VGND VGND VPWR VPWR sky130_fd_sc_hd__decap_3
XFILLER_80_1357 VGND VGND VPWR VPWR sky130_fd_sc_hd__decap_3
XFILLER_39_314 VGND VGND VPWR VPWR sky130_fd_sc_hd__decap_3
XTAP_TAPCELL_ROW_33_1055 VGND VPWR sky130_fd_sc_hd__tapvpwrvgnd_1
XFILLER_41_1319 VGND VGND VPWR VPWR sky130_fd_sc_hd__decap_3
X_3162_ _6081_/A _6965_/Q _6973_/Q _6081_/B VGND VGND VPWR VPWR _3162_/X sky130_fd_sc_hd__a22o_2
XFILLER_80_1379 VGND VGND VPWR VPWR sky130_fd_sc_hd__decap_3
XTAP_TAPCELL_ROW_33_1066 VGND VPWR sky130_fd_sc_hd__tapvpwrvgnd_1
X_3093_ _3743_/B _3077_/B _3483_/A VGND VGND VPWR VPWR _7090_/D sky130_fd_sc_hd__o21ai_2
XFILLER_67_689 VGND VGND VPWR VPWR sky130_fd_sc_hd__decap_3
XFILLER_54_317 VGND VGND VPWR VPWR sky130_fd_sc_hd__fill_2
XFILLER_48_881 VGND VGND VPWR VPWR sky130_fd_sc_hd__fill_1
XFILLER_54_328 VGND VGND VPWR VPWR sky130_fd_sc_hd__decap_3
XFILLER_78_1220 VGND VGND VPWR VPWR sky130_fd_sc_hd__decap_3
X_6921_ _6929_/CLK _6921_/D load_slew707/X VGND VGND VPWR VPWR _6921_/Q sky130_fd_sc_hd__dfrtp_2
XFILLER_35_520 VGND VGND VPWR VPWR sky130_fd_sc_hd__decap_3
XFILLER_54_339 VGND VGND VPWR VPWR sky130_fd_sc_hd__fill_1
XFILLER_78_1253 VGND VGND VPWR VPWR sky130_fd_sc_hd__decap_3
XFILLER_78_1264 VGND VGND VPWR VPWR sky130_fd_sc_hd__decap_3
XFILLER_35_553 VGND VGND VPWR VPWR sky130_fd_sc_hd__decap_3
XTAP_TAPCELL_ROW_46_1405 VGND VPWR sky130_fd_sc_hd__tapvpwrvgnd_1
XFILLER_63_862 VGND VGND VPWR VPWR sky130_fd_sc_hd__fill_2
X_6852_ _7012_/CLK _6852_/D load_slew810/X VGND VGND VPWR VPWR _6852_/Q sky130_fd_sc_hd__dfrtp_2
XFILLER_35_564 VGND VGND VPWR VPWR sky130_fd_sc_hd__decap_3
XFILLER_74_1117 VGND VGND VPWR VPWR sky130_fd_sc_hd__decap_3
XFILLER_78_1297 VGND VGND VPWR VPWR sky130_fd_sc_hd__decap_3
XFILLER_39_1248 VGND VGND VPWR VPWR sky130_fd_sc_hd__decap_3
XFILLER_22_203 VGND VGND VPWR VPWR sky130_fd_sc_hd__decap_3
Xfanout18 _3856_/Y VGND VGND VPWR VPWR _4312_/B sky130_fd_sc_hd__clkdlybuf4s25_1
X_5803_ _6069_/S _5879_/A VGND VGND VPWR VPWR _5924_/B sky130_fd_sc_hd__or2_2
X_6783_ _6943_/CLK _6783_/D load_slew822/X VGND VGND VPWR VPWR _6783_/Q sky130_fd_sc_hd__dfrtp_2
X_3995_ _6229_/Q _4069_/A2 _3993_/X _3994_/X VGND VGND VPWR VPWR _6229_/D sky130_fd_sc_hd__o22a_2
XFILLER_52_1415 VGND VGND VPWR VPWR sky130_fd_sc_hd__decap_3
X_5734_ _5826_/A0 _5734_/A1 _5739_/S VGND VGND VPWR VPWR _6780_/D sky130_fd_sc_hd__mux2_1
XFILLER_13_39 VGND VGND VPWR VPWR sky130_fd_sc_hd__decap_3
XFILLER_52_1459 VGND VGND VPWR VPWR sky130_fd_sc_hd__decap_3
X_5665_ _5931_/A0 _5665_/A1 _5665_/S VGND VGND VPWR VPWR _6720_/D sky130_fd_sc_hd__mux2_1
XFILLER_15_1281 VGND VGND VPWR VPWR sky130_fd_sc_hd__decap_3
X_4616_ _4277_/B _6545_/Q _4658_/S VGND VGND VPWR VPWR _4616_/X sky130_fd_sc_hd__mux2_1
XFILLER_50_1161 VGND VGND VPWR VPWR sky130_fd_sc_hd__decap_3
XFILLER_15_1292 VGND VGND VPWR VPWR sky130_fd_sc_hd__decap_3
X_5596_ _5577_/A _3491_/X _5605_/A3 _5593_/Y _5596_/B2 VGND VGND VPWR VPWR _6668_/D
+ sky130_fd_sc_hd__a32o_2
X_4547_ _5514_/A _4547_/B VGND VGND VPWR VPWR _4547_/X sky130_fd_sc_hd__or2_2
XFILLER_11_1189 VGND VGND VPWR VPWR sky130_fd_sc_hd__decap_3
XFILLER_2_619 VGND VGND VPWR VPWR sky130_fd_sc_hd__decap_3
Xmax_cap162 _5626_/S VGND VGND VPWR VPWR _5627_/S sky130_fd_sc_hd__buf_8
X_4478_ _6856_/Q _4833_/A2 _4833_/B1 _4477_/X VGND VGND VPWR VPWR _4478_/X sky130_fd_sc_hd__a211o_2
X_6217_ _7039_/CLK _6217_/D load_slew829/X VGND VGND VPWR VPWR _6217_/Q sky130_fd_sc_hd__dfrtp_2
X_3429_ _6035_/A0 _3428_/X _3429_/S VGND VGND VPWR VPWR _6188_/D sky130_fd_sc_hd__mux2_1
XFILLER_58_623 VGND VGND VPWR VPWR sky130_fd_sc_hd__fill_1
XFILLER_58_634 VGND VGND VPWR VPWR sky130_fd_sc_hd__fill_1
X_6148_ _6999_/CLK _6148_/D wire827/X VGND VGND VPWR VPWR _6148_/Q sky130_fd_sc_hd__dfrtp_2
Xhold1110 _6151_/Q VGND VGND VPWR VPWR _5998_/A0 sky130_fd_sc_hd__dlygate4sd3_1
XFILLER_58_645 VGND VGND VPWR VPWR sky130_fd_sc_hd__decap_3
XPHY_EDGE_ROW_13_Left_94 VGND VGND VPWR VPWR sky130_fd_sc_hd__decap_3
Xhold1121 _6718_/Q VGND VGND VPWR VPWR _5663_/A1 sky130_fd_sc_hd__dlygate4sd3_1
XFILLER_57_122 VGND VGND VPWR VPWR sky130_fd_sc_hd__decap_3
Xhold1132 _6133_/Q VGND VGND VPWR VPWR _5980_/A0 sky130_fd_sc_hd__dlygate4sd3_1
XFILLER_57_133 VGND VGND VPWR VPWR sky130_fd_sc_hd__decap_3
Xhold1143 _6189_/Q VGND VGND VPWR VPWR _6036_/A0 sky130_fd_sc_hd__dlygate4sd3_1
Xhold1154 _6804_/Q VGND VGND VPWR VPWR _5761_/A1 sky130_fd_sc_hd__dlygate4sd3_1
XFILLER_22_1230 VGND VGND VPWR VPWR sky130_fd_sc_hd__decap_3
XFILLER_58_689 VGND VGND VPWR VPWR sky130_fd_sc_hd__decap_3
X_6079_ _6074_/Y _6081_/B VGND VGND VPWR VPWR _6079_/X sky130_fd_sc_hd__and2b_2
Xhold1165 _6721_/Q VGND VGND VPWR VPWR _5666_/A1 sky130_fd_sc_hd__dlygate4sd3_1
Xhold1176 _6107_/Q VGND VGND VPWR VPWR _5954_/A0 sky130_fd_sc_hd__dlygate4sd3_1
XFILLER_72_114 VGND VGND VPWR VPWR sky130_fd_sc_hd__decap_3
Xhold1187 _6186_/Q VGND VGND VPWR VPWR _6033_/A0 sky130_fd_sc_hd__dlygate4sd3_1
XFILLER_2_1335 VGND VGND VPWR VPWR sky130_fd_sc_hd__decap_3
Xhold1198 _6026_/X VGND VGND VPWR VPWR _7030_/D sky130_fd_sc_hd__dlygate4sd3_1
XFILLER_22_1285 VGND VGND VPWR VPWR sky130_fd_sc_hd__decap_3
XFILLER_72_147 VGND VGND VPWR VPWR sky130_fd_sc_hd__decap_3
XFILLER_2_1368 VGND VGND VPWR VPWR sky130_fd_sc_hd__decap_3
XFILLER_57_1304 VGND VGND VPWR VPWR sky130_fd_sc_hd__decap_3
XFILLER_2_1379 VGND VGND VPWR VPWR sky130_fd_sc_hd__decap_3
XFILLER_54_46 VGND VGND VPWR VPWR sky130_fd_sc_hd__decap_3
XFILLER_60_309 VGND VGND VPWR VPWR sky130_fd_sc_hd__decap_3
XFILLER_14_715 VGND VGND VPWR VPWR sky130_fd_sc_hd__decap_3
XTAP_TAPCELL_ROW_0_162 VGND VPWR sky130_fd_sc_hd__tapvpwrvgnd_1
XTAP_TAPCELL_ROW_0_173 VGND VPWR sky130_fd_sc_hd__tapvpwrvgnd_1
XFILLER_57_1337 VGND VGND VPWR VPWR sky130_fd_sc_hd__decap_3
XTAP_TAPCELL_ROW_0_184 VGND VPWR sky130_fd_sc_hd__tapvpwrvgnd_1
XFILLER_57_1348 VGND VGND VPWR VPWR sky130_fd_sc_hd__decap_3
XTAP_TAPCELL_ROW_0_195 VGND VPWR sky130_fd_sc_hd__tapvpwrvgnd_1
XFILLER_13_236 VGND VGND VPWR VPWR sky130_fd_sc_hd__fill_2
XFILLER_13_247 VGND VGND VPWR VPWR sky130_fd_sc_hd__fill_2
XFILLER_70_12 VGND VGND VPWR VPWR sky130_fd_sc_hd__decap_3
XFILLER_16_1023 VGND VGND VPWR VPWR sky130_fd_sc_hd__fill_1
XFILLER_10_976 VGND VGND VPWR VPWR sky130_fd_sc_hd__decap_3
XFILLER_5_402 VGND VGND VPWR VPWR sky130_fd_sc_hd__decap_3
XFILLER_33_1381 VGND VGND VPWR VPWR sky130_fd_sc_hd__decap_3
XFILLER_68_1400 VGND VGND VPWR VPWR sky130_fd_sc_hd__decap_3
XFILLER_79_21 VGND VGND VPWR VPWR sky130_fd_sc_hd__decap_3
XFILLER_68_1444 VGND VGND VPWR VPWR sky130_fd_sc_hd__decap_3
XFILLER_5_479 VGND VGND VPWR VPWR sky130_fd_sc_hd__decap_3
XFILLER_79_54 VGND VGND VPWR VPWR sky130_fd_sc_hd__fill_2
XFILLER_29_1428 VGND VGND VPWR VPWR sky130_fd_sc_hd__decap_3
XFILLER_79_87 VGND VGND VPWR VPWR sky130_fd_sc_hd__fill_2
XTAP_TAPCELL_ROW_73_2092 VGND VPWR sky130_fd_sc_hd__tapvpwrvgnd_1
XFILLER_7_1213 VGND VGND VPWR VPWR sky130_fd_sc_hd__decap_3
XFILLER_1_663 VGND VGND VPWR VPWR sky130_fd_sc_hd__decap_3
XFILLER_27_1141 VGND VGND VPWR VPWR sky130_fd_sc_hd__fill_1
XFILLER_49_601 VGND VGND VPWR VPWR sky130_fd_sc_hd__decap_3
XFILLER_77_921 VGND VGND VPWR VPWR sky130_fd_sc_hd__decap_3
XFILLER_0_162 VGND VGND VPWR VPWR sky130_fd_sc_hd__decap_3
XFILLER_1_685 VGND VGND VPWR VPWR sky130_fd_sc_hd__decap_3
XFILLER_62_1043 VGND VGND VPWR VPWR sky130_fd_sc_hd__fill_2
XFILLER_23_1005 VGND VGND VPWR VPWR sky130_fd_sc_hd__decap_3
XFILLER_48_100 VGND VGND VPWR VPWR sky130_fd_sc_hd__decap_3
XFILLER_7_1257 VGND VGND VPWR VPWR sky130_fd_sc_hd__decap_3
XFILLER_0_184 VGND VGND VPWR VPWR sky130_fd_sc_hd__decap_3
XFILLER_49_645 VGND VGND VPWR VPWR sky130_fd_sc_hd__fill_1
XFILLER_48_144 VGND VGND VPWR VPWR sky130_fd_sc_hd__decap_3
XFILLER_49_667 VGND VGND VPWR VPWR sky130_fd_sc_hd__decap_3
XFILLER_76_464 VGND VGND VPWR VPWR sky130_fd_sc_hd__decap_3
XFILLER_40_1341 VGND VGND VPWR VPWR sky130_fd_sc_hd__decap_3
XFILLER_48_177 VGND VGND VPWR VPWR sky130_fd_sc_hd__fill_2
XFILLER_29_380 VGND VGND VPWR VPWR sky130_fd_sc_hd__decap_3
XFILLER_17_531 VGND VGND VPWR VPWR sky130_fd_sc_hd__decap_3
XFILLER_29_391 VGND VGND VPWR VPWR sky130_fd_sc_hd__fill_1
XFILLER_40_1385 VGND VGND VPWR VPWR sky130_fd_sc_hd__decap_3
XFILLER_75_1404 VGND VGND VPWR VPWR sky130_fd_sc_hd__decap_3
XFILLER_17_564 VGND VGND VPWR VPWR sky130_fd_sc_hd__fill_1
XFILLER_45_873 VGND VGND VPWR VPWR sky130_fd_sc_hd__decap_3
XFILLER_32_501 VGND VGND VPWR VPWR sky130_fd_sc_hd__decap_3
XFILLER_60_810 VGND VGND VPWR VPWR sky130_fd_sc_hd__fill_2
XFILLER_75_1437 VGND VGND VPWR VPWR sky130_fd_sc_hd__decap_3
XFILLER_45_895 VGND VGND VPWR VPWR sky130_fd_sc_hd__fill_1
XFILLER_72_681 VGND VGND VPWR VPWR sky130_fd_sc_hd__decap_3
XFILLER_60_865 VGND VGND VPWR VPWR sky130_fd_sc_hd__decap_3
XFILLER_38_1270 VGND VGND VPWR VPWR sky130_fd_sc_hd__decap_3
XFILLER_73_1172 VGND VGND VPWR VPWR sky130_fd_sc_hd__decap_3
XFILLER_32_589 VGND VGND VPWR VPWR sky130_fd_sc_hd__decap_3
X_3780_ _4281_/A _4291_/B VGND VGND VPWR VPWR _3781_/B sky130_fd_sc_hd__xnor2_2
XFILLER_60_898 VGND VGND VPWR VPWR sky130_fd_sc_hd__decap_3
XFILLER_73_1183 VGND VGND VPWR VPWR sky130_fd_sc_hd__decap_3
XFILLER_34_1145 VGND VGND VPWR VPWR sky130_fd_sc_hd__decap_3
XFILLER_12_1421 VGND VGND VPWR VPWR sky130_fd_sc_hd__decap_3
X_5450_ _5450_/A1 _5453_/A2 _4025_/X VGND VGND VPWR VPWR _6562_/D sky130_fd_sc_hd__a21o_2
XFILLER_12_1432 VGND VGND VPWR VPWR sky130_fd_sc_hd__decap_3
XFILLER_69_1219 VGND VGND VPWR VPWR sky130_fd_sc_hd__decap_3
XFILLER_67_3 VGND VGND VPWR VPWR sky130_fd_sc_hd__decap_3
XFILLER_12_1465 VGND VGND VPWR VPWR sky130_fd_sc_hd__decap_3
XTAP_TAPCELL_ROW_10_470 VGND VPWR sky130_fd_sc_hd__tapvpwrvgnd_1
X_4401_ _6276_/Q _4664_/S _4398_/X _4400_/X VGND VGND VPWR VPWR _6276_/D sky130_fd_sc_hd__o22a_2
X_5381_ _5381_/A1 _5477_/A2 _4330_/X VGND VGND VPWR VPWR _6493_/D sky130_fd_sc_hd__a21o_2
XTAP_TAPCELL_ROW_39_1220 VGND VPWR sky130_fd_sc_hd__tapvpwrvgnd_1
XFILLER_5_51 VGND VGND VPWR VPWR sky130_fd_sc_hd__decap_3
X_4332_ _6831_/Q _4883_/A2 _4883_/B1 _4331_/X VGND VGND VPWR VPWR _4332_/X sky130_fd_sc_hd__a211o_2
XTAP_TAPCELL_ROW_35_1106 VGND VPWR sky130_fd_sc_hd__tapvpwrvgnd_1
XTAP_TAPCELL_ROW_35_1117 VGND VPWR sky130_fd_sc_hd__tapvpwrvgnd_1
XFILLER_5_95 VGND VGND VPWR VPWR sky130_fd_sc_hd__fill_1
Xfanout208 fanout216/X VGND VGND VPWR VPWR _6044_/S sky130_fd_sc_hd__clkdlybuf4s25_1
X_7051_ _7051_/CLK _7051_/D load_slew815/X VGND VGND VPWR VPWR _7051_/Q sky130_fd_sc_hd__dfrtp_2
X_4263_ _6825_/Q _4263_/A2 _4606_/B1 _4262_/X VGND VGND VPWR VPWR _4263_/X sky130_fd_sc_hd__a211o_2
XFILLER_45_1230 VGND VGND VPWR VPWR sky130_fd_sc_hd__fill_2
XFILLER_68_910 VGND VGND VPWR VPWR sky130_fd_sc_hd__decap_3
XFILLER_80_1121 VGND VGND VPWR VPWR sky130_fd_sc_hd__decap_3
X_6002_ _6002_/A0 _6002_/A1 _6058_/S VGND VGND VPWR VPWR _7006_/D sky130_fd_sc_hd__mux2_1
XFILLER_45_1263 VGND VGND VPWR VPWR sky130_fd_sc_hd__decap_3
X_3214_ _7017_/Q _7025_/Q _3222_/A VGND VGND VPWR VPWR _3214_/X sky130_fd_sc_hd__mux2_1
XFILLER_41_1105 VGND VGND VPWR VPWR sky130_fd_sc_hd__decap_3
X_4194_ _4338_/A _4610_/B _4191_/X _4787_/C1 VGND VGND VPWR VPWR _4194_/X sky130_fd_sc_hd__o2bb2a_2
XFILLER_39_133 VGND VGND VPWR VPWR sky130_fd_sc_hd__decap_3
XFILLER_68_965 VGND VGND VPWR VPWR sky130_fd_sc_hd__decap_3
XFILLER_80_1198 VGND VGND VPWR VPWR sky130_fd_sc_hd__decap_3
X_3145_ _3202_/A _3145_/B _3145_/C VGND VGND VPWR VPWR _3145_/X sky130_fd_sc_hd__and3_2
XFILLER_39_177 VGND VGND VPWR VPWR sky130_fd_sc_hd__decap_3
XFILLER_67_497 VGND VGND VPWR VPWR sky130_fd_sc_hd__decap_3
X_3076_ _6600_/Q _6602_/Q _6603_/Q _6601_/Q VGND VGND VPWR VPWR _3077_/B sky130_fd_sc_hd__and4bb_2
X_6904_ _7064_/CLK _6904_/D load_slew720/X VGND VGND VPWR VPWR _6904_/Q sky130_fd_sc_hd__dfrtp_2
XFILLER_70_618 VGND VGND VPWR VPWR sky130_fd_sc_hd__fill_1
XFILLER_42_309 VGND VGND VPWR VPWR sky130_fd_sc_hd__decap_3
XTAP_TAPCELL_ROW_69_1983 VGND VPWR sky130_fd_sc_hd__tapvpwrvgnd_1
XFILLER_23_501 VGND VGND VPWR VPWR sky130_fd_sc_hd__decap_3
XTAP_TAPCELL_ROW_69_1994 VGND VPWR sky130_fd_sc_hd__tapvpwrvgnd_1
XFILLER_63_681 VGND VGND VPWR VPWR sky130_fd_sc_hd__fill_2
XFILLER_23_523 VGND VGND VPWR VPWR sky130_fd_sc_hd__fill_2
XFILLER_35_383 VGND VGND VPWR VPWR sky130_fd_sc_hd__decap_3
XFILLER_51_832 VGND VGND VPWR VPWR sky130_fd_sc_hd__decap_3
XFILLER_63_692 VGND VGND VPWR VPWR sky130_fd_sc_hd__fill_1
XFILLER_1_1390 VGND VGND VPWR VPWR sky130_fd_sc_hd__decap_3
X_6835_ _7039_/CLK _6835_/D load_slew829/X VGND VGND VPWR VPWR _6835_/Q sky130_fd_sc_hd__dfrtp_2
XFILLER_17_1310 VGND VGND VPWR VPWR sky130_fd_sc_hd__decap_3
XFILLER_11_718 VGND VGND VPWR VPWR sky130_fd_sc_hd__decap_3
XFILLER_11_729 VGND VGND VPWR VPWR sky130_fd_sc_hd__decap_3
X_6766_ _7046_/CLK _6766_/D load_slew754/X VGND VGND VPWR VPWR _6766_/Q sky130_fd_sc_hd__dfrtp_2
XFILLER_23_589 VGND VGND VPWR VPWR sky130_fd_sc_hd__decap_3
XFILLER_17_1343 VGND VGND VPWR VPWR sky130_fd_sc_hd__fill_1
X_3978_ _5512_/A _4002_/A2 _4300_/B _3958_/Y _6531_/Q VGND VGND VPWR VPWR _3978_/X
+ sky130_fd_sc_hd__a32o_2
XFILLER_17_1354 VGND VGND VPWR VPWR sky130_fd_sc_hd__decap_3
XFILLER_52_1234 VGND VGND VPWR VPWR sky130_fd_sc_hd__decap_3
X_5717_ _5910_/A0 _5717_/A1 wire88/X VGND VGND VPWR VPWR _6765_/D sky130_fd_sc_hd__mux2_1
XTAP_TAPCELL_ROW_21_735 VGND VPWR sky130_fd_sc_hd__tapvpwrvgnd_1
XTAP_TAPCELL_ROW_21_746 VGND VPWR sky130_fd_sc_hd__tapvpwrvgnd_1
XFILLER_13_1218 VGND VGND VPWR VPWR sky130_fd_sc_hd__decap_3
XFILLER_17_1387 VGND VGND VPWR VPWR sky130_fd_sc_hd__decap_3
XTAP_TAPCELL_ROW_21_757 VGND VPWR sky130_fd_sc_hd__tapvpwrvgnd_1
X_6697_ _6819_/CLK _6697_/D fanout749/X VGND VGND VPWR VPWR _6697_/Q sky130_fd_sc_hd__dfrtp_2
XFILLER_52_1267 VGND VGND VPWR VPWR sky130_fd_sc_hd__decap_3
XFILLER_40_15 VGND VGND VPWR VPWR sky130_fd_sc_hd__decap_3
X_5648_ _5923_/A1 _5648_/A1 wire92/X VGND VGND VPWR VPWR _6705_/D sky130_fd_sc_hd__mux2_1
XFILLER_3_906 VGND VGND VPWR VPWR sky130_fd_sc_hd__decap_3
X_5579_ _5579_/A1 _5568_/Y _5578_/Y _5579_/B2 VGND VGND VPWR VPWR _6655_/D sky130_fd_sc_hd__a22o_2
XFILLER_2_416 VGND VGND VPWR VPWR sky130_fd_sc_hd__decap_3
XFILLER_78_707 VGND VGND VPWR VPWR sky130_fd_sc_hd__decap_3
XFILLER_49_46 VGND VGND VPWR VPWR sky130_fd_sc_hd__decap_3
XFILLER_49_57 VGND VGND VPWR VPWR sky130_fd_sc_hd__decap_3
XFILLER_28_1450 VGND VGND VPWR VPWR sky130_fd_sc_hd__decap_3
Xfanout731 wire734/A VGND VGND VPWR VPWR fanout731/X sky130_fd_sc_hd__clkdlybuf4s25_1
XFILLER_77_228 VGND VGND VPWR VPWR sky130_fd_sc_hd__fill_2
XFILLER_24_1303 VGND VGND VPWR VPWR sky130_fd_sc_hd__decap_3
XFILLER_59_932 VGND VGND VPWR VPWR sky130_fd_sc_hd__decap_3
Xfanout753 fanout755/X VGND VGND VPWR VPWR fanout753/X sky130_fd_sc_hd__clkdlybuf4s25_1
XFILLER_63_1363 VGND VGND VPWR VPWR sky130_fd_sc_hd__decap_3
XFILLER_24_1347 VGND VGND VPWR VPWR sky130_fd_sc_hd__decap_3
XFILLER_63_1396 VGND VGND VPWR VPWR sky130_fd_sc_hd__decap_3
Xfanout797 fanout803/X VGND VGND VPWR VPWR fanout797/X sky130_fd_sc_hd__clkdlybuf4s25_1
XFILLER_65_12 VGND VGND VPWR VPWR sky130_fd_sc_hd__decap_3
XFILLER_73_423 VGND VGND VPWR VPWR sky130_fd_sc_hd__decap_3
XFILLER_2_1132 VGND VGND VPWR VPWR sky130_fd_sc_hd__decap_3
XFILLER_74_979 VGND VGND VPWR VPWR sky130_fd_sc_hd__fill_1
XFILLER_22_1071 VGND VGND VPWR VPWR sky130_fd_sc_hd__decap_3
XFILLER_65_78 VGND VGND VPWR VPWR sky130_fd_sc_hd__decap_3
XFILLER_22_1093 VGND VGND VPWR VPWR sky130_fd_sc_hd__fill_1
XFILLER_45_169 VGND VGND VPWR VPWR sky130_fd_sc_hd__decap_3
XFILLER_2_1176 VGND VGND VPWR VPWR sky130_fd_sc_hd__decap_3
XFILLER_26_361 VGND VGND VPWR VPWR sky130_fd_sc_hd__decap_3
XFILLER_27_895 VGND VGND VPWR VPWR sky130_fd_sc_hd__fill_1
XFILLER_54_681 VGND VGND VPWR VPWR sky130_fd_sc_hd__decap_3
XFILLER_53_1009 VGND VGND VPWR VPWR sky130_fd_sc_hd__decap_3
XFILLER_14_567 VGND VGND VPWR VPWR sky130_fd_sc_hd__fill_1
XFILLER_35_1410 VGND VGND VPWR VPWR sky130_fd_sc_hd__decap_3
XFILLER_57_1189 VGND VGND VPWR VPWR sky130_fd_sc_hd__decap_3
XFILLER_42_887 VGND VGND VPWR VPWR sky130_fd_sc_hd__decap_3
XFILLER_70_1312 VGND VGND VPWR VPWR sky130_fd_sc_hd__decap_3
XFILLER_70_1323 VGND VGND VPWR VPWR sky130_fd_sc_hd__decap_3
XFILLER_35_1443 VGND VGND VPWR VPWR sky130_fd_sc_hd__decap_3
XFILLER_70_1356 VGND VGND VPWR VPWR sky130_fd_sc_hd__decap_3
XFILLER_31_1307 VGND VGND VPWR VPWR sky130_fd_sc_hd__decap_3
XFILLER_6_755 VGND VGND VPWR VPWR sky130_fd_sc_hd__fill_1
XTAP_TAPCELL_ROW_75_2143 VGND VPWR sky130_fd_sc_hd__tapvpwrvgnd_1
XTAP_TAPCELL_ROW_75_2154 VGND VPWR sky130_fd_sc_hd__tapvpwrvgnd_1
XFILLER_53_9 VGND VGND VPWR VPWR sky130_fd_sc_hd__decap_3
XFILLER_30_70 VGND VGND VPWR VPWR sky130_fd_sc_hd__decap_3
XFILLER_68_1241 VGND VGND VPWR VPWR sky130_fd_sc_hd__decap_3
XFILLER_5_276 VGND VGND VPWR VPWR sky130_fd_sc_hd__decap_3
XFILLER_29_1236 VGND VGND VPWR VPWR sky130_fd_sc_hd__decap_3
XFILLER_68_1285 VGND VGND VPWR VPWR sky130_fd_sc_hd__decap_3
XFILLER_9_1319 VGND VGND VPWR VPWR sky130_fd_sc_hd__decap_3
XFILLER_2_961 VGND VGND VPWR VPWR sky130_fd_sc_hd__decap_3
XFILLER_29_1269 VGND VGND VPWR VPWR sky130_fd_sc_hd__decap_3
XFILLER_69_729 VGND VGND VPWR VPWR sky130_fd_sc_hd__decap_3
XFILLER_68_217 VGND VGND VPWR VPWR sky130_fd_sc_hd__fill_1
XFILLER_42_1403 VGND VGND VPWR VPWR sky130_fd_sc_hd__decap_3
XFILLER_77_740 VGND VGND VPWR VPWR sky130_fd_sc_hd__decap_3
XFILLER_49_431 VGND VGND VPWR VPWR sky130_fd_sc_hd__fill_2
XFILLER_42_1447 VGND VGND VPWR VPWR sky130_fd_sc_hd__decap_3
XFILLER_39_90 VGND VGND VPWR VPWR sky130_fd_sc_hd__fill_2
XFILLER_49_464 VGND VGND VPWR VPWR sky130_fd_sc_hd__decap_3
Xinput8 ui_in[6] VGND VGND VPWR VPWR input8/X sky130_fd_sc_hd__clkdlybuf4s25_1
XFILLER_7_1098 VGND VGND VPWR VPWR sky130_fd_sc_hd__decap_3
XFILLER_36_136 VGND VGND VPWR VPWR sky130_fd_sc_hd__decap_3
XFILLER_64_445 VGND VGND VPWR VPWR sky130_fd_sc_hd__fill_2
XFILLER_80_905 VGND VGND VPWR VPWR sky130_fd_sc_hd__decap_3
XFILLER_40_1182 VGND VGND VPWR VPWR sky130_fd_sc_hd__decap_3
XFILLER_52_618 VGND VGND VPWR VPWR sky130_fd_sc_hd__fill_1
XFILLER_75_1201 VGND VGND VPWR VPWR sky130_fd_sc_hd__decap_3
X_4950_ _6350_/Q _4949_/X _4950_/S VGND VGND VPWR VPWR _6350_/D sky130_fd_sc_hd__mux2_1
XFILLER_79_1381 VGND VGND VPWR VPWR sky130_fd_sc_hd__decap_3
XFILLER_75_1245 VGND VGND VPWR VPWR sky130_fd_sc_hd__decap_3
X_3901_ _3927_/A_N _6309_/Q VGND VGND VPWR VPWR _3901_/X sky130_fd_sc_hd__and2b_2
XFILLER_32_320 VGND VGND VPWR VPWR sky130_fd_sc_hd__decap_3
X_4881_ _4881_/A _4881_/B _4881_/C VGND VGND VPWR VPWR _4881_/X sky130_fd_sc_hd__and3_2
XFILLER_75_1278 VGND VGND VPWR VPWR sky130_fd_sc_hd__decap_3
XFILLER_60_651 VGND VGND VPWR VPWR sky130_fd_sc_hd__decap_3
XFILLER_75_1289 VGND VGND VPWR VPWR sky130_fd_sc_hd__decap_3
X_6620_ _7012_/CLK _6620_/D load_slew801/X VGND VGND VPWR VPWR _6620_/Q sky130_fd_sc_hd__dfrtp_2
XFILLER_32_353 VGND VGND VPWR VPWR sky130_fd_sc_hd__decap_3
X_3832_ _3960_/A _6307_/Q VGND VGND VPWR VPWR _3832_/X sky130_fd_sc_hd__and2b_2
XFILLER_20_526 VGND VGND VPWR VPWR sky130_fd_sc_hd__decap_3
XTAP_TAPCELL_ROW_15_584 VGND VPWR sky130_fd_sc_hd__tapvpwrvgnd_1
XTAP_TAPCELL_ROW_15_595 VGND VPWR sky130_fd_sc_hd__tapvpwrvgnd_1
X_6551_ _6889_/CLK _6551_/D fanout713/X VGND VGND VPWR VPWR _6551_/Q sky130_fd_sc_hd__dfrtp_2
X_3763_ _3763_/A _3763_/B VGND VGND VPWR VPWR wire23/A sky130_fd_sc_hd__xnor2_2
XTAP_TAPCELL_ROW_60_1755 VGND VPWR sky130_fd_sc_hd__tapvpwrvgnd_1
XTAP_TAPCELL_ROW_60_1766 VGND VPWR sky130_fd_sc_hd__tapvpwrvgnd_1
Xtt_um_aes128_optimized_856 VGND VGND VPWR VPWR tt_um_aes128_optimized_856/HI uio_out[3]
+ sky130_fd_sc_hd__conb_1
X_5502_ _5506_/A _7086_/Q _5502_/C _5502_/D VGND VGND VPWR VPWR _5511_/B sky130_fd_sc_hd__and4bb_2
X_6482_ _6958_/CLK _6482_/D load_slew799/X VGND VGND VPWR VPWR _6482_/Q sky130_fd_sc_hd__dfrtp_2
X_3694_ _3692_/X _3693_/X _3635_/A VGND VGND VPWR VPWR _3697_/A sky130_fd_sc_hd__a21o_2
X_5433_ _5433_/A1 _5465_/A2 _4619_/X VGND VGND VPWR VPWR _6545_/D sky130_fd_sc_hd__a21o_2
XFILLER_12_1273 VGND VGND VPWR VPWR sky130_fd_sc_hd__decap_3
XFILLER_10_18 VGND VGND VPWR VPWR sky130_fd_sc_hd__decap_3
X_5364_ _5364_/A1 _5484_/A2 _4155_/X VGND VGND VPWR VPWR _6476_/D sky130_fd_sc_hd__a21o_2
XFILLER_47_1325 VGND VGND VPWR VPWR sky130_fd_sc_hd__decap_3
XFILLER_0_909 VGND VGND VPWR VPWR sky130_fd_sc_hd__decap_3
X_4315_ _4315_/A _4315_/B VGND VGND VPWR VPWR _4317_/A sky130_fd_sc_hd__xnor2_2
XFILLER_47_1369 VGND VGND VPWR VPWR sky130_fd_sc_hd__decap_3
X_5295_ _6440_/Q _5294_/X _5307_/S VGND VGND VPWR VPWR _6440_/D sky130_fd_sc_hd__mux2_1
XFILLER_59_228 VGND VGND VPWR VPWR sky130_fd_sc_hd__decap_3
X_7034_ _7034_/CLK _7034_/D fanout685/X VGND VGND VPWR VPWR _7034_/Q sky130_fd_sc_hd__dfrtp_2
X_4246_ _6823_/Q _4883_/A2 _4855_/B1 _4245_/X VGND VGND VPWR VPWR _4246_/X sky130_fd_sc_hd__a211o_2
X_4177_ _6816_/Q _4751_/A2 wire36/X _4176_/X VGND VGND VPWR VPWR _4177_/X sky130_fd_sc_hd__a211o_2
XFILLER_55_412 VGND VGND VPWR VPWR sky130_fd_sc_hd__decap_3
XFILLER_28_648 VGND VGND VPWR VPWR sky130_fd_sc_hd__decap_3
XTAP_TAPCELL_ROW_2_246 VGND VPWR sky130_fd_sc_hd__tapvpwrvgnd_1
X_3128_ _7043_/Q _7051_/Q _3149_/S VGND VGND VPWR VPWR _3128_/X sky130_fd_sc_hd__mux2_1
XTAP_TAPCELL_ROW_2_257 VGND VPWR sky130_fd_sc_hd__tapvpwrvgnd_1
XFILLER_3_1452 VGND VGND VPWR VPWR sky130_fd_sc_hd__decap_3
XFILLER_55_456 VGND VGND VPWR VPWR sky130_fd_sc_hd__decap_3
XFILLER_3_1463 VGND VGND VPWR VPWR sky130_fd_sc_hd__decap_3
XFILLER_55_467 VGND VGND VPWR VPWR sky130_fd_sc_hd__fill_2
XFILLER_27_169 VGND VGND VPWR VPWR sky130_fd_sc_hd__decap_3
XFILLER_71_938 VGND VGND VPWR VPWR sky130_fd_sc_hd__decap_3
X_3059_ _6355_/Q VGND VGND VPWR VPWR _3059_/Y sky130_fd_sc_hd__inv_2
XFILLER_58_1421 VGND VGND VPWR VPWR sky130_fd_sc_hd__decap_3
XFILLER_71_949 VGND VGND VPWR VPWR sky130_fd_sc_hd__decap_3
XFILLER_35_48 VGND VGND VPWR VPWR sky130_fd_sc_hd__decap_3
XFILLER_58_1432 VGND VGND VPWR VPWR sky130_fd_sc_hd__decap_3
XFILLER_24_821 VGND VGND VPWR VPWR sky130_fd_sc_hd__fill_1
XFILLER_19_1416 VGND VGND VPWR VPWR sky130_fd_sc_hd__decap_3
XFILLER_58_1465 VGND VGND VPWR VPWR sky130_fd_sc_hd__decap_3
XFILLER_19_1449 VGND VGND VPWR VPWR sky130_fd_sc_hd__decap_3
XFILLER_54_1329 VGND VGND VPWR VPWR sky130_fd_sc_hd__decap_3
X_6818_ _6882_/CLK _6818_/D fanout663/X VGND VGND VPWR VPWR _6818_/Q sky130_fd_sc_hd__dfrtp_2
XFILLER_7_508 VGND VGND VPWR VPWR sky130_fd_sc_hd__decap_3
X_6749_ _7076_/CLK _6749_/D load_slew681/X VGND VGND VPWR VPWR _6749_/Q sky130_fd_sc_hd__dfrtp_2
XFILLER_13_1037 VGND VGND VPWR VPWR sky130_fd_sc_hd__decap_3
XFILLER_3_703 VGND VGND VPWR VPWR sky130_fd_sc_hd__decap_3
XFILLER_30_1362 VGND VGND VPWR VPWR sky130_fd_sc_hd__decap_3
XFILLER_30_1373 VGND VGND VPWR VPWR sky130_fd_sc_hd__decap_3
XFILLER_2_224 VGND VGND VPWR VPWR sky130_fd_sc_hd__decap_3
XFILLER_65_1425 VGND VGND VPWR VPWR sky130_fd_sc_hd__decap_3
XFILLER_26_1409 VGND VGND VPWR VPWR sky130_fd_sc_hd__decap_3
XFILLER_2_279 VGND VGND VPWR VPWR sky130_fd_sc_hd__decap_3
XFILLER_8_1341 VGND VGND VPWR VPWR sky130_fd_sc_hd__decap_3
XFILLER_76_44 VGND VGND VPWR VPWR sky130_fd_sc_hd__decap_3
XFILLER_28_1291 VGND VGND VPWR VPWR sky130_fd_sc_hd__decap_3
Xfanout561 _3211_/S VGND VGND VPWR VPWR _3222_/A sky130_fd_sc_hd__clkdlybuf4s25_1
XFILLER_63_1171 VGND VGND VPWR VPWR sky130_fd_sc_hd__decap_3
XFILLER_4_1205 VGND VGND VPWR VPWR sky130_fd_sc_hd__decap_3
XFILLER_24_1133 VGND VGND VPWR VPWR sky130_fd_sc_hd__decap_3
Xfanout572 _5517_/B2 VGND VGND VPWR VPWR _3722_/A sky130_fd_sc_hd__clkdlybuf4s25_1
Xfanout583 _4355_/A VGND VGND VPWR VPWR _4665_/B sky130_fd_sc_hd__clkdlybuf4s25_1
XFILLER_47_913 VGND VGND VPWR VPWR sky130_fd_sc_hd__decap_3
XFILLER_59_773 VGND VGND VPWR VPWR sky130_fd_sc_hd__decap_3
XFILLER_8_1385 VGND VGND VPWR VPWR sky130_fd_sc_hd__decap_3
XFILLER_19_615 VGND VGND VPWR VPWR sky130_fd_sc_hd__fill_1
XFILLER_76_77 VGND VGND VPWR VPWR sky130_fd_sc_hd__fill_1
XFILLER_4_1238 VGND VGND VPWR VPWR sky130_fd_sc_hd__decap_3
XFILLER_74_732 VGND VGND VPWR VPWR sky130_fd_sc_hd__decap_3
XFILLER_62_905 VGND VGND VPWR VPWR sky130_fd_sc_hd__decap_3
XPHY_EDGE_ROW_38_Left_119 VGND VGND VPWR VPWR sky130_fd_sc_hd__decap_3
XFILLER_61_437 VGND VGND VPWR VPWR sky130_fd_sc_hd__decap_3
XFILLER_33_139 VGND VGND VPWR VPWR sky130_fd_sc_hd__decap_3
XFILLER_72_1418 VGND VGND VPWR VPWR sky130_fd_sc_hd__decap_3
XFILLER_42_651 VGND VGND VPWR VPWR sky130_fd_sc_hd__decap_3
XFILLER_30_802 VGND VGND VPWR VPWR sky130_fd_sc_hd__fill_2
XFILLER_72_1429 VGND VGND VPWR VPWR sky130_fd_sc_hd__decap_3
XTAP_TAPCELL_ROW_25_860 VGND VPWR sky130_fd_sc_hd__tapvpwrvgnd_1
XFILLER_42_673 VGND VGND VPWR VPWR sky130_fd_sc_hd__decap_3
XFILLER_14_386 VGND VGND VPWR VPWR sky130_fd_sc_hd__decap_3
XTAP_TAPCELL_ROW_12_510 VGND VPWR sky130_fd_sc_hd__tapvpwrvgnd_1
XFILLER_30_846 VGND VGND VPWR VPWR sky130_fd_sc_hd__decap_3
XTAP_TAPCELL_ROW_12_521 VGND VPWR sky130_fd_sc_hd__tapvpwrvgnd_1
XFILLER_35_1251 VGND VGND VPWR VPWR sky130_fd_sc_hd__decap_3
XTAP_TAPCELL_ROW_77_2205 VGND VPWR sky130_fd_sc_hd__tapvpwrvgnd_1
XFILLER_70_1164 VGND VGND VPWR VPWR sky130_fd_sc_hd__decap_3
XFILLER_35_1284 VGND VGND VPWR VPWR sky130_fd_sc_hd__decap_3
XFILLER_35_1295 VGND VGND VPWR VPWR sky130_fd_sc_hd__decap_3
XFILLER_70_1197 VGND VGND VPWR VPWR sky130_fd_sc_hd__decap_3
XFILLER_10_592 VGND VGND VPWR VPWR sky130_fd_sc_hd__decap_3
Xclkbuf_4_5__f_clk clkbuf_3_2_0_clk/X VGND VGND VPWR VPWR clkload2/A sky130_fd_sc_hd__clkbuf_16
XFILLER_6_574 VGND VGND VPWR VPWR sky130_fd_sc_hd__decap_3
XFILLER_51_6 VGND VGND VPWR VPWR sky130_fd_sc_hd__decap_3
XPHY_EDGE_ROW_47_Left_128 VGND VGND VPWR VPWR sky130_fd_sc_hd__decap_3
XFILLER_68_1093 VGND VGND VPWR VPWR sky130_fd_sc_hd__decap_3
XFILLER_9_1127 VGND VGND VPWR VPWR sky130_fd_sc_hd__decap_3
X_4100_ _5512_/A _4768_/A _4344_/B _5515_/A1 _6599_/Q VGND VGND VPWR VPWR _4100_/X
+ sky130_fd_sc_hd__a32o_2
XFILLER_2_791 VGND VGND VPWR VPWR sky130_fd_sc_hd__decap_3
X_5080_ _6433_/Q _5080_/B VGND VGND VPWR VPWR _5273_/B sky130_fd_sc_hd__xnor2_2
XFILLER_1_290 VGND VGND VPWR VPWR sky130_fd_sc_hd__decap_3
XTAP_TAPCELL_ROW_53_1570 VGND VPWR sky130_fd_sc_hd__tapvpwrvgnd_1
XFILLER_2_41 VGND VGND VPWR VPWR sky130_fd_sc_hd__decap_3
XFILLER_46_1391 VGND VGND VPWR VPWR sky130_fd_sc_hd__decap_3
XTAP_TAPCELL_ROW_53_1581 VGND VPWR sky130_fd_sc_hd__tapvpwrvgnd_1
X_4031_ _4049_/A1 _4028_/X _4029_/Y _4030_/X _4013_/A VGND VGND VPWR VPWR _4031_/X
+ sky130_fd_sc_hd__o221a_2
XFILLER_42_1255 VGND VGND VPWR VPWR sky130_fd_sc_hd__decap_3
XFILLER_2_74 VGND VGND VPWR VPWR sky130_fd_sc_hd__decap_3
XFILLER_2_85 VGND VGND VPWR VPWR sky130_fd_sc_hd__decap_3
XFILLER_65_732 VGND VGND VPWR VPWR sky130_fd_sc_hd__decap_3
XFILLER_42_1288 VGND VGND VPWR VPWR sky130_fd_sc_hd__decap_3
XFILLER_77_1307 VGND VGND VPWR VPWR sky130_fd_sc_hd__decap_3
XFILLER_37_445 VGND VGND VPWR VPWR sky130_fd_sc_hd__decap_3
XFILLER_37_467 VGND VGND VPWR VPWR sky130_fd_sc_hd__decap_3
XFILLER_65_776 VGND VGND VPWR VPWR sky130_fd_sc_hd__decap_3
XPHY_EDGE_ROW_56_Left_137 VGND VGND VPWR VPWR sky130_fd_sc_hd__decap_3
XFILLER_64_253 VGND VGND VPWR VPWR sky130_fd_sc_hd__fill_1
XFILLER_80_713 VGND VGND VPWR VPWR sky130_fd_sc_hd__decap_3
X_5982_ _5982_/A0 _5982_/A1 _6046_/S VGND VGND VPWR VPWR _6986_/D sky130_fd_sc_hd__mux2_1
XTAP_TAPCELL_ROW_66_1920 VGND VPWR sky130_fd_sc_hd__tapvpwrvgnd_1
XFILLER_80_735 VGND VGND VPWR VPWR sky130_fd_sc_hd__decap_3
XFILLER_80_757 VGND VGND VPWR VPWR sky130_fd_sc_hd__decap_3
X_4933_ _6380_/Q _5210_/B _5107_/A VGND VGND VPWR VPWR _4933_/Y sky130_fd_sc_hd__a21oi_2
XTAP_TAPCELL_ROW_62_1806 VGND VPWR sky130_fd_sc_hd__tapvpwrvgnd_1
XFILLER_36_1004 VGND VGND VPWR VPWR sky130_fd_sc_hd__decap_3
XTAP_TAPCELL_ROW_23_808 VGND VPWR sky130_fd_sc_hd__tapvpwrvgnd_1
XTAP_TAPCELL_ROW_62_1817 VGND VPWR sky130_fd_sc_hd__tapvpwrvgnd_1
XFILLER_75_1075 VGND VGND VPWR VPWR sky130_fd_sc_hd__decap_3
XFILLER_33_673 VGND VGND VPWR VPWR sky130_fd_sc_hd__decap_3
X_4864_ _4428_/A _4608_/B _4300_/X _4842_/X _6587_/Q VGND VGND VPWR VPWR _4864_/X
+ sky130_fd_sc_hd__a32o_2
XFILLER_36_1037 VGND VGND VPWR VPWR sky130_fd_sc_hd__decap_3
XANTENNA_13 _3202_/A VGND VGND VPWR VPWR sky130_fd_sc_hd__diode_2
XFILLER_53_1340 VGND VGND VPWR VPWR sky130_fd_sc_hd__decap_3
X_6603_ _6617_/CLK _6603_/D fanout724/X VGND VGND VPWR VPWR _6603_/Q sky130_fd_sc_hd__dfrtp_2
XFILLER_20_334 VGND VGND VPWR VPWR sky130_fd_sc_hd__decap_3
XANTENNA_24 _5813_/S VGND VGND VPWR VPWR sky130_fd_sc_hd__diode_2
XFILLER_32_194 VGND VGND VPWR VPWR sky130_fd_sc_hd__fill_2
X_3815_ _6498_/Q _4330_/A2 _4734_/C1 _3814_/Y VGND VGND VPWR VPWR _3815_/X sky130_fd_sc_hd__o211a_2
XANTENNA_35 input9/X VGND VGND VPWR VPWR sky130_fd_sc_hd__diode_2
XFILLER_53_1351 VGND VGND VPWR VPWR sky130_fd_sc_hd__decap_3
X_4795_ _4879_/B _4617_/B _4794_/Y _4793_/A VGND VGND VPWR VPWR _4796_/C sky130_fd_sc_hd__o211a_2
XANTENNA_46 _5739_/S VGND VGND VPWR VPWR sky130_fd_sc_hd__diode_2
XANTENNA_57 _5601_/B1 VGND VGND VPWR VPWR sky130_fd_sc_hd__diode_2
XFILLER_14_1335 VGND VGND VPWR VPWR sky130_fd_sc_hd__decap_3
XFILLER_53_1384 VGND VGND VPWR VPWR sky130_fd_sc_hd__decap_3
XANTENNA_68 wire331/X VGND VGND VPWR VPWR sky130_fd_sc_hd__diode_2
X_6534_ _7090_/CLK _6534_/D load_slew723/X VGND VGND VPWR VPWR _6534_/Q sky130_fd_sc_hd__dfrtp_2
XANTENNA_79 fanout848/X VGND VGND VPWR VPWR sky130_fd_sc_hd__diode_2
X_3746_ _3678_/Y _3683_/Y _3687_/Y _3614_/X _3613_/Y VGND VGND VPWR VPWR _3882_/B
+ sky130_fd_sc_hd__o2111a_2
XFILLER_14_1368 VGND VGND VPWR VPWR sky130_fd_sc_hd__decap_3
XFILLER_14_1379 VGND VGND VPWR VPWR sky130_fd_sc_hd__decap_3
XPHY_EDGE_ROW_65_Left_146 VGND VGND VPWR VPWR sky130_fd_sc_hd__decap_3
X_6465_ _6807_/CLK _6465_/D fanout785/X VGND VGND VPWR VPWR _6465_/Q sky130_fd_sc_hd__dfrtp_2
X_3677_ _3648_/X _3693_/A wire26/X _3687_/B VGND VGND VPWR VPWR _3786_/B sky130_fd_sc_hd__a211o_2
X_5416_ _5416_/A1 _5480_/A2 _3963_/X VGND VGND VPWR VPWR _6528_/D sky130_fd_sc_hd__a21o_2
X_6396_ _7046_/CLK _6396_/D load_slew754/X VGND VGND VPWR VPWR _6396_/Q sky130_fd_sc_hd__dfrtp_2
X_5347_ _6466_/Q _5346_/X _5353_/S VGND VGND VPWR VPWR _6466_/D sky130_fd_sc_hd__mux2_1
XFILLER_47_1177 VGND VGND VPWR VPWR sky130_fd_sc_hd__decap_3
XFILLER_43_1019 VGND VGND VPWR VPWR sky130_fd_sc_hd__decap_3
X_5278_ _6434_/Q _5278_/A2 _5277_/X VGND VGND VPWR VPWR _6434_/D sky130_fd_sc_hd__a21o_2
XFILLER_60_1300 VGND VGND VPWR VPWR sky130_fd_sc_hd__decap_3
XFILLER_25_1431 VGND VGND VPWR VPWR sky130_fd_sc_hd__decap_3
X_7017_ _7025_/CLK _7017_/D wire764/X VGND VGND VPWR VPWR _7017_/Q sky130_fd_sc_hd__dfrtp_2
X_4229_ _4312_/B _6484_/Q _4257_/S VGND VGND VPWR VPWR _4229_/X sky130_fd_sc_hd__mux2_1
XFILLER_75_529 VGND VGND VPWR VPWR sky130_fd_sc_hd__decap_3
XFILLER_60_1344 VGND VGND VPWR VPWR sky130_fd_sc_hd__decap_3
XFILLER_28_412 VGND VGND VPWR VPWR sky130_fd_sc_hd__decap_3
XPHY_EDGE_ROW_74_Left_155 VGND VGND VPWR VPWR sky130_fd_sc_hd__decap_3
XFILLER_21_1328 VGND VGND VPWR VPWR sky130_fd_sc_hd__decap_3
XFILLER_55_231 VGND VGND VPWR VPWR sky130_fd_sc_hd__fill_2
XFILLER_60_1388 VGND VGND VPWR VPWR sky130_fd_sc_hd__decap_3
XFILLER_56_765 VGND VGND VPWR VPWR sky130_fd_sc_hd__decap_3
XFILLER_16_607 VGND VGND VPWR VPWR sky130_fd_sc_hd__decap_3
XFILLER_46_58 VGND VGND VPWR VPWR sky130_fd_sc_hd__decap_3
XFILLER_3_1260 VGND VGND VPWR VPWR sky130_fd_sc_hd__decap_3
XFILLER_43_404 VGND VGND VPWR VPWR sky130_fd_sc_hd__decap_3
XFILLER_71_735 VGND VGND VPWR VPWR sky130_fd_sc_hd__fill_1
XFILLER_43_426 VGND VGND VPWR VPWR sky130_fd_sc_hd__decap_3
XFILLER_58_1240 VGND VGND VPWR VPWR sky130_fd_sc_hd__decap_3
XFILLER_71_768 VGND VGND VPWR VPWR sky130_fd_sc_hd__decap_3
XFILLER_58_1273 VGND VGND VPWR VPWR sky130_fd_sc_hd__decap_3
XFILLER_70_256 VGND VGND VPWR VPWR sky130_fd_sc_hd__decap_3
XFILLER_12_813 VGND VGND VPWR VPWR sky130_fd_sc_hd__decap_3
XFILLER_12_824 VGND VGND VPWR VPWR sky130_fd_sc_hd__decap_3
XFILLER_19_1257 VGND VGND VPWR VPWR sky130_fd_sc_hd__decap_3
XFILLER_23_172 VGND VGND VPWR VPWR sky130_fd_sc_hd__fill_2
XFILLER_51_481 VGND VGND VPWR VPWR sky130_fd_sc_hd__fill_1
XFILLER_11_323 VGND VGND VPWR VPWR sky130_fd_sc_hd__decap_3
XFILLER_71_1440 VGND VGND VPWR VPWR sky130_fd_sc_hd__decap_3
XFILLER_12_857 VGND VGND VPWR VPWR sky130_fd_sc_hd__decap_3
XFILLER_12_879 VGND VGND VPWR VPWR sky130_fd_sc_hd__decap_3
XFILLER_11_367 VGND VGND VPWR VPWR sky130_fd_sc_hd__decap_3
XFILLER_8_839 VGND VGND VPWR VPWR sky130_fd_sc_hd__decap_3
XFILLER_32_1424 VGND VGND VPWR VPWR sky130_fd_sc_hd__decap_3
XFILLER_32_1435 VGND VGND VPWR VPWR sky130_fd_sc_hd__decap_3
Xwire269 _4431_/B VGND VGND VPWR VPWR _4534_/B sky130_fd_sc_hd__clkbuf_4
XFILLER_32_1468 VGND VGND VPWR VPWR sky130_fd_sc_hd__fill_1
XFILLER_11_94 VGND VGND VPWR VPWR sky130_fd_sc_hd__decap_3
XFILLER_65_1222 VGND VGND VPWR VPWR sky130_fd_sc_hd__decap_3
XFILLER_65_1233 VGND VGND VPWR VPWR sky130_fd_sc_hd__decap_3
Xload_slew219 _5970_/S VGND VGND VPWR VPWR _6021_/S sky130_fd_sc_hd__buf_4
XFILLER_65_1266 VGND VGND VPWR VPWR sky130_fd_sc_hd__decap_3
XFILLER_78_334 VGND VGND VPWR VPWR sky130_fd_sc_hd__fill_2
XFILLER_61_1119 VGND VGND VPWR VPWR sky130_fd_sc_hd__fill_1
XTAP_TAPCELL_ROW_6_360 VGND VPWR sky130_fd_sc_hd__tapvpwrvgnd_1
XFILLER_4_1002 VGND VGND VPWR VPWR sky130_fd_sc_hd__decap_3
XFILLER_8_1182 VGND VGND VPWR VPWR sky130_fd_sc_hd__decap_3
XFILLER_59_570 VGND VGND VPWR VPWR sky130_fd_sc_hd__decap_3
Xclkbuf_4_13__f_clk clkbuf_3_6_0_clk/X VGND VGND VPWR VPWR clkload6/A sky130_fd_sc_hd__clkbuf_16
XFILLER_16_9 VGND VGND VPWR VPWR sky130_fd_sc_hd__fill_2
XFILLER_47_732 VGND VGND VPWR VPWR sky130_fd_sc_hd__decap_3
XFILLER_4_1046 VGND VGND VPWR VPWR sky130_fd_sc_hd__decap_3
XFILLER_35_905 VGND VGND VPWR VPWR sky130_fd_sc_hd__decap_3
XFILLER_74_551 VGND VGND VPWR VPWR sky130_fd_sc_hd__decap_3
XFILLER_4_1079 VGND VGND VPWR VPWR sky130_fd_sc_hd__decap_3
XFILLER_46_253 VGND VGND VPWR VPWR sky130_fd_sc_hd__decap_3
XFILLER_34_404 VGND VGND VPWR VPWR sky130_fd_sc_hd__decap_3
XFILLER_19_489 VGND VGND VPWR VPWR sky130_fd_sc_hd__decap_3
XFILLER_62_724 VGND VGND VPWR VPWR sky130_fd_sc_hd__decap_3
XFILLER_74_584 VGND VGND VPWR VPWR sky130_fd_sc_hd__decap_3
XFILLER_35_949 VGND VGND VPWR VPWR sky130_fd_sc_hd__decap_3
XFILLER_61_201 VGND VGND VPWR VPWR sky130_fd_sc_hd__fill_1
XFILLER_74_595 VGND VGND VPWR VPWR sky130_fd_sc_hd__decap_3
XFILLER_59_1059 VGND VGND VPWR VPWR sky130_fd_sc_hd__decap_3
XFILLER_61_223 VGND VGND VPWR VPWR sky130_fd_sc_hd__fill_1
XPHY_EDGE_ROW_1_Left_82 VGND VGND VPWR VPWR sky130_fd_sc_hd__decap_3
XTAP_TAPCELL_ROW_17_635 VGND VPWR sky130_fd_sc_hd__tapvpwrvgnd_1
XFILLER_34_448 VGND VGND VPWR VPWR sky130_fd_sc_hd__decap_3
XFILLER_62_757 VGND VGND VPWR VPWR sky130_fd_sc_hd__fill_1
XTAP_TAPCELL_ROW_17_646 VGND VPWR sky130_fd_sc_hd__tapvpwrvgnd_1
XFILLER_50_908 VGND VGND VPWR VPWR sky130_fd_sc_hd__decap_3
XFILLER_76_1362 VGND VGND VPWR VPWR sky130_fd_sc_hd__decap_3
XFILLER_37_1313 VGND VGND VPWR VPWR sky130_fd_sc_hd__decap_3
XFILLER_76_1373 VGND VGND VPWR VPWR sky130_fd_sc_hd__decap_3
XFILLER_15_662 VGND VGND VPWR VPWR sky130_fd_sc_hd__fill_1
XFILLER_43_971 VGND VGND VPWR VPWR sky130_fd_sc_hd__decap_3
XFILLER_21_109 VGND VGND VPWR VPWR sky130_fd_sc_hd__decap_3
XFILLER_72_1226 VGND VGND VPWR VPWR sky130_fd_sc_hd__decap_3
XFILLER_14_150 VGND VGND VPWR VPWR sky130_fd_sc_hd__decap_3
XFILLER_43_993 VGND VGND VPWR VPWR sky130_fd_sc_hd__fill_1
XFILLER_30_621 VGND VGND VPWR VPWR sky130_fd_sc_hd__decap_3
XFILLER_37_1357 VGND VGND VPWR VPWR sky130_fd_sc_hd__decap_3
XFILLER_72_1259 VGND VGND VPWR VPWR sky130_fd_sc_hd__fill_1
XFILLER_30_643 VGND VGND VPWR VPWR sky130_fd_sc_hd__fill_1
XFILLER_30_654 VGND VGND VPWR VPWR sky130_fd_sc_hd__fill_1
X_3600_ _4723_/B _3598_/X _3599_/X VGND VGND VPWR VPWR _3600_/X sky130_fd_sc_hd__a21o_2
Xinput11 uio_in[1] VGND VGND VPWR VPWR _7092_/D sky130_fd_sc_hd__clkdlybuf4s25_1
XTAP_TAPCELL_ROW_42_1282 VGND VPWR sky130_fd_sc_hd__tapvpwrvgnd_1
X_4580_ _6540_/Q _4580_/B VGND VGND VPWR VPWR _4580_/Y sky130_fd_sc_hd__nand2_2
XTAP_TAPCELL_ROW_42_1293 VGND VPWR sky130_fd_sc_hd__tapvpwrvgnd_1
XFILLER_7_850 VGND VGND VPWR VPWR sky130_fd_sc_hd__decap_3
X_3531_ _6222_/Q _5591_/A2 _5606_/A2 _6262_/Q _4532_/B VGND VGND VPWR VPWR _3532_/B
+ sky130_fd_sc_hd__a221o_2
XFILLER_13_1390 VGND VGND VPWR VPWR sky130_fd_sc_hd__decap_3
X_6250_ _6943_/CLK _6250_/D fanout823/X VGND VGND VPWR VPWR _6250_/Q sky130_fd_sc_hd__dfrtp_2
X_3462_ _6342_/Q _6462_/Q VGND VGND VPWR VPWR _3462_/X sky130_fd_sc_hd__xor2_2
XTAP_TAPCELL_ROW_55_1621 VGND VPWR sky130_fd_sc_hd__tapvpwrvgnd_1
X_5201_ _5298_/S _5201_/B VGND VGND VPWR VPWR _5201_/Y sky130_fd_sc_hd__nand2_2
XTAP_TAPCELL_ROW_55_1632 VGND VPWR sky130_fd_sc_hd__tapvpwrvgnd_1
X_6181_ _7032_/CLK _6181_/D load_slew720/X VGND VGND VPWR VPWR _6181_/Q sky130_fd_sc_hd__dfrtp_2
XFILLER_48_1453 VGND VGND VPWR VPWR sky130_fd_sc_hd__decap_3
XTAP_TAPCELL_ROW_55_1643 VGND VPWR sky130_fd_sc_hd__tapvpwrvgnd_1
X_3393_ _6017_/A0 _3392_/X _3435_/S VGND VGND VPWR VPWR _6170_/D sky130_fd_sc_hd__mux2_1
XFILLER_69_301 VGND VGND VPWR VPWR sky130_fd_sc_hd__decap_3
XFILLER_44_1306 VGND VGND VPWR VPWR sky130_fd_sc_hd__decap_3
Xload_slew720 fanout719/X VGND VGND VPWR VPWR load_slew720/X sky130_fd_sc_hd__buf_2
XFILLER_44_1317 VGND VGND VPWR VPWR sky130_fd_sc_hd__decap_3
X_5132_ _6375_/Q _5131_/X _5107_/A _6713_/Q VGND VGND VPWR VPWR _5132_/X sky130_fd_sc_hd__a2bb2o_2
XTAP_TAPCELL_ROW_51_1518 VGND VPWR sky130_fd_sc_hd__tapvpwrvgnd_1
XTAP_TAPCELL_ROW_4_308 VGND VPWR sky130_fd_sc_hd__tapvpwrvgnd_1
Xload_slew742 fanout741/X VGND VGND VPWR VPWR load_slew742/X sky130_fd_sc_hd__buf_4
XTAP_TAPCELL_ROW_51_1529 VGND VPWR sky130_fd_sc_hd__tapvpwrvgnd_1
Xhold1506 _6501_/Q VGND VGND VPWR VPWR _5389_/A1 sky130_fd_sc_hd__dlygate4sd3_1
Xload_slew775 fanout774/X VGND VGND VPWR VPWR load_slew775/X sky130_fd_sc_hd__buf_2
Xhold1517 _6512_/Q VGND VGND VPWR VPWR _5400_/A1 sky130_fd_sc_hd__dlygate4sd3_1
Xload_slew786 fanout785/X VGND VGND VPWR VPWR load_slew786/X sky130_fd_sc_hd__buf_4
X_5063_ _6463_/Q _6681_/Q VGND VGND VPWR VPWR _5064_/B sky130_fd_sc_hd__xor2_2
XFILLER_42_1030 VGND VGND VPWR VPWR sky130_fd_sc_hd__decap_3
XFILLER_69_389 VGND VGND VPWR VPWR sky130_fd_sc_hd__decap_3
Xhold1528 _6556_/Q VGND VGND VPWR VPWR _5444_/A1 sky130_fd_sc_hd__dlygate4sd3_1
Xhold1539 _6677_/Q VGND VGND VPWR VPWR _5606_/B2 sky130_fd_sc_hd__dlygate4sd3_1
X_4014_ _3402_/X _4080_/A2 _4080_/B1 _6898_/Q _4080_/C1 VGND VGND VPWR VPWR _4014_/X
+ sky130_fd_sc_hd__a221o_2
XFILLER_37_231 VGND VGND VPWR VPWR sky130_fd_sc_hd__decap_3
XFILLER_77_1104 VGND VGND VPWR VPWR sky130_fd_sc_hd__decap_3
XFILLER_38_776 VGND VGND VPWR VPWR sky130_fd_sc_hd__decap_3
XFILLER_53_702 VGND VGND VPWR VPWR sky130_fd_sc_hd__decap_3
XFILLER_20_1350 VGND VGND VPWR VPWR sky130_fd_sc_hd__decap_3
XFILLER_0_1422 VGND VGND VPWR VPWR sky130_fd_sc_hd__decap_3
XFILLER_53_735 VGND VGND VPWR VPWR sky130_fd_sc_hd__decap_3
XFILLER_65_595 VGND VGND VPWR VPWR sky130_fd_sc_hd__decap_3
XFILLER_77_1148 VGND VGND VPWR VPWR sky130_fd_sc_hd__decap_3
XFILLER_0_1444 VGND VGND VPWR VPWR sky130_fd_sc_hd__decap_3
XTAP_TAPCELL_ROW_49_1469 VGND VPWR sky130_fd_sc_hd__tapvpwrvgnd_1
XFILLER_0_1466 VGND VGND VPWR VPWR sky130_fd_sc_hd__decap_3
XFILLER_20_1394 VGND VGND VPWR VPWR sky130_fd_sc_hd__decap_3
XFILLER_34_960 VGND VGND VPWR VPWR sky130_fd_sc_hd__decap_3
X_5965_ hold862/X _6969_/Q _6021_/S VGND VGND VPWR VPWR _5965_/X sky130_fd_sc_hd__mux2_1
XFILLER_55_1413 VGND VGND VPWR VPWR sky130_fd_sc_hd__decap_3
XFILLER_80_598 VGND VGND VPWR VPWR sky130_fd_sc_hd__decap_3
X_4916_ _6442_/Q _6660_/Q VGND VGND VPWR VPWR _4917_/B sky130_fd_sc_hd__xor2_2
XFILLER_55_1446 VGND VGND VPWR VPWR sky130_fd_sc_hd__decap_3
XFILLER_55_1457 VGND VGND VPWR VPWR sky130_fd_sc_hd__decap_3
X_5896_ _5932_/A0 _5896_/A1 _5896_/S VGND VGND VPWR VPWR _6905_/D sky130_fd_sc_hd__mux2_1
XFILLER_33_492 VGND VGND VPWR VPWR sky130_fd_sc_hd__decap_3
X_4847_ _6312_/Q _4847_/A2 _3450_/X _4868_/B2 VGND VGND VPWR VPWR _4847_/X sky130_fd_sc_hd__a22o_2
XFILLER_14_1121 VGND VGND VPWR VPWR sky130_fd_sc_hd__decap_3
X_4778_ _6575_/Q _4777_/A _4779_/A1 VGND VGND VPWR VPWR _4778_/X sky130_fd_sc_hd__a21bo_2
XFILLER_20_197 VGND VGND VPWR VPWR sky130_fd_sc_hd__decap_3
X_6517_ _6863_/CLK _6517_/D load_slew757/X VGND VGND VPWR VPWR _6517_/Q sky130_fd_sc_hd__dfrtp_2
X_3729_ _6295_/Q _3948_/A2 _3948_/B1 _6271_/Q _3948_/C1 VGND VGND VPWR VPWR _3729_/X
+ sky130_fd_sc_hd__a221o_2
X_6448_ _7050_/CLK _6448_/D load_slew645/X VGND VGND VPWR VPWR _6448_/Q sky130_fd_sc_hd__dfrtp_2
XFILLER_49_1239 VGND VGND VPWR VPWR sky130_fd_sc_hd__decap_3
X_6379_ _7034_/CLK _6379_/D load_slew671/X VGND VGND VPWR VPWR _6379_/Q sky130_fd_sc_hd__dfrtp_2
XFILLER_0_514 VGND VGND VPWR VPWR sky130_fd_sc_hd__decap_3
XFILLER_62_1406 VGND VGND VPWR VPWR sky130_fd_sc_hd__decap_3
XFILLER_0_536 VGND VGND VPWR VPWR sky130_fd_sc_hd__decap_3
XFILLER_76_827 VGND VGND VPWR VPWR sky130_fd_sc_hd__decap_3
XFILLER_29_710 VGND VGND VPWR VPWR sky130_fd_sc_hd__decap_3
XFILLER_60_1130 VGND VGND VPWR VPWR sky130_fd_sc_hd__decap_3
XFILLER_5_1322 VGND VGND VPWR VPWR sky130_fd_sc_hd__decap_3
XFILLER_75_337 VGND VGND VPWR VPWR sky130_fd_sc_hd__fill_1
XFILLER_25_1272 VGND VGND VPWR VPWR sky130_fd_sc_hd__decap_3
XFILLER_29_732 VGND VGND VPWR VPWR sky130_fd_sc_hd__fill_1
XFILLER_60_1152 VGND VGND VPWR VPWR sky130_fd_sc_hd__fill_1
XFILLER_29_754 VGND VGND VPWR VPWR sky130_fd_sc_hd__decap_3
XFILLER_5_1366 VGND VGND VPWR VPWR sky130_fd_sc_hd__decap_3
XFILLER_60_1185 VGND VGND VPWR VPWR sky130_fd_sc_hd__decap_3
XFILLER_1_1219 VGND VGND VPWR VPWR sky130_fd_sc_hd__decap_3
XFILLER_28_253 VGND VGND VPWR VPWR sky130_fd_sc_hd__decap_3
XFILLER_5_1399 VGND VGND VPWR VPWR sky130_fd_sc_hd__fill_1
XTAP_TAPCELL_ROW_27_900 VGND VPWR sky130_fd_sc_hd__tapvpwrvgnd_1
XFILLER_28_264 VGND VGND VPWR VPWR sky130_fd_sc_hd__decap_3
XFILLER_56_573 VGND VGND VPWR VPWR sky130_fd_sc_hd__decap_3
XFILLER_73_12 VGND VGND VPWR VPWR sky130_fd_sc_hd__decap_3
XFILLER_17_938 VGND VGND VPWR VPWR sky130_fd_sc_hd__decap_3
XTAP_TAPCELL_ROW_27_911 VGND VPWR sky130_fd_sc_hd__tapvpwrvgnd_1
XFILLER_73_45 VGND VGND VPWR VPWR sky130_fd_sc_hd__decap_3
XFILLER_71_532 VGND VGND VPWR VPWR sky130_fd_sc_hd__decap_3
XFILLER_43_245 VGND VGND VPWR VPWR sky130_fd_sc_hd__decap_3
XFILLER_44_779 VGND VGND VPWR VPWR sky130_fd_sc_hd__decap_3
XFILLER_73_78 VGND VGND VPWR VPWR sky130_fd_sc_hd__decap_3
Xwire90 wire90/A VGND VGND VPWR VPWR wire90/X sky130_fd_sc_hd__clkbuf_8
XFILLER_25_971 VGND VGND VPWR VPWR sky130_fd_sc_hd__fill_1
XFILLER_58_1081 VGND VGND VPWR VPWR sky130_fd_sc_hd__decap_3
XFILLER_12_610 VGND VGND VPWR VPWR sky130_fd_sc_hd__decap_3
XFILLER_19_1043 VGND VGND VPWR VPWR sky130_fd_sc_hd__decap_3
XFILLER_40_952 VGND VGND VPWR VPWR sky130_fd_sc_hd__decap_3
XFILLER_12_654 VGND VGND VPWR VPWR sky130_fd_sc_hd__fill_1
XFILLER_19_1076 VGND VGND VPWR VPWR sky130_fd_sc_hd__fill_1
XFILLER_11_131 VGND VGND VPWR VPWR sky130_fd_sc_hd__decap_3
XFILLER_8_614 VGND VGND VPWR VPWR sky130_fd_sc_hd__decap_3
XFILLER_12_698 VGND VGND VPWR VPWR sky130_fd_sc_hd__fill_2
XFILLER_32_1232 VGND VGND VPWR VPWR sky130_fd_sc_hd__decap_3
XFILLER_71_1281 VGND VGND VPWR VPWR sky130_fd_sc_hd__decap_3
XFILLER_7_124 VGND VGND VPWR VPWR sky130_fd_sc_hd__fill_2
XFILLER_71_1292 VGND VGND VPWR VPWR sky130_fd_sc_hd__decap_3
XFILLER_8_658 VGND VGND VPWR VPWR sky130_fd_sc_hd__decap_3
XFILLER_32_1276 VGND VGND VPWR VPWR sky130_fd_sc_hd__decap_3
XFILLER_67_1328 VGND VGND VPWR VPWR sky130_fd_sc_hd__decap_3
XFILLER_4_864 VGND VGND VPWR VPWR sky130_fd_sc_hd__decap_3
XFILLER_3_352 VGND VGND VPWR VPWR sky130_fd_sc_hd__decap_3
XFILLER_4_897 VGND VGND VPWR VPWR sky130_fd_sc_hd__decap_3
XFILLER_79_632 VGND VGND VPWR VPWR sky130_fd_sc_hd__decap_3
XFILLER_3_396 VGND VGND VPWR VPWR sky130_fd_sc_hd__decap_3
XFILLER_6_1108 VGND VGND VPWR VPWR sky130_fd_sc_hd__decap_3
XFILLER_67_816 VGND VGND VPWR VPWR sky130_fd_sc_hd__fill_1
XFILLER_39_518 VGND VGND VPWR VPWR sky130_fd_sc_hd__fill_2
XFILLER_67_838 VGND VGND VPWR VPWR sky130_fd_sc_hd__fill_2
XFILLER_78_197 VGND VGND VPWR VPWR sky130_fd_sc_hd__decap_3
XFILLER_14_6 VGND VGND VPWR VPWR sky130_fd_sc_hd__decap_3
XFILLER_43_1372 VGND VGND VPWR VPWR sky130_fd_sc_hd__decap_3
XFILLER_19_231 VGND VGND VPWR VPWR sky130_fd_sc_hd__decap_3
XFILLER_78_1424 VGND VGND VPWR VPWR sky130_fd_sc_hd__decap_3
XFILLER_78_1435 VGND VGND VPWR VPWR sky130_fd_sc_hd__decap_3
XFILLER_78_1468 VGND VGND VPWR VPWR sky130_fd_sc_hd__fill_1
XFILLER_39_1419 VGND VGND VPWR VPWR sky130_fd_sc_hd__decap_3
XFILLER_23_908 VGND VGND VPWR VPWR sky130_fd_sc_hd__fill_1
XFILLER_34_256 VGND VGND VPWR VPWR sky130_fd_sc_hd__decap_3
XFILLER_22_407 VGND VGND VPWR VPWR sky130_fd_sc_hd__decap_3
XFILLER_37_1121 VGND VGND VPWR VPWR sky130_fd_sc_hd__fill_2
XFILLER_76_1170 VGND VGND VPWR VPWR sky130_fd_sc_hd__decap_3
X_5750_ _5907_/A0 _5750_/A1 _5750_/S VGND VGND VPWR VPWR _6794_/D sky130_fd_sc_hd__mux2_1
XFILLER_62_598 VGND VGND VPWR VPWR sky130_fd_sc_hd__decap_3
XFILLER_50_749 VGND VGND VPWR VPWR sky130_fd_sc_hd__decap_3
XFILLER_15_481 VGND VGND VPWR VPWR sky130_fd_sc_hd__decap_3
XFILLER_37_1143 VGND VGND VPWR VPWR sky130_fd_sc_hd__fill_1
XTAP_TAPCELL_ROW_44_1333 VGND VPWR sky130_fd_sc_hd__tapvpwrvgnd_1
XFILLER_31_941 VGND VGND VPWR VPWR sky130_fd_sc_hd__decap_3
XTAP_TAPCELL_ROW_44_1344 VGND VPWR sky130_fd_sc_hd__tapvpwrvgnd_1
X_4701_ _6316_/Q wire60/X _4698_/X _4700_/X VGND VGND VPWR VPWR _6316_/D sky130_fd_sc_hd__o22a_2
XTAP_TAPCELL_ROW_44_1355 VGND VPWR sky130_fd_sc_hd__tapvpwrvgnd_1
X_5681_ hold935/X _5911_/A0 wire90/X VGND VGND VPWR VPWR _6734_/D sky130_fd_sc_hd__mux2_1
XFILLER_30_451 VGND VGND VPWR VPWR sky130_fd_sc_hd__decap_3
XFILLER_31_996 VGND VGND VPWR VPWR sky130_fd_sc_hd__decap_3
X_4632_ _6547_/Q _4710_/A _4831_/A1 VGND VGND VPWR VPWR _4632_/X sky130_fd_sc_hd__a21bo_2
XFILLER_50_1332 VGND VGND VPWR VPWR sky130_fd_sc_hd__decap_3
XFILLER_15_1452 VGND VGND VPWR VPWR sky130_fd_sc_hd__decap_3
XFILLER_30_495 VGND VGND VPWR VPWR sky130_fd_sc_hd__decap_3
XFILLER_15_1463 VGND VGND VPWR VPWR sky130_fd_sc_hd__decap_3
XFILLER_11_1316 VGND VGND VPWR VPWR sky130_fd_sc_hd__decap_3
XFILLER_50_1365 VGND VGND VPWR VPWR sky130_fd_sc_hd__decap_3
X_4563_ _6538_/Q _4547_/X _4741_/C1 VGND VGND VPWR VPWR _4563_/X sky130_fd_sc_hd__a21o_2
XFILLER_50_1376 VGND VGND VPWR VPWR sky130_fd_sc_hd__decap_3
X_3514_ _6252_/Q _6260_/Q _6268_/Q _6220_/Q _5505_/A _4420_/A VGND VGND VPWR VPWR
+ _3514_/X sky130_fd_sc_hd__mux4_2
X_6302_ _6912_/CLK _6302_/D wire715/X VGND VGND VPWR VPWR _6302_/Q sky130_fd_sc_hd__dfrtp_2
X_4494_ _6288_/Q _4493_/X _4849_/S VGND VGND VPWR VPWR _6288_/D sky130_fd_sc_hd__mux2_1
XFILLER_6_190 VGND VGND VPWR VPWR sky130_fd_sc_hd__decap_3
X_6233_ _6900_/CLK _6233_/D fanout830/X VGND VGND VPWR VPWR _6233_/Q sky130_fd_sc_hd__dfrtp_2
X_3445_ _6043_/A0 _3444_/X _3455_/S VGND VGND VPWR VPWR _6196_/D sky130_fd_sc_hd__mux2_1
XFILLER_48_1261 VGND VGND VPWR VPWR sky130_fd_sc_hd__decap_3
X_6164_ _7015_/CLK _6164_/D fanout793/X VGND VGND VPWR VPWR _6164_/Q sky130_fd_sc_hd__dfrtp_2
X_3376_ _6307_/Q _6419_/Q VGND VGND VPWR VPWR _3376_/X sky130_fd_sc_hd__xor2_2
XFILLER_48_1294 VGND VGND VPWR VPWR sky130_fd_sc_hd__decap_3
XFILLER_44_1136 VGND VGND VPWR VPWR sky130_fd_sc_hd__decap_3
XFILLER_69_142 VGND VGND VPWR VPWR sky130_fd_sc_hd__decap_3
Xload_slew550 _5285_/A VGND VGND VPWR VPWR _5276_/A sky130_fd_sc_hd__buf_4
XFILLER_58_816 VGND VGND VPWR VPWR sky130_fd_sc_hd__decap_3
X_5115_ _5502_/C _5115_/B VGND VGND VPWR VPWR _5115_/X sky130_fd_sc_hd__or2_2
Xhold1303 _6714_/Q VGND VGND VPWR VPWR _5659_/A1 sky130_fd_sc_hd__dlygate4sd3_1
Xhold1314 _6204_/Q VGND VGND VPWR VPWR _3461_/A0 sky130_fd_sc_hd__dlygate4sd3_1
X_6095_ _6954_/CLK _6095_/D load_slew650/X VGND VGND VPWR VPWR _6095_/Q sky130_fd_sc_hd__dfrtp_2
Xhold1325 _6478_/Q VGND VGND VPWR VPWR _5366_/A1 sky130_fd_sc_hd__dlygate4sd3_1
Xhold1336 _6515_/Q VGND VGND VPWR VPWR _5403_/A1 sky130_fd_sc_hd__dlygate4sd3_1
XFILLER_22_1412 VGND VGND VPWR VPWR sky130_fd_sc_hd__decap_3
XFILLER_57_337 VGND VGND VPWR VPWR sky130_fd_sc_hd__decap_3
X_5046_ _5044_/X _5045_/Y wire112/X VGND VGND VPWR VPWR _5048_/S sky130_fd_sc_hd__a21oi_2
Xhold1347 _6888_/Q VGND VGND VPWR VPWR _5877_/A1 sky130_fd_sc_hd__dlygate4sd3_1
Xhold1358 _6571_/Q VGND VGND VPWR VPWR _5459_/A1 sky130_fd_sc_hd__dlygate4sd3_1
Xhold1369 _6776_/Q VGND VGND VPWR VPWR _5729_/A1 sky130_fd_sc_hd__dlygate4sd3_1
XFILLER_66_860 VGND VGND VPWR VPWR sky130_fd_sc_hd__decap_3
XFILLER_22_1456 VGND VGND VPWR VPWR sky130_fd_sc_hd__decap_3
XFILLER_26_713 VGND VGND VPWR VPWR sky130_fd_sc_hd__decap_3
XFILLER_25_201 VGND VGND VPWR VPWR sky130_fd_sc_hd__decap_3
XFILLER_65_381 VGND VGND VPWR VPWR sky130_fd_sc_hd__decap_3
XFILLER_26_757 VGND VGND VPWR VPWR sky130_fd_sc_hd__decap_3
XFILLER_80_340 VGND VGND VPWR VPWR sky130_fd_sc_hd__fill_1
X_6997_ _7077_/CLK _6997_/D load_slew679/X VGND VGND VPWR VPWR _6997_/Q sky130_fd_sc_hd__dfrtp_2
XFILLER_25_278 VGND VGND VPWR VPWR sky130_fd_sc_hd__fill_2
XFILLER_43_15 VGND VGND VPWR VPWR sky130_fd_sc_hd__decap_3
XFILLER_80_373 VGND VGND VPWR VPWR sky130_fd_sc_hd__fill_2
XFILLER_0_1285 VGND VGND VPWR VPWR sky130_fd_sc_hd__decap_3
XFILLER_41_738 VGND VGND VPWR VPWR sky130_fd_sc_hd__decap_3
XFILLER_43_37 VGND VGND VPWR VPWR sky130_fd_sc_hd__fill_1
XFILLER_59_1390 VGND VGND VPWR VPWR sky130_fd_sc_hd__decap_3
X_5948_ hold974/X _5948_/A1 _6049_/S VGND VGND VPWR VPWR _6952_/D sky130_fd_sc_hd__mux2_1
XFILLER_16_1205 VGND VGND VPWR VPWR sky130_fd_sc_hd__decap_3
XFILLER_55_1254 VGND VGND VPWR VPWR sky130_fd_sc_hd__decap_3
XFILLER_40_259 VGND VGND VPWR VPWR sky130_fd_sc_hd__decap_3
XFILLER_16_1238 VGND VGND VPWR VPWR sky130_fd_sc_hd__decap_3
X_5879_ _5879_/A _5924_/C _5915_/D _5906_/B VGND VGND VPWR VPWR _5887_/S sky130_fd_sc_hd__or4bb_2
XFILLER_55_1287 VGND VGND VPWR VPWR sky130_fd_sc_hd__fill_1
XFILLER_55_1298 VGND VGND VPWR VPWR sky130_fd_sc_hd__decap_3
XFILLER_22_996 VGND VGND VPWR VPWR sky130_fd_sc_hd__decap_3
XFILLER_5_617 VGND VGND VPWR VPWR sky130_fd_sc_hd__decap_3
XFILLER_4_116 VGND VGND VPWR VPWR sky130_fd_sc_hd__decap_3
XTAP_TAPCELL_ROW_8_400 VGND VPWR sky130_fd_sc_hd__tapvpwrvgnd_1
XTAP_TAPCELL_ROW_8_411 VGND VPWR sky130_fd_sc_hd__tapvpwrvgnd_1
XFILLER_49_1058 VGND VGND VPWR VPWR sky130_fd_sc_hd__decap_3
XFILLER_1_812 VGND VGND VPWR VPWR sky130_fd_sc_hd__decap_3
XFILLER_68_12 VGND VGND VPWR VPWR sky130_fd_sc_hd__decap_3
XFILLER_27_1301 VGND VGND VPWR VPWR sky130_fd_sc_hd__decap_3
XFILLER_66_1350 VGND VGND VPWR VPWR sky130_fd_sc_hd__decap_3
XFILLER_1_856 VGND VGND VPWR VPWR sky130_fd_sc_hd__decap_3
XFILLER_0_333 VGND VGND VPWR VPWR sky130_fd_sc_hd__decap_3
XFILLER_27_1334 VGND VGND VPWR VPWR sky130_fd_sc_hd__decap_3
XFILLER_62_1214 VGND VGND VPWR VPWR sky130_fd_sc_hd__decap_3
XFILLER_68_56 VGND VGND VPWR VPWR sky130_fd_sc_hd__decap_3
XFILLER_27_1345 VGND VGND VPWR VPWR sky130_fd_sc_hd__decap_3
XFILLER_66_1394 VGND VGND VPWR VPWR sky130_fd_sc_hd__decap_3
XFILLER_0_355 VGND VGND VPWR VPWR sky130_fd_sc_hd__decap_3
XFILLER_7_1428 VGND VGND VPWR VPWR sky130_fd_sc_hd__decap_3
XFILLER_1_889 VGND VGND VPWR VPWR sky130_fd_sc_hd__decap_3
XFILLER_49_827 VGND VGND VPWR VPWR sky130_fd_sc_hd__decap_3
XFILLER_62_1247 VGND VGND VPWR VPWR sky130_fd_sc_hd__decap_3
XFILLER_0_377 VGND VGND VPWR VPWR sky130_fd_sc_hd__decap_3
XFILLER_27_1378 VGND VGND VPWR VPWR sky130_fd_sc_hd__decap_3
XFILLER_76_635 VGND VGND VPWR VPWR sky130_fd_sc_hd__decap_3
XFILLER_0_399 VGND VGND VPWR VPWR sky130_fd_sc_hd__decap_3
XFILLER_5_1130 VGND VGND VPWR VPWR sky130_fd_sc_hd__decap_3
XFILLER_5_1163 VGND VGND VPWR VPWR sky130_fd_sc_hd__decap_3
XFILLER_75_178 VGND VGND VPWR VPWR sky130_fd_sc_hd__decap_3
XFILLER_57_882 VGND VGND VPWR VPWR sky130_fd_sc_hd__decap_3
XFILLER_17_724 VGND VGND VPWR VPWR sky130_fd_sc_hd__decap_3
XFILLER_44_510 VGND VGND VPWR VPWR sky130_fd_sc_hd__decap_3
XFILLER_1_1027 VGND VGND VPWR VPWR sky130_fd_sc_hd__decap_3
XFILLER_17_735 VGND VGND VPWR VPWR sky130_fd_sc_hd__decap_3
XFILLER_72_830 VGND VGND VPWR VPWR sky130_fd_sc_hd__decap_3
XFILLER_72_863 VGND VGND VPWR VPWR sky130_fd_sc_hd__decap_3
XFILLER_16_256 VGND VGND VPWR VPWR sky130_fd_sc_hd__decap_3
XFILLER_73_1310 VGND VGND VPWR VPWR sky130_fd_sc_hd__decap_3
XFILLER_71_373 VGND VGND VPWR VPWR sky130_fd_sc_hd__decap_3
XFILLER_38_1441 VGND VGND VPWR VPWR sky130_fd_sc_hd__decap_3
XTAP_TAPCELL_ROW_80_2278 VGND VPWR sky130_fd_sc_hd__tapvpwrvgnd_1
XFILLER_73_1343 VGND VGND VPWR VPWR sky130_fd_sc_hd__fill_1
XTAP_TAPCELL_ROW_80_2289 VGND VPWR sky130_fd_sc_hd__tapvpwrvgnd_1
XFILLER_73_1354 VGND VGND VPWR VPWR sky130_fd_sc_hd__decap_3
XFILLER_9_912 VGND VGND VPWR VPWR sky130_fd_sc_hd__fill_1
XFILLER_73_1387 VGND VGND VPWR VPWR sky130_fd_sc_hd__decap_3
XFILLER_12_451 VGND VGND VPWR VPWR sky130_fd_sc_hd__decap_3
XFILLER_34_1338 VGND VGND VPWR VPWR sky130_fd_sc_hd__decap_3
XFILLER_40_760 VGND VGND VPWR VPWR sky130_fd_sc_hd__decap_3
XFILLER_9_934 VGND VGND VPWR VPWR sky130_fd_sc_hd__decap_3
XFILLER_12_473 VGND VGND VPWR VPWR sky130_fd_sc_hd__decap_3
XFILLER_8_433 VGND VGND VPWR VPWR sky130_fd_sc_hd__fill_2
XFILLER_32_1040 VGND VGND VPWR VPWR sky130_fd_sc_hd__decap_3
XFILLER_8_466 VGND VGND VPWR VPWR sky130_fd_sc_hd__decap_3
XFILLER_8_477 VGND VGND VPWR VPWR sky130_fd_sc_hd__fill_2
XFILLER_10_1371 VGND VGND VPWR VPWR sky130_fd_sc_hd__fill_1
XFILLER_4_661 VGND VGND VPWR VPWR sky130_fd_sc_hd__decap_3
XFILLER_10_1382 VGND VGND VPWR VPWR sky130_fd_sc_hd__decap_3
XFILLER_67_1169 VGND VGND VPWR VPWR sky130_fd_sc_hd__decap_3
XFILLER_45_1401 VGND VGND VPWR VPWR sky130_fd_sc_hd__decap_3
X_3230_ _6250_/Q _6346_/Q VGND VGND VPWR VPWR _3230_/X sky130_fd_sc_hd__xor2_2
XTAP_TAPCELL_ROW_37_1170 VGND VPWR sky130_fd_sc_hd__tapvpwrvgnd_1
XFILLER_45_1434 VGND VGND VPWR VPWR sky130_fd_sc_hd__decap_3
X_3161_ _6981_/Q _6989_/Q _3200_/S VGND VGND VPWR VPWR _3161_/X sky130_fd_sc_hd__mux2_1
XFILLER_39_326 VGND VGND VPWR VPWR sky130_fd_sc_hd__fill_2
XFILLER_80_1369 VGND VGND VPWR VPWR sky130_fd_sc_hd__decap_3
XTAP_TAPCELL_ROW_33_1056 VGND VPWR sky130_fd_sc_hd__tapvpwrvgnd_1
XTAP_TAPCELL_ROW_33_1067 VGND VPWR sky130_fd_sc_hd__tapvpwrvgnd_1
XFILLER_66_123 VGND VGND VPWR VPWR sky130_fd_sc_hd__decap_3
XFILLER_67_646 VGND VGND VPWR VPWR sky130_fd_sc_hd__fill_1
XFILLER_12_3 VGND VGND VPWR VPWR sky130_fd_sc_hd__decap_3
X_3092_ _3098_/A _3092_/B VGND VGND VPWR VPWR _3092_/Y sky130_fd_sc_hd__nand2_2
XFILLER_43_1180 VGND VGND VPWR VPWR sky130_fd_sc_hd__decap_3
XFILLER_54_307 VGND VGND VPWR VPWR sky130_fd_sc_hd__fill_1
XFILLER_66_167 VGND VGND VPWR VPWR sky130_fd_sc_hd__fill_1
X_6920_ _6925_/CLK _6920_/D wire655/A VGND VGND VPWR VPWR _6920_/Q sky130_fd_sc_hd__dfrtp_2
XFILLER_66_189 VGND VGND VPWR VPWR sky130_fd_sc_hd__decap_3
XFILLER_78_1232 VGND VGND VPWR VPWR sky130_fd_sc_hd__decap_3
XFILLER_63_841 VGND VGND VPWR VPWR sky130_fd_sc_hd__decap_3
XFILLER_78_1276 VGND VGND VPWR VPWR sky130_fd_sc_hd__decap_3
X_6851_ _7011_/CLK _6851_/D fanout811/X VGND VGND VPWR VPWR _6851_/Q sky130_fd_sc_hd__dfrtp_2
XFILLER_39_1227 VGND VGND VPWR VPWR sky130_fd_sc_hd__decap_3
XTAP_TAPCELL_ROW_46_1406 VGND VPWR sky130_fd_sc_hd__tapvpwrvgnd_1
XFILLER_50_502 VGND VGND VPWR VPWR sky130_fd_sc_hd__decap_3
XFILLER_63_885 VGND VGND VPWR VPWR sky130_fd_sc_hd__decap_3
XFILLER_74_1129 VGND VGND VPWR VPWR sky130_fd_sc_hd__decap_3
XFILLER_35_587 VGND VGND VPWR VPWR sky130_fd_sc_hd__decap_3
X_5802_ _5802_/A1 _5783_/X _5787_/Y _5801_/X VGND VGND VPWR VPWR _6825_/D sky130_fd_sc_hd__a22o_2
Xfanout19 _3856_/Y VGND VGND VPWR VPWR _5589_/A3 sky130_fd_sc_hd__clkdlybuf4s25_1
XFILLER_16_790 VGND VGND VPWR VPWR sky130_fd_sc_hd__decap_3
X_6782_ _6910_/CLK _6782_/D load_slew784/X VGND VGND VPWR VPWR _6782_/Q sky130_fd_sc_hd__dfrtp_2
X_3994_ _3348_/X _4765_/B2 _4766_/A2 _6871_/Q _4068_/C1 VGND VGND VPWR VPWR _3994_/X
+ sky130_fd_sc_hd__a221o_2
XFILLER_22_248 VGND VGND VPWR VPWR sky130_fd_sc_hd__decap_3
X_5733_ _5899_/A0 _5733_/A1 _5739_/S VGND VGND VPWR VPWR _6779_/D sky130_fd_sc_hd__mux2_1
XFILLER_13_18 VGND VGND VPWR VPWR sky130_fd_sc_hd__decap_3
XFILLER_52_1427 VGND VGND VPWR VPWR sky130_fd_sc_hd__fill_1
XFILLER_52_1438 VGND VGND VPWR VPWR sky130_fd_sc_hd__decap_3
X_5664_ _5664_/A0 _5664_/A1 _5666_/S VGND VGND VPWR VPWR _6719_/D sky130_fd_sc_hd__mux2_1
XFILLER_15_1260 VGND VGND VPWR VPWR sky130_fd_sc_hd__decap_3
XFILLER_11_1102 VGND VGND VPWR VPWR sky130_fd_sc_hd__decap_3
X_4615_ _6304_/Q _4614_/X _4849_/S VGND VGND VPWR VPWR _6304_/D sky130_fd_sc_hd__mux2_1
X_5595_ _3491_/X _5572_/Y _5593_/Y _5595_/B2 VGND VGND VPWR VPWR _6667_/D sky130_fd_sc_hd__a22o_2
XFILLER_11_1135 VGND VGND VPWR VPWR sky130_fd_sc_hd__decap_3
X_4546_ _6295_/Q _4899_/S _4543_/X _4545_/X VGND VGND VPWR VPWR _6295_/D sky130_fd_sc_hd__o22a_2
XFILLER_11_1168 VGND VGND VPWR VPWR sky130_fd_sc_hd__decap_3
XFILLER_1_108 VGND VGND VPWR VPWR sky130_fd_sc_hd__decap_3
Xmax_cap163 _5602_/Y VGND VGND VPWR VPWR _5610_/B1 sky130_fd_sc_hd__buf_4
X_4477_ _6334_/Q _4832_/A2 _3318_/X _4832_/B2 VGND VGND VPWR VPWR _4477_/X sky130_fd_sc_hd__a22o_2
XFILLER_1_119 VGND VGND VPWR VPWR sky130_fd_sc_hd__decap_3
X_3428_ _6325_/Q _6445_/Q VGND VGND VPWR VPWR _3428_/X sky130_fd_sc_hd__xor2_2
X_6216_ _7037_/CLK _6216_/D fanout688/X VGND VGND VPWR VPWR _6216_/Q sky130_fd_sc_hd__dfrtp_2
X_6147_ _7001_/CLK _6147_/D load_slew773/X VGND VGND VPWR VPWR _6147_/Q sky130_fd_sc_hd__dfrtp_2
Xhold1100 _6924_/Q VGND VGND VPWR VPWR _5918_/A0 sky130_fd_sc_hd__dlygate4sd3_1
X_3359_ _6000_/A0 _3358_/X _3389_/S VGND VGND VPWR VPWR _6153_/D sky130_fd_sc_hd__mux2_1
Xhold1111 _5998_/X VGND VGND VPWR VPWR _7002_/D sky130_fd_sc_hd__dlygate4sd3_1
Xload_slew380 _4056_/A2 VGND VGND VPWR VPWR _5519_/A2 sky130_fd_sc_hd__buf_2
XFILLER_58_657 VGND VGND VPWR VPWR sky130_fd_sc_hd__decap_3
Xhold1122 _6753_/Q VGND VGND VPWR VPWR _5702_/A0 sky130_fd_sc_hd__dlygate4sd3_1
Xhold1133 _5980_/X VGND VGND VPWR VPWR _6984_/D sky130_fd_sc_hd__dlygate4sd3_1
XFILLER_6_1450 VGND VGND VPWR VPWR sky130_fd_sc_hd__decap_3
Xload_slew391 fanout390/X VGND VGND VPWR VPWR _4882_/B2 sky130_fd_sc_hd__buf_4
XFILLER_46_808 VGND VGND VPWR VPWR sky130_fd_sc_hd__decap_3
XFILLER_79_1007 VGND VGND VPWR VPWR sky130_fd_sc_hd__fill_1
XFILLER_46_819 VGND VGND VPWR VPWR sky130_fd_sc_hd__decap_3
X_6078_ _6081_/C _6077_/Y _6074_/Y VGND VGND VPWR VPWR _6078_/X sky130_fd_sc_hd__a21o_2
Xhold1144 _7035_/Q VGND VGND VPWR VPWR _6031_/A1 sky130_fd_sc_hd__dlygate4sd3_1
Xhold1155 _6099_/Q VGND VGND VPWR VPWR _5946_/A0 sky130_fd_sc_hd__dlygate4sd3_1
XFILLER_2_1303 VGND VGND VPWR VPWR sky130_fd_sc_hd__decap_3
XFILLER_22_1242 VGND VGND VPWR VPWR sky130_fd_sc_hd__decap_3
XFILLER_45_307 VGND VGND VPWR VPWR sky130_fd_sc_hd__decap_3
Xhold1166 _6205_/Q VGND VGND VPWR VPWR _6052_/A0 sky130_fd_sc_hd__dlygate4sd3_1
X_5029_ _6426_/Q _5029_/B VGND VGND VPWR VPWR _5252_/B sky130_fd_sc_hd__xnor2_2
Xhold1177 _5954_/X VGND VGND VPWR VPWR _6958_/D sky130_fd_sc_hd__dlygate4sd3_1
XFILLER_45_329 VGND VGND VPWR VPWR sky130_fd_sc_hd__fill_1
Xhold1188 _6861_/Q VGND VGND VPWR VPWR _5845_/A0 sky130_fd_sc_hd__dlygate4sd3_1
XFILLER_22_1264 VGND VGND VPWR VPWR sky130_fd_sc_hd__decap_3
Xhold1199 _6928_/Q VGND VGND VPWR VPWR _5922_/A0 sky130_fd_sc_hd__dlygate4sd3_1
XFILLER_2_1347 VGND VGND VPWR VPWR sky130_fd_sc_hd__decap_3
XFILLER_22_1297 VGND VGND VPWR VPWR sky130_fd_sc_hd__decap_3
XFILLER_54_852 VGND VGND VPWR VPWR sky130_fd_sc_hd__decap_3
XFILLER_72_159 VGND VGND VPWR VPWR sky130_fd_sc_hd__decap_3
XFILLER_57_1316 VGND VGND VPWR VPWR sky130_fd_sc_hd__decap_3
XTAP_TAPCELL_ROW_0_163 VGND VPWR sky130_fd_sc_hd__tapvpwrvgnd_1
XFILLER_53_351 VGND VGND VPWR VPWR sky130_fd_sc_hd__decap_3
XTAP_TAPCELL_ROW_0_174 VGND VPWR sky130_fd_sc_hd__tapvpwrvgnd_1
XTAP_TAPCELL_ROW_0_185 VGND VPWR sky130_fd_sc_hd__tapvpwrvgnd_1
XTAP_TAPCELL_ROW_0_196 VGND VPWR sky130_fd_sc_hd__tapvpwrvgnd_1
XFILLER_0_1071 VGND VGND VPWR VPWR sky130_fd_sc_hd__decap_3
XFILLER_0_1093 VGND VGND VPWR VPWR sky130_fd_sc_hd__decap_3
XFILLER_16_1013 VGND VGND VPWR VPWR sky130_fd_sc_hd__fill_1
XFILLER_55_1073 VGND VGND VPWR VPWR sky130_fd_sc_hd__decap_3
XFILLER_70_24 VGND VGND VPWR VPWR sky130_fd_sc_hd__decap_3
XFILLER_16_1035 VGND VGND VPWR VPWR sky130_fd_sc_hd__fill_1
XFILLER_70_35 VGND VGND VPWR VPWR sky130_fd_sc_hd__decap_3
XFILLER_21_281 VGND VGND VPWR VPWR sky130_fd_sc_hd__decap_3
XFILLER_16_1079 VGND VGND VPWR VPWR sky130_fd_sc_hd__fill_1
XFILLER_33_1360 VGND VGND VPWR VPWR sky130_fd_sc_hd__decap_3
XFILLER_6_937 VGND VGND VPWR VPWR sky130_fd_sc_hd__fill_1
XFILLER_5_414 VGND VGND VPWR VPWR sky130_fd_sc_hd__decap_3
XFILLER_33_1393 VGND VGND VPWR VPWR sky130_fd_sc_hd__decap_3
XFILLER_6_959 VGND VGND VPWR VPWR sky130_fd_sc_hd__decap_3
XFILLER_68_1412 VGND VGND VPWR VPWR sky130_fd_sc_hd__decap_3
XFILLER_5_447 VGND VGND VPWR VPWR sky130_fd_sc_hd__fill_1
XFILLER_5_458 VGND VGND VPWR VPWR sky130_fd_sc_hd__decap_3
XFILLER_79_33 VGND VGND VPWR VPWR sky130_fd_sc_hd__decap_3
XFILLER_29_1407 VGND VGND VPWR VPWR sky130_fd_sc_hd__decap_3
XFILLER_68_1456 VGND VGND VPWR VPWR sky130_fd_sc_hd__decap_3
XFILLER_79_66 VGND VGND VPWR VPWR sky130_fd_sc_hd__decap_3
XFILLER_64_1309 VGND VGND VPWR VPWR sky130_fd_sc_hd__decap_3
XTAP_TAPCELL_ROW_73_2093 VGND VPWR sky130_fd_sc_hd__tapvpwrvgnd_1
XFILLER_1_642 VGND VGND VPWR VPWR sky130_fd_sc_hd__decap_3
XFILLER_66_1180 VGND VGND VPWR VPWR sky130_fd_sc_hd__decap_3
XFILLER_0_141 VGND VGND VPWR VPWR sky130_fd_sc_hd__decap_3
XFILLER_7_1225 VGND VGND VPWR VPWR sky130_fd_sc_hd__decap_3
XFILLER_76_410 VGND VGND VPWR VPWR sky130_fd_sc_hd__decap_3
XFILLER_7_1236 VGND VGND VPWR VPWR sky130_fd_sc_hd__decap_3
XFILLER_76_421 VGND VGND VPWR VPWR sky130_fd_sc_hd__decap_3
XFILLER_1_697 VGND VGND VPWR VPWR sky130_fd_sc_hd__decap_3
XFILLER_27_1175 VGND VGND VPWR VPWR sky130_fd_sc_hd__fill_1
XFILLER_62_1077 VGND VGND VPWR VPWR sky130_fd_sc_hd__decap_3
XFILLER_7_1269 VGND VGND VPWR VPWR sky130_fd_sc_hd__decap_3
XFILLER_48_134 VGND VGND VPWR VPWR sky130_fd_sc_hd__decap_3
XFILLER_40_1320 VGND VGND VPWR VPWR sky130_fd_sc_hd__decap_3
XFILLER_64_605 VGND VGND VPWR VPWR sky130_fd_sc_hd__decap_3
XFILLER_36_318 VGND VGND VPWR VPWR sky130_fd_sc_hd__decap_3
XFILLER_40_1353 VGND VGND VPWR VPWR sky130_fd_sc_hd__decap_3
XFILLER_76_498 VGND VGND VPWR VPWR sky130_fd_sc_hd__fill_2
XFILLER_40_1397 VGND VGND VPWR VPWR sky130_fd_sc_hd__decap_3
XFILLER_63_148 VGND VGND VPWR VPWR sky130_fd_sc_hd__decap_3
XFILLER_75_1416 VGND VGND VPWR VPWR sky130_fd_sc_hd__decap_3
XFILLER_44_351 VGND VGND VPWR VPWR sky130_fd_sc_hd__decap_3
XFILLER_17_576 VGND VGND VPWR VPWR sky130_fd_sc_hd__decap_3
XFILLER_75_1449 VGND VGND VPWR VPWR sky130_fd_sc_hd__decap_3
XFILLER_60_833 VGND VGND VPWR VPWR sky130_fd_sc_hd__fill_1
XFILLER_71_181 VGND VGND VPWR VPWR sky130_fd_sc_hd__decap_3
XFILLER_60_855 VGND VGND VPWR VPWR sky130_fd_sc_hd__fill_2
XFILLER_73_1151 VGND VGND VPWR VPWR sky130_fd_sc_hd__decap_3
XFILLER_38_1282 VGND VGND VPWR VPWR sky130_fd_sc_hd__decap_3
XFILLER_73_1195 VGND VGND VPWR VPWR sky130_fd_sc_hd__decap_3
XFILLER_9_742 VGND VGND VPWR VPWR sky130_fd_sc_hd__fill_2
XFILLER_12_281 VGND VGND VPWR VPWR sky130_fd_sc_hd__decap_3
XFILLER_8_230 VGND VGND VPWR VPWR sky130_fd_sc_hd__decap_3
XFILLER_12_1400 VGND VGND VPWR VPWR sky130_fd_sc_hd__decap_3
XFILLER_51_1460 VGND VGND VPWR VPWR sky130_fd_sc_hd__decap_3
XFILLER_12_1444 VGND VGND VPWR VPWR sky130_fd_sc_hd__decap_3
XTAP_TAPCELL_ROW_10_460 VGND VPWR sky130_fd_sc_hd__tapvpwrvgnd_1
X_4400_ _6846_/Q _4584_/A2 _4876_/B1 _4399_/X VGND VGND VPWR VPWR _4400_/X sky130_fd_sc_hd__a211o_2
XTAP_TAPCELL_ROW_10_471 VGND VPWR sky130_fd_sc_hd__tapvpwrvgnd_1
X_5380_ _5380_/A1 _5476_/A2 _4320_/X VGND VGND VPWR VPWR _6492_/D sky130_fd_sc_hd__a21o_2
XTAP_TAPCELL_ROW_39_1210 VGND VPWR sky130_fd_sc_hd__tapvpwrvgnd_1
XTAP_TAPCELL_ROW_39_1221 VGND VPWR sky130_fd_sc_hd__tapvpwrvgnd_1
XFILLER_5_30 VGND VGND VPWR VPWR sky130_fd_sc_hd__decap_3
X_4331_ _6341_/Q _4882_/A2 _3268_/X _4882_/B2 VGND VGND VPWR VPWR _4331_/X sky130_fd_sc_hd__a22o_2
XFILLER_5_63 VGND VGND VPWR VPWR sky130_fd_sc_hd__decap_3
XTAP_TAPCELL_ROW_35_1107 VGND VPWR sky130_fd_sc_hd__tapvpwrvgnd_1
XFILLER_4_491 VGND VGND VPWR VPWR sky130_fd_sc_hd__decap_3
X_7050_ _7050_/CLK _7050_/D load_slew645/X VGND VGND VPWR VPWR _7050_/Q sky130_fd_sc_hd__dfrtp_2
XTAP_TAPCELL_ROW_35_1118 VGND VPWR sky130_fd_sc_hd__tapvpwrvgnd_1
X_4262_ _6311_/Q wire515/A _3256_/X _4262_/B2 VGND VGND VPWR VPWR _4262_/X sky130_fd_sc_hd__a22o_2
Xfanout209 _5993_/S VGND VGND VPWR VPWR _6001_/S sky130_fd_sc_hd__clkdlybuf4s25_1
XFILLER_80_1111 VGND VGND VPWR VPWR sky130_fd_sc_hd__decap_3
XFILLER_45_1242 VGND VGND VPWR VPWR sky130_fd_sc_hd__decap_3
X_6001_ _6001_/A0 _7005_/Q _6001_/S VGND VGND VPWR VPWR _6001_/X sky130_fd_sc_hd__mux2_1
XFILLER_80_1133 VGND VGND VPWR VPWR sky130_fd_sc_hd__decap_3
X_3213_ _3213_/A1 _3211_/X _3212_/X _3213_/C1 VGND VGND VPWR VPWR _3217_/B sky130_fd_sc_hd__a211o_2
XFILLER_68_922 VGND VGND VPWR VPWR sky130_fd_sc_hd__fill_2
X_4193_ _4193_/A _4193_/B VGND VGND VPWR VPWR _4610_/B sky130_fd_sc_hd__xnor2_2
XFILLER_80_1155 VGND VGND VPWR VPWR sky130_fd_sc_hd__decap_3
XFILLER_79_281 VGND VGND VPWR VPWR sky130_fd_sc_hd__fill_2
XFILLER_45_1275 VGND VGND VPWR VPWR sky130_fd_sc_hd__decap_3
XFILLER_80_1177 VGND VGND VPWR VPWR sky130_fd_sc_hd__decap_3
X_3144_ _6940_/Q _3219_/B2 _3193_/A1 _3143_/X _3205_/B1 VGND VGND VPWR VPWR _3145_/C
+ sky130_fd_sc_hd__a221o_2
XFILLER_27_318 VGND VGND VPWR VPWR sky130_fd_sc_hd__fill_2
XFILLER_39_189 VGND VGND VPWR VPWR sky130_fd_sc_hd__decap_3
X_3075_ _7094_/Q VGND VGND VPWR VPWR _6073_/B sky130_fd_sc_hd__inv_2
X_6903_ _6999_/CLK _6903_/D wire827/X VGND VGND VPWR VPWR _6903_/Q sky130_fd_sc_hd__dfrtp_2
XFILLER_35_340 VGND VGND VPWR VPWR sky130_fd_sc_hd__decap_3
XTAP_TAPCELL_ROW_69_1984 VGND VPWR sky130_fd_sc_hd__tapvpwrvgnd_1
XFILLER_51_800 VGND VGND VPWR VPWR sky130_fd_sc_hd__decap_3
XFILLER_63_660 VGND VGND VPWR VPWR sky130_fd_sc_hd__decap_3
XTAP_TAPCELL_ROW_69_1995 VGND VPWR sky130_fd_sc_hd__tapvpwrvgnd_1
XFILLER_78_1073 VGND VGND VPWR VPWR sky130_fd_sc_hd__decap_3
X_6834_ _7037_/CLK _6834_/D fanout688/X VGND VGND VPWR VPWR _6834_/Q sky130_fd_sc_hd__dfrtp_2
XFILLER_39_1057 VGND VGND VPWR VPWR sky130_fd_sc_hd__decap_3
XFILLER_23_546 VGND VGND VPWR VPWR sky130_fd_sc_hd__fill_2
XFILLER_39_1068 VGND VGND VPWR VPWR sky130_fd_sc_hd__decap_3
XFILLER_23_557 VGND VGND VPWR VPWR sky130_fd_sc_hd__decap_3
XFILLER_51_866 VGND VGND VPWR VPWR sky130_fd_sc_hd__decap_3
XFILLER_17_1322 VGND VGND VPWR VPWR sky130_fd_sc_hd__decap_3
XFILLER_56_1371 VGND VGND VPWR VPWR sky130_fd_sc_hd__fill_1
X_6765_ _6765_/CLK _6765_/D wire641/X VGND VGND VPWR VPWR _6765_/Q sky130_fd_sc_hd__dfrtp_2
XFILLER_56_1382 VGND VGND VPWR VPWR sky130_fd_sc_hd__decap_3
X_3977_ _6226_/Q _4069_/A2 _3975_/X _3976_/X VGND VGND VPWR VPWR _6226_/D sky130_fd_sc_hd__o22a_2
XFILLER_10_229 VGND VGND VPWR VPWR sky130_fd_sc_hd__decap_3
X_5716_ _5909_/A0 _5716_/A1 wire88/X VGND VGND VPWR VPWR _6764_/D sky130_fd_sc_hd__mux2_1
XFILLER_17_1366 VGND VGND VPWR VPWR sky130_fd_sc_hd__decap_3
XTAP_TAPCELL_ROW_21_736 VGND VPWR sky130_fd_sc_hd__tapvpwrvgnd_1
XFILLER_52_1246 VGND VGND VPWR VPWR sky130_fd_sc_hd__decap_3
X_6696_ _7048_/CLK _6696_/D load_slew658/X VGND VGND VPWR VPWR _6696_/Q sky130_fd_sc_hd__dfrtp_2
XTAP_TAPCELL_ROW_21_747 VGND VPWR sky130_fd_sc_hd__tapvpwrvgnd_1
XTAP_TAPCELL_ROW_21_758 VGND VPWR sky130_fd_sc_hd__tapvpwrvgnd_1
XFILLER_17_1399 VGND VGND VPWR VPWR sky130_fd_sc_hd__fill_1
XFILLER_52_1279 VGND VGND VPWR VPWR sky130_fd_sc_hd__decap_3
XFILLER_40_27 VGND VGND VPWR VPWR sky130_fd_sc_hd__fill_1
X_5647_ _5913_/A0 _5647_/A1 wire92/X VGND VGND VPWR VPWR _6704_/D sky130_fd_sc_hd__mux2_1
XFILLER_3_918 VGND VGND VPWR VPWR sky130_fd_sc_hd__decap_3
X_5578_ _5578_/A VGND VGND VPWR VPWR _5578_/Y sky130_fd_sc_hd__inv_2
X_4529_ _6269_/Q _4882_/A2 _3332_/X _4882_/B2 VGND VGND VPWR VPWR _4529_/X sky130_fd_sc_hd__a22o_2
XFILLER_59_900 VGND VGND VPWR VPWR sky130_fd_sc_hd__decap_3
Xfanout721 fanout724/X VGND VGND VPWR VPWR fanout721/X sky130_fd_sc_hd__clkdlybuf4s25_1
XFILLER_63_1331 VGND VGND VPWR VPWR sky130_fd_sc_hd__decap_3
XFILLER_28_1462 VGND VGND VPWR VPWR sky130_fd_sc_hd__decap_3
Xfanout743 fanout745/X VGND VGND VPWR VPWR fanout743/X sky130_fd_sc_hd__clkdlybuf4s25_1
XFILLER_58_410 VGND VGND VPWR VPWR sky130_fd_sc_hd__fill_1
XFILLER_24_1315 VGND VGND VPWR VPWR sky130_fd_sc_hd__fill_1
XFILLER_58_421 VGND VGND VPWR VPWR sky130_fd_sc_hd__decap_3
XFILLER_24_1326 VGND VGND VPWR VPWR sky130_fd_sc_hd__decap_3
Xfanout765 fanout766/X VGND VGND VPWR VPWR fanout765/X sky130_fd_sc_hd__clkdlybuf4s25_1
XFILLER_63_1375 VGND VGND VPWR VPWR sky130_fd_sc_hd__decap_3
Xfanout776 fanout779/A VGND VGND VPWR VPWR fanout776/X sky130_fd_sc_hd__clkdlybuf4s25_1
XFILLER_4_1409 VGND VGND VPWR VPWR sky130_fd_sc_hd__decap_3
Xfanout787 fanout788/X VGND VGND VPWR VPWR fanout787/X sky130_fd_sc_hd__clkdlybuf4s25_1
XFILLER_24_1359 VGND VGND VPWR VPWR sky130_fd_sc_hd__decap_3
XFILLER_74_914 VGND VGND VPWR VPWR sky130_fd_sc_hd__decap_3
Xfanout798 fanout803/X VGND VGND VPWR VPWR fanout798/X sky130_fd_sc_hd__clkdlybuf4s25_1
XFILLER_46_605 VGND VGND VPWR VPWR sky130_fd_sc_hd__fill_1
XFILLER_74_925 VGND VGND VPWR VPWR sky130_fd_sc_hd__fill_2
XFILLER_73_402 VGND VGND VPWR VPWR sky130_fd_sc_hd__decap_3
XFILLER_59_999 VGND VGND VPWR VPWR sky130_fd_sc_hd__fill_1
XFILLER_65_24 VGND VGND VPWR VPWR sky130_fd_sc_hd__decap_3
XFILLER_2_1111 VGND VGND VPWR VPWR sky130_fd_sc_hd__decap_3
XFILLER_6_1291 VGND VGND VPWR VPWR sky130_fd_sc_hd__decap_3
XFILLER_65_57 VGND VGND VPWR VPWR sky130_fd_sc_hd__decap_3
XFILLER_73_446 VGND VGND VPWR VPWR sky130_fd_sc_hd__fill_2
XFILLER_27_841 VGND VGND VPWR VPWR sky130_fd_sc_hd__decap_3
XFILLER_2_1144 VGND VGND VPWR VPWR sky130_fd_sc_hd__decap_3
XFILLER_2_1155 VGND VGND VPWR VPWR sky130_fd_sc_hd__decap_3
XFILLER_22_1083 VGND VGND VPWR VPWR sky130_fd_sc_hd__fill_1
XFILLER_73_479 VGND VGND VPWR VPWR sky130_fd_sc_hd__decap_3
XFILLER_27_874 VGND VGND VPWR VPWR sky130_fd_sc_hd__decap_3
XFILLER_42_811 VGND VGND VPWR VPWR sky130_fd_sc_hd__fill_1
XFILLER_2_1188 VGND VGND VPWR VPWR sky130_fd_sc_hd__decap_3
XFILLER_57_1124 VGND VGND VPWR VPWR sky130_fd_sc_hd__decap_3
XFILLER_42_822 VGND VGND VPWR VPWR sky130_fd_sc_hd__decap_3
XFILLER_14_524 VGND VGND VPWR VPWR sky130_fd_sc_hd__decap_3
XFILLER_54_693 VGND VGND VPWR VPWR sky130_fd_sc_hd__decap_3
Xclkbuf_leaf_80_clk clkbuf_leaf_3_clk/A VGND VGND VPWR VPWR _6897_/CLK sky130_fd_sc_hd__clkbuf_8
XFILLER_35_1422 VGND VGND VPWR VPWR sky130_fd_sc_hd__decap_3
XFILLER_42_899 VGND VGND VPWR VPWR sky130_fd_sc_hd__decap_3
XFILLER_41_387 VGND VGND VPWR VPWR sky130_fd_sc_hd__decap_3
XFILLER_70_1335 VGND VGND VPWR VPWR sky130_fd_sc_hd__decap_3
XFILLER_35_1455 VGND VGND VPWR VPWR sky130_fd_sc_hd__fill_1
XFILLER_35_1466 VGND VGND VPWR VPWR sky130_fd_sc_hd__decap_3
XFILLER_70_1368 VGND VGND VPWR VPWR sky130_fd_sc_hd__decap_3
XFILLER_14_83 VGND VGND VPWR VPWR sky130_fd_sc_hd__fill_1
XFILLER_31_1319 VGND VGND VPWR VPWR sky130_fd_sc_hd__decap_3
XFILLER_70_1379 VGND VGND VPWR VPWR sky130_fd_sc_hd__decap_3
XFILLER_10_774 VGND VGND VPWR VPWR sky130_fd_sc_hd__decap_3
XTAP_TAPCELL_ROW_75_2144 VGND VPWR sky130_fd_sc_hd__tapvpwrvgnd_1
XFILLER_68_1220 VGND VGND VPWR VPWR sky130_fd_sc_hd__decap_3
XTAP_TAPCELL_ROW_75_2155 VGND VPWR sky130_fd_sc_hd__tapvpwrvgnd_1
XFILLER_68_1253 VGND VGND VPWR VPWR sky130_fd_sc_hd__decap_3
XFILLER_29_1215 VGND VGND VPWR VPWR sky130_fd_sc_hd__decap_3
XFILLER_68_1264 VGND VGND VPWR VPWR sky130_fd_sc_hd__decap_3
XFILLER_29_1226 VGND VGND VPWR VPWR sky130_fd_sc_hd__decap_3
XFILLER_2_940 VGND VGND VPWR VPWR sky130_fd_sc_hd__decap_3
XFILLER_64_1117 VGND VGND VPWR VPWR sky130_fd_sc_hd__decap_3
XFILLER_29_1248 VGND VGND VPWR VPWR sky130_fd_sc_hd__decap_3
XFILLER_68_1297 VGND VGND VPWR VPWR sky130_fd_sc_hd__decap_3
XFILLER_2_973 VGND VGND VPWR VPWR sky130_fd_sc_hd__decap_3
XFILLER_2_984 VGND VGND VPWR VPWR sky130_fd_sc_hd__decap_3
XFILLER_1_472 VGND VGND VPWR VPWR sky130_fd_sc_hd__decap_3
XFILLER_42_1415 VGND VGND VPWR VPWR sky130_fd_sc_hd__decap_3
XFILLER_7_1044 VGND VGND VPWR VPWR sky130_fd_sc_hd__decap_3
XFILLER_77_752 VGND VGND VPWR VPWR sky130_fd_sc_hd__fill_2
XFILLER_65_903 VGND VGND VPWR VPWR sky130_fd_sc_hd__decap_3
XFILLER_37_605 VGND VGND VPWR VPWR sky130_fd_sc_hd__decap_3
XFILLER_42_1459 VGND VGND VPWR VPWR sky130_fd_sc_hd__decap_3
XFILLER_77_785 VGND VGND VPWR VPWR sky130_fd_sc_hd__decap_3
XFILLER_49_476 VGND VGND VPWR VPWR sky130_fd_sc_hd__decap_3
Xinput9 ui_in[7] VGND VGND VPWR VPWR input9/X sky130_fd_sc_hd__clkdlybuf4s25_1
XFILLER_18_830 VGND VGND VPWR VPWR sky130_fd_sc_hd__decap_3
XFILLER_18_852 VGND VGND VPWR VPWR sky130_fd_sc_hd__decap_3
XFILLER_79_1360 VGND VGND VPWR VPWR sky130_fd_sc_hd__decap_3
XFILLER_75_1213 VGND VGND VPWR VPWR sky130_fd_sc_hd__decap_3
XFILLER_45_660 VGND VGND VPWR VPWR sky130_fd_sc_hd__decap_3
XFILLER_17_362 VGND VGND VPWR VPWR sky130_fd_sc_hd__decap_3
XFILLER_79_1393 VGND VGND VPWR VPWR sky130_fd_sc_hd__decap_3
X_3900_ _6325_/Q _3903_/A2 _3898_/X _3899_/X VGND VGND VPWR VPWR _4170_/A sky130_fd_sc_hd__o22a_2
XFILLER_51_129 VGND VGND VPWR VPWR sky130_fd_sc_hd__decap_3
XFILLER_75_1257 VGND VGND VPWR VPWR sky130_fd_sc_hd__decap_3
X_4880_ _4879_/B _4703_/B _4879_/Y _4880_/C1 VGND VGND VPWR VPWR _4881_/C sky130_fd_sc_hd__o211ai_2
Xclkbuf_leaf_71_clk clkbuf_4_8__f_clk/X VGND VGND VPWR VPWR _7046_/CLK sky130_fd_sc_hd__clkbuf_8
XFILLER_36_1208 VGND VGND VPWR VPWR sky130_fd_sc_hd__fill_1
XFILLER_44_192 VGND VGND VPWR VPWR sky130_fd_sc_hd__decap_3
XFILLER_20_505 VGND VGND VPWR VPWR sky130_fd_sc_hd__decap_3
X_3831_ _4008_/B _4002_/A2 _4300_/B _3089_/B _6499_/Q VGND VGND VPWR VPWR _3831_/X
+ sky130_fd_sc_hd__a32o_2
XTAP_TAPCELL_ROW_64_1870 VGND VPWR sky130_fd_sc_hd__tapvpwrvgnd_1
XFILLER_32_365 VGND VGND VPWR VPWR sky130_fd_sc_hd__fill_2
XFILLER_60_674 VGND VGND VPWR VPWR sky130_fd_sc_hd__decap_3
XFILLER_32_376 VGND VGND VPWR VPWR sky130_fd_sc_hd__fill_2
XTAP_TAPCELL_ROW_15_585 VGND VPWR sky130_fd_sc_hd__tapvpwrvgnd_1
X_3762_ _3762_/A _3762_/B VGND VGND VPWR VPWR _3763_/B sky130_fd_sc_hd__xnor2_2
XTAP_TAPCELL_ROW_15_596 VGND VPWR sky130_fd_sc_hd__tapvpwrvgnd_1
X_6550_ _6888_/CLK _6550_/D fanout659/X VGND VGND VPWR VPWR _6550_/Q sky130_fd_sc_hd__dfrtp_2
XTAP_TAPCELL_ROW_60_1756 VGND VPWR sky130_fd_sc_hd__tapvpwrvgnd_1
XTAP_TAPCELL_ROW_60_1767 VGND VPWR sky130_fd_sc_hd__tapvpwrvgnd_1
Xtt_um_aes128_optimized_857 VGND VGND VPWR VPWR tt_um_aes128_optimized_857/HI uio_out[4]
+ sky130_fd_sc_hd__conb_1
XFILLER_9_561 VGND VGND VPWR VPWR sky130_fd_sc_hd__fill_2
X_5501_ _7081_/Q _5501_/B VGND VGND VPWR VPWR _5501_/Y sky130_fd_sc_hd__nor2_2
XFILLER_9_572 VGND VGND VPWR VPWR sky130_fd_sc_hd__decap_3
XFILLER_9_583 VGND VGND VPWR VPWR sky130_fd_sc_hd__decap_3
X_3693_ _3693_/A _3748_/B _3693_/C VGND VGND VPWR VPWR _3693_/X sky130_fd_sc_hd__or3_2
X_6481_ _6923_/CLK _6481_/D load_slew760/X VGND VGND VPWR VPWR _6481_/Q sky130_fd_sc_hd__dfrtp_2
XFILLER_12_1241 VGND VGND VPWR VPWR sky130_fd_sc_hd__decap_3
X_5432_ _5432_/A1 _5464_/A2 _4612_/X VGND VGND VPWR VPWR _6544_/D sky130_fd_sc_hd__a21o_2
XFILLER_12_1285 VGND VGND VPWR VPWR sky130_fd_sc_hd__decap_3
XFILLER_47_1304 VGND VGND VPWR VPWR sky130_fd_sc_hd__decap_3
X_5363_ _5363_/A1 _5456_/A2 _4145_/X VGND VGND VPWR VPWR _6475_/D sky130_fd_sc_hd__a21o_2
XFILLER_47_1337 VGND VGND VPWR VPWR sky130_fd_sc_hd__decap_3
X_4314_ _4326_/B _4314_/B VGND VGND VPWR VPWR _4315_/B sky130_fd_sc_hd__xnor2_2
XFILLER_47_1348 VGND VGND VPWR VPWR sky130_fd_sc_hd__decap_3
XTAP_TAPCELL_ROW_58_1696 VGND VPWR sky130_fd_sc_hd__tapvpwrvgnd_1
X_5294_ _6778_/Q _4903_/B _5306_/S VGND VGND VPWR VPWR _5294_/X sky130_fd_sc_hd__mux2_1
X_4245_ _6309_/Q _4854_/A2 _3252_/X _4882_/B2 VGND VGND VPWR VPWR _4245_/X sky130_fd_sc_hd__a22o_2
X_7033_ _7089_/CLK _7033_/D wire738/X VGND VGND VPWR VPWR _7033_/Q sky130_fd_sc_hd__dfrtp_2
X_4176_ _6278_/Q _4750_/A2 _3238_/X _4750_/B2 VGND VGND VPWR VPWR _4176_/X sky130_fd_sc_hd__a22o_2
XFILLER_56_925 VGND VGND VPWR VPWR sky130_fd_sc_hd__fill_1
XFILLER_55_424 VGND VGND VPWR VPWR sky130_fd_sc_hd__decap_3
X_3127_ _6995_/Q wire419/X _3136_/A _7003_/Q _3205_/B1 VGND VGND VPWR VPWR _3127_/X
+ sky130_fd_sc_hd__a221o_2
XFILLER_67_284 VGND VGND VPWR VPWR sky130_fd_sc_hd__decap_3
XFILLER_3_1431 VGND VGND VPWR VPWR sky130_fd_sc_hd__decap_3
XTAP_TAPCELL_ROW_2_247 VGND VPWR sky130_fd_sc_hd__tapvpwrvgnd_1
XFILLER_56_969 VGND VGND VPWR VPWR sky130_fd_sc_hd__fill_2
XTAP_TAPCELL_ROW_2_258 VGND VPWR sky130_fd_sc_hd__tapvpwrvgnd_1
XFILLER_23_1381 VGND VGND VPWR VPWR sky130_fd_sc_hd__decap_3
XFILLER_71_906 VGND VGND VPWR VPWR sky130_fd_sc_hd__fill_2
XFILLER_58_1400 VGND VGND VPWR VPWR sky130_fd_sc_hd__decap_3
X_3058_ _6354_/Q VGND VGND VPWR VPWR _3058_/Y sky130_fd_sc_hd__inv_2
XFILLER_55_479 VGND VGND VPWR VPWR sky130_fd_sc_hd__decap_3
XFILLER_70_438 VGND VGND VPWR VPWR sky130_fd_sc_hd__decap_3
XFILLER_24_833 VGND VGND VPWR VPWR sky130_fd_sc_hd__decap_3
XFILLER_42_129 VGND VGND VPWR VPWR sky130_fd_sc_hd__decap_3
XFILLER_58_1444 VGND VGND VPWR VPWR sky130_fd_sc_hd__decap_3
XFILLER_19_1428 VGND VGND VPWR VPWR sky130_fd_sc_hd__decap_3
Xclkbuf_leaf_62_clk clkbuf_leaf_67_clk/A VGND VGND VPWR VPWR _6988_/CLK sky130_fd_sc_hd__clkbuf_8
XFILLER_35_192 VGND VGND VPWR VPWR sky130_fd_sc_hd__decap_3
XFILLER_23_343 VGND VGND VPWR VPWR sky130_fd_sc_hd__decap_3
XFILLER_24_866 VGND VGND VPWR VPWR sky130_fd_sc_hd__fill_2
X_6817_ _7057_/CLK _6817_/D fanout727/X VGND VGND VPWR VPWR _6817_/Q sky130_fd_sc_hd__dfrtp_2
XFILLER_11_527 VGND VGND VPWR VPWR sky130_fd_sc_hd__fill_2
X_6748_ _7019_/CLK _6748_/D load_slew837/X VGND VGND VPWR VPWR _6748_/Q sky130_fd_sc_hd__dfrtp_2
XFILLER_50_195 VGND VGND VPWR VPWR sky130_fd_sc_hd__fill_1
XFILLER_17_1163 VGND VGND VPWR VPWR sky130_fd_sc_hd__decap_3
XFILLER_52_1043 VGND VGND VPWR VPWR sky130_fd_sc_hd__fill_2
XFILLER_52_1076 VGND VGND VPWR VPWR sky130_fd_sc_hd__decap_3
X_6679_ _7054_/CLK _6679_/D fanout791/X VGND VGND VPWR VPWR _6679_/Q sky130_fd_sc_hd__dfrtp_2
XFILLER_13_1049 VGND VGND VPWR VPWR sky130_fd_sc_hd__decap_3
XFILLER_30_1341 VGND VGND VPWR VPWR sky130_fd_sc_hd__decap_3
XFILLER_3_715 VGND VGND VPWR VPWR sky130_fd_sc_hd__decap_3
XFILLER_2_203 VGND VGND VPWR VPWR sky130_fd_sc_hd__fill_1
XFILLER_30_1385 VGND VGND VPWR VPWR sky130_fd_sc_hd__decap_3
XFILLER_65_1404 VGND VGND VPWR VPWR sky130_fd_sc_hd__decap_3
XFILLER_2_236 VGND VGND VPWR VPWR sky130_fd_sc_hd__decap_3
XFILLER_65_1437 VGND VGND VPWR VPWR sky130_fd_sc_hd__decap_3
XTAP_TAPCELL_ROW_70_2030 VGND VPWR sky130_fd_sc_hd__tapvpwrvgnd_1
XFILLER_8_1320 VGND VGND VPWR VPWR sky130_fd_sc_hd__decap_3
XFILLER_76_12 VGND VGND VPWR VPWR sky130_fd_sc_hd__decap_3
XFILLER_28_1270 VGND VGND VPWR VPWR sky130_fd_sc_hd__decap_3
Xfanout551 _5298_/S VGND VGND VPWR VPWR _5213_/A sky130_fd_sc_hd__clkdlybuf4s25_1
XFILLER_8_1353 VGND VGND VPWR VPWR sky130_fd_sc_hd__decap_3
XFILLER_76_56 VGND VGND VPWR VPWR sky130_fd_sc_hd__decap_3
Xfanout573 _4010_/A VGND VGND VPWR VPWR _3927_/A_N sky130_fd_sc_hd__clkdlybuf4s25_1
XFILLER_4_1217 VGND VGND VPWR VPWR sky130_fd_sc_hd__decap_3
XFILLER_24_1145 VGND VGND VPWR VPWR sky130_fd_sc_hd__decap_3
Xfanout584 _6606_/Q VGND VGND VPWR VPWR _4355_/A sky130_fd_sc_hd__clkdlybuf4s25_1
Xfanout595 _4369_/B VGND VGND VPWR VPWR _3597_/S0 sky130_fd_sc_hd__clkdlybuf4s25_1
XFILLER_59_785 VGND VGND VPWR VPWR sky130_fd_sc_hd__decap_3
XFILLER_8_1397 VGND VGND VPWR VPWR sky130_fd_sc_hd__decap_3
XFILLER_59_796 VGND VGND VPWR VPWR sky130_fd_sc_hd__fill_2
XFILLER_47_947 VGND VGND VPWR VPWR sky130_fd_sc_hd__decap_3
XFILLER_58_273 VGND VGND VPWR VPWR sky130_fd_sc_hd__decap_3
XFILLER_73_210 VGND VGND VPWR VPWR sky130_fd_sc_hd__decap_3
XFILLER_19_649 VGND VGND VPWR VPWR sky130_fd_sc_hd__decap_3
XFILLER_46_435 VGND VGND VPWR VPWR sky130_fd_sc_hd__decap_3
XFILLER_15_844 VGND VGND VPWR VPWR sky130_fd_sc_hd__decap_3
Xclkbuf_leaf_53_clk clkbuf_leaf_54_clk/A VGND VGND VPWR VPWR _6943_/CLK sky130_fd_sc_hd__clkbuf_8
XFILLER_25_60 VGND VGND VPWR VPWR sky130_fd_sc_hd__decap_3
XTAP_TAPCELL_ROW_25_850 VGND VPWR sky130_fd_sc_hd__tapvpwrvgnd_1
XFILLER_14_365 VGND VGND VPWR VPWR sky130_fd_sc_hd__decap_3
XTAP_TAPCELL_ROW_25_861 VGND VPWR sky130_fd_sc_hd__tapvpwrvgnd_1
XTAP_TAPCELL_ROW_12_500 VGND VPWR sky130_fd_sc_hd__tapvpwrvgnd_1
XFILLER_35_1230 VGND VGND VPWR VPWR sky130_fd_sc_hd__fill_2
XTAP_TAPCELL_ROW_12_511 VGND VPWR sky130_fd_sc_hd__tapvpwrvgnd_1
XFILLER_41_184 VGND VGND VPWR VPWR sky130_fd_sc_hd__decap_3
XFILLER_70_1132 VGND VGND VPWR VPWR sky130_fd_sc_hd__decap_3
XTAP_TAPCELL_ROW_12_522 VGND VPWR sky130_fd_sc_hd__tapvpwrvgnd_1
XTAP_TAPCELL_ROW_77_2206 VGND VPWR sky130_fd_sc_hd__tapvpwrvgnd_1
XFILLER_35_1263 VGND VGND VPWR VPWR sky130_fd_sc_hd__decap_3
XFILLER_31_1116 VGND VGND VPWR VPWR sky130_fd_sc_hd__decap_3
XFILLER_70_1176 VGND VGND VPWR VPWR sky130_fd_sc_hd__decap_3
XFILLER_10_582 VGND VGND VPWR VPWR sky130_fd_sc_hd__decap_3
XFILLER_6_531 VGND VGND VPWR VPWR sky130_fd_sc_hd__fill_1
XFILLER_6_542 VGND VGND VPWR VPWR sky130_fd_sc_hd__fill_2
XFILLER_41_81 VGND VGND VPWR VPWR sky130_fd_sc_hd__decap_3
XFILLER_29_1001 VGND VGND VPWR VPWR sky130_fd_sc_hd__decap_3
XFILLER_68_1050 VGND VGND VPWR VPWR sky130_fd_sc_hd__decap_3
XFILLER_44_6 VGND VGND VPWR VPWR sky130_fd_sc_hd__decap_3
XFILLER_9_1117 VGND VGND VPWR VPWR sky130_fd_sc_hd__decap_3
XFILLER_69_505 VGND VGND VPWR VPWR sky130_fd_sc_hd__decap_3
XFILLER_9_1139 VGND VGND VPWR VPWR sky130_fd_sc_hd__decap_3
XTAP_TAPCELL_ROW_53_1571 VGND VPWR sky130_fd_sc_hd__tapvpwrvgnd_1
X_4030_ _6563_/Q _4572_/B _4049_/A1 VGND VGND VPWR VPWR _4030_/X sky130_fd_sc_hd__a21bo_2
XPHY_EDGE_ROW_10_Right_10 VGND VGND VPWR VPWR sky130_fd_sc_hd__decap_3
XTAP_TAPCELL_ROW_53_1582 VGND VPWR sky130_fd_sc_hd__tapvpwrvgnd_1
XFILLER_2_53 VGND VGND VPWR VPWR sky130_fd_sc_hd__decap_3
XFILLER_38_914 VGND VGND VPWR VPWR sky130_fd_sc_hd__decap_3
XFILLER_42_1267 VGND VGND VPWR VPWR sky130_fd_sc_hd__decap_3
XFILLER_38_947 VGND VGND VPWR VPWR sky130_fd_sc_hd__decap_3
XFILLER_49_284 VGND VGND VPWR VPWR sky130_fd_sc_hd__fill_2
XFILLER_2_97 VGND VGND VPWR VPWR sky130_fd_sc_hd__decap_3
XFILLER_77_1319 VGND VGND VPWR VPWR sky130_fd_sc_hd__decap_3
XFILLER_64_243 VGND VGND VPWR VPWR sky130_fd_sc_hd__decap_3
XFILLER_53_917 VGND VGND VPWR VPWR sky130_fd_sc_hd__decap_3
XTAP_TAPCELL_ROW_66_1910 VGND VPWR sky130_fd_sc_hd__tapvpwrvgnd_1
XFILLER_80_725 VGND VGND VPWR VPWR sky130_fd_sc_hd__decap_3
X_5981_ _5981_/A0 _6985_/Q _5989_/S VGND VGND VPWR VPWR _5981_/X sky130_fd_sc_hd__mux2_1
XFILLER_65_799 VGND VGND VPWR VPWR sky130_fd_sc_hd__decap_3
XTAP_TAPCELL_ROW_66_1921 VGND VPWR sky130_fd_sc_hd__tapvpwrvgnd_1
XFILLER_52_427 VGND VGND VPWR VPWR sky130_fd_sc_hd__decap_3
XFILLER_64_287 VGND VGND VPWR VPWR sky130_fd_sc_hd__decap_3
XFILLER_80_747 VGND VGND VPWR VPWR sky130_fd_sc_hd__decap_3
XFILLER_75_1032 VGND VGND VPWR VPWR sky130_fd_sc_hd__decap_3
X_4932_ _6380_/Q _5210_/B VGND VGND VPWR VPWR _4932_/X sky130_fd_sc_hd__or2_2
XFILLER_80_769 VGND VGND VPWR VPWR sky130_fd_sc_hd__decap_3
Xclkbuf_leaf_44_clk clkbuf_leaf_47_clk/A VGND VGND VPWR VPWR _6900_/CLK sky130_fd_sc_hd__clkbuf_8
XTAP_TAPCELL_ROW_62_1807 VGND VPWR sky130_fd_sc_hd__tapvpwrvgnd_1
XTAP_TAPCELL_ROW_23_809 VGND VPWR sky130_fd_sc_hd__tapvpwrvgnd_1
XFILLER_33_652 VGND VGND VPWR VPWR sky130_fd_sc_hd__fill_2
XTAP_TAPCELL_ROW_62_1818 VGND VPWR sky130_fd_sc_hd__tapvpwrvgnd_1
XFILLER_75_1065 VGND VGND VPWR VPWR sky130_fd_sc_hd__fill_2
XFILLER_36_1016 VGND VGND VPWR VPWR sky130_fd_sc_hd__decap_3
XFILLER_75_1087 VGND VGND VPWR VPWR sky130_fd_sc_hd__decap_3
X_4863_ _6338_/Q _4863_/A2 _4860_/X _4862_/X VGND VGND VPWR VPWR _6338_/D sky130_fd_sc_hd__o22a_2
XFILLER_60_460 VGND VGND VPWR VPWR sky130_fd_sc_hd__decap_3
XFILLER_33_685 VGND VGND VPWR VPWR sky130_fd_sc_hd__decap_3
X_6602_ _6617_/CLK _6602_/D fanout724/X VGND VGND VPWR VPWR _6602_/Q sky130_fd_sc_hd__dfrtp_2
XFILLER_18_1450 VGND VGND VPWR VPWR sky130_fd_sc_hd__decap_3
XANTENNA_14 _4562_/B VGND VGND VPWR VPWR sky130_fd_sc_hd__diode_2
XANTENNA_25 _5887_/S VGND VGND VPWR VPWR sky130_fd_sc_hd__diode_2
X_3814_ _4283_/A _4071_/B VGND VGND VPWR VPWR _3814_/Y sky130_fd_sc_hd__nand2_2
XFILLER_14_1303 VGND VGND VPWR VPWR sky130_fd_sc_hd__decap_3
XANTENNA_36 fanout47/X VGND VGND VPWR VPWR sky130_fd_sc_hd__diode_2
X_4794_ _6577_/Q _4879_/B VGND VGND VPWR VPWR _4794_/Y sky130_fd_sc_hd__nand2_2
XFILLER_53_1363 VGND VGND VPWR VPWR sky130_fd_sc_hd__decap_3
XANTENNA_47 _5739_/S VGND VGND VPWR VPWR sky130_fd_sc_hd__diode_2
XANTENNA_58 _5601_/B1 VGND VGND VPWR VPWR sky130_fd_sc_hd__diode_2
XFILLER_20_368 VGND VGND VPWR VPWR sky130_fd_sc_hd__fill_2
XANTENNA_69 _5579_/B2 VGND VGND VPWR VPWR sky130_fd_sc_hd__diode_2
X_6533_ _6910_/CLK _6533_/D load_slew784/X VGND VGND VPWR VPWR _6533_/Q sky130_fd_sc_hd__dfrtp_2
XFILLER_14_1347 VGND VGND VPWR VPWR sky130_fd_sc_hd__decap_3
XFILLER_21_18 VGND VGND VPWR VPWR sky130_fd_sc_hd__fill_2
XFILLER_53_1396 VGND VGND VPWR VPWR sky130_fd_sc_hd__decap_3
X_3745_ _6216_/Q _4081_/A2 _3742_/X _3744_/X VGND VGND VPWR VPWR _6216_/D sky130_fd_sc_hd__o22a_2
X_6464_ _7032_/CLK _6464_/D fanout689/X VGND VGND VPWR VPWR _6464_/Q sky130_fd_sc_hd__dfrtp_2
X_3676_ _3676_/A _3676_/B VGND VGND VPWR VPWR _3687_/B sky130_fd_sc_hd__xor2_2
XFILLER_12_1082 VGND VGND VPWR VPWR sky130_fd_sc_hd__fill_1
X_5415_ _5415_/A1 _5479_/A2 _4543_/X VGND VGND VPWR VPWR _6527_/D sky130_fd_sc_hd__a21o_2
X_6395_ _6765_/CLK _6395_/D wire641/X VGND VGND VPWR VPWR _6395_/Q sky130_fd_sc_hd__dfrtp_2
XFILLER_47_1101 VGND VGND VPWR VPWR sky130_fd_sc_hd__decap_3
X_5346_ _6804_/Q _5088_/B _5352_/S VGND VGND VPWR VPWR _5346_/X sky130_fd_sc_hd__mux2_1
XFILLER_0_707 VGND VGND VPWR VPWR sky130_fd_sc_hd__decap_3
XFILLER_0_729 VGND VGND VPWR VPWR sky130_fd_sc_hd__decap_3
X_5277_ _6772_/Q _5276_/A _5286_/B1 _5276_/Y VGND VGND VPWR VPWR _5277_/X sky130_fd_sc_hd__o211a_2
XFILLER_25_1410 VGND VGND VPWR VPWR sky130_fd_sc_hd__decap_3
XFILLER_47_1189 VGND VGND VPWR VPWR sky130_fd_sc_hd__decap_3
XFILLER_60_1312 VGND VGND VPWR VPWR sky130_fd_sc_hd__decap_3
XFILLER_75_508 VGND VGND VPWR VPWR sky130_fd_sc_hd__decap_3
X_7016_ _7016_/CLK _7016_/D fanout666/X VGND VGND VPWR VPWR _7016_/Q sky130_fd_sc_hd__dfrtp_2
XFILLER_25_1443 VGND VGND VPWR VPWR sky130_fd_sc_hd__decap_3
XFILLER_29_903 VGND VGND VPWR VPWR sky130_fd_sc_hd__decap_3
XFILLER_60_1323 VGND VGND VPWR VPWR sky130_fd_sc_hd__decap_3
X_4228_ _6259_/Q wire49/A _4225_/X _4227_/X VGND VGND VPWR VPWR _6259_/D sky130_fd_sc_hd__o22a_2
XFILLER_68_571 VGND VGND VPWR VPWR sky130_fd_sc_hd__fill_2
XFILLER_21_1307 VGND VGND VPWR VPWR sky130_fd_sc_hd__decap_3
XFILLER_60_1356 VGND VGND VPWR VPWR sky130_fd_sc_hd__decap_3
X_4159_ _6477_/Q _4586_/B _4265_/B VGND VGND VPWR VPWR _4159_/X sky130_fd_sc_hd__mux2_1
XFILLER_55_221 VGND VGND VPWR VPWR sky130_fd_sc_hd__decap_3
Xmax_cap27 _3670_/B VGND VGND VPWR VPWR _3755_/A sky130_fd_sc_hd__clkbuf_2
XFILLER_56_777 VGND VGND VPWR VPWR sky130_fd_sc_hd__fill_1
XFILLER_71_714 VGND VGND VPWR VPWR sky130_fd_sc_hd__decap_3
XFILLER_15_107 VGND VGND VPWR VPWR sky130_fd_sc_hd__decap_3
XFILLER_3_1272 VGND VGND VPWR VPWR sky130_fd_sc_hd__decap_3
XFILLER_55_276 VGND VGND VPWR VPWR sky130_fd_sc_hd__decap_3
XFILLER_37_991 VGND VGND VPWR VPWR sky130_fd_sc_hd__decap_3
XFILLER_58_1252 VGND VGND VPWR VPWR sky130_fd_sc_hd__decap_3
Xclkbuf_leaf_35_clk clkbuf_leaf_56_clk/A VGND VGND VPWR VPWR _7009_/CLK sky130_fd_sc_hd__clkbuf_8
XFILLER_19_1236 VGND VGND VPWR VPWR sky130_fd_sc_hd__decap_3
XFILLER_58_1285 VGND VGND VPWR VPWR sky130_fd_sc_hd__decap_3
XFILLER_51_460 VGND VGND VPWR VPWR sky130_fd_sc_hd__decap_3
XFILLER_23_162 VGND VGND VPWR VPWR sky130_fd_sc_hd__decap_3
XFILLER_19_1269 VGND VGND VPWR VPWR sky130_fd_sc_hd__decap_3
XFILLER_11_335 VGND VGND VPWR VPWR sky130_fd_sc_hd__fill_1
XFILLER_8_807 VGND VGND VPWR VPWR sky130_fd_sc_hd__decap_3
XFILLER_23_195 VGND VGND VPWR VPWR sky130_fd_sc_hd__decap_3
XFILLER_71_1452 VGND VGND VPWR VPWR sky130_fd_sc_hd__decap_3
XFILLER_12_869 VGND VGND VPWR VPWR sky130_fd_sc_hd__fill_2
XFILLER_11_346 VGND VGND VPWR VPWR sky130_fd_sc_hd__fill_1
XFILLER_32_1403 VGND VGND VPWR VPWR sky130_fd_sc_hd__decap_3
XFILLER_71_1463 VGND VGND VPWR VPWR sky130_fd_sc_hd__decap_3
XFILLER_32_1447 VGND VGND VPWR VPWR sky130_fd_sc_hd__decap_3
XFILLER_20_880 VGND VGND VPWR VPWR sky130_fd_sc_hd__fill_2
XFILLER_3_523 VGND VGND VPWR VPWR sky130_fd_sc_hd__decap_3
XFILLER_11_73 VGND VGND VPWR VPWR sky130_fd_sc_hd__decap_3
XFILLER_69_1381 VGND VGND VPWR VPWR sky130_fd_sc_hd__decap_3
XFILLER_3_556 VGND VGND VPWR VPWR sky130_fd_sc_hd__decap_3
XFILLER_3_567 VGND VGND VPWR VPWR sky130_fd_sc_hd__decap_3
XFILLER_65_1245 VGND VGND VPWR VPWR sky130_fd_sc_hd__decap_3
XFILLER_26_1229 VGND VGND VPWR VPWR sky130_fd_sc_hd__decap_3
XFILLER_65_1278 VGND VGND VPWR VPWR sky130_fd_sc_hd__decap_3
XFILLER_79_869 VGND VGND VPWR VPWR sky130_fd_sc_hd__decap_3
XFILLER_65_1289 VGND VGND VPWR VPWR sky130_fd_sc_hd__decap_3
XFILLER_78_357 VGND VGND VPWR VPWR sky130_fd_sc_hd__fill_1
XTAP_TAPCELL_ROW_6_350 VGND VPWR sky130_fd_sc_hd__tapvpwrvgnd_1
XTAP_TAPCELL_ROW_6_361 VGND VPWR sky130_fd_sc_hd__tapvpwrvgnd_1
XFILLER_8_1161 VGND VGND VPWR VPWR sky130_fd_sc_hd__decap_3
Xfanout370 _3491_/X VGND VGND VPWR VPWR _4312_/A sky130_fd_sc_hd__clkdlybuf4s25_1
Xfanout381 wire383/A VGND VGND VPWR VPWR _4780_/B2 sky130_fd_sc_hd__clkdlybuf4s25_1
Xfanout392 _4765_/B2 VGND VGND VPWR VPWR _4743_/B2 sky130_fd_sc_hd__clkdlybuf4s25_1
XFILLER_8_1194 VGND VGND VPWR VPWR sky130_fd_sc_hd__decap_3
XFILLER_46_221 VGND VGND VPWR VPWR sky130_fd_sc_hd__decap_3
XFILLER_47_766 VGND VGND VPWR VPWR sky130_fd_sc_hd__decap_3
XFILLER_34_416 VGND VGND VPWR VPWR sky130_fd_sc_hd__decap_3
XFILLER_62_736 VGND VGND VPWR VPWR sky130_fd_sc_hd__decap_3
XFILLER_59_1049 VGND VGND VPWR VPWR sky130_fd_sc_hd__fill_1
XTAP_TAPCELL_ROW_17_636 VGND VPWR sky130_fd_sc_hd__tapvpwrvgnd_1
XFILLER_76_1341 VGND VGND VPWR VPWR sky130_fd_sc_hd__decap_3
XFILLER_36_81 VGND VGND VPWR VPWR sky130_fd_sc_hd__decap_3
Xclkbuf_leaf_26_clk clkload3/A VGND VGND VPWR VPWR _7064_/CLK sky130_fd_sc_hd__clkbuf_8
XTAP_TAPCELL_ROW_17_647 VGND VPWR sky130_fd_sc_hd__tapvpwrvgnd_1
XFILLER_36_92 VGND VGND VPWR VPWR sky130_fd_sc_hd__decap_3
XFILLER_72_1205 VGND VGND VPWR VPWR sky130_fd_sc_hd__decap_3
XFILLER_37_1325 VGND VGND VPWR VPWR sky130_fd_sc_hd__decap_3
XFILLER_76_1385 VGND VGND VPWR VPWR sky130_fd_sc_hd__decap_3
XFILLER_30_600 VGND VGND VPWR VPWR sky130_fd_sc_hd__decap_3
XFILLER_61_279 VGND VGND VPWR VPWR sky130_fd_sc_hd__fill_1
XFILLER_72_1238 VGND VGND VPWR VPWR sky130_fd_sc_hd__decap_3
XFILLER_42_471 VGND VGND VPWR VPWR sky130_fd_sc_hd__decap_3
XFILLER_37_1369 VGND VGND VPWR VPWR sky130_fd_sc_hd__decap_3
Xinput12 uio_in[2] VGND VGND VPWR VPWR _7093_/D sky130_fd_sc_hd__clkdlybuf4s25_1
XTAP_TAPCELL_ROW_42_1283 VGND VPWR sky130_fd_sc_hd__tapvpwrvgnd_1
XTAP_TAPCELL_ROW_42_1294 VGND VPWR sky130_fd_sc_hd__tapvpwrvgnd_1
X_3530_ _6270_/Q _5600_/A2 _3533_/B1 _6254_/Q VGND VGND VPWR VPWR _3532_/A sky130_fd_sc_hd__a22o_2
X_3461_ _3461_/A0 _3460_/X _3461_/S VGND VGND VPWR VPWR _6204_/D sky130_fd_sc_hd__mux2_1
XFILLER_48_1421 VGND VGND VPWR VPWR sky130_fd_sc_hd__decap_3
X_5200_ _6408_/Q wire105/X _5199_/X VGND VGND VPWR VPWR _6408_/D sky130_fd_sc_hd__a21o_2
XFILLER_48_1432 VGND VGND VPWR VPWR sky130_fd_sc_hd__decap_3
XTAP_TAPCELL_ROW_55_1622 VGND VPWR sky130_fd_sc_hd__tapvpwrvgnd_1
XFILLER_42_3 VGND VGND VPWR VPWR sky130_fd_sc_hd__decap_3
X_3392_ _6315_/Q _6427_/Q VGND VGND VPWR VPWR _3392_/X sky130_fd_sc_hd__xor2_2
XTAP_TAPCELL_ROW_55_1633 VGND VPWR sky130_fd_sc_hd__tapvpwrvgnd_1
X_6180_ _6999_/CLK _6180_/D wire827/X VGND VGND VPWR VPWR _6180_/Q sky130_fd_sc_hd__dfrtp_2
XFILLER_48_1465 VGND VGND VPWR VPWR sky130_fd_sc_hd__decap_3
Xload_slew710 fanout709/X VGND VGND VPWR VPWR load_slew710/X sky130_fd_sc_hd__clkbuf_4
X_5131_ _5359_/B _5131_/B VGND VGND VPWR VPWR _5131_/X sky130_fd_sc_hd__or2_2
Xload_slew732 fanout731/X VGND VGND VPWR VPWR load_slew732/X sky130_fd_sc_hd__buf_2
XFILLER_44_1329 VGND VGND VPWR VPWR sky130_fd_sc_hd__decap_3
XTAP_TAPCELL_ROW_51_1519 VGND VPWR sky130_fd_sc_hd__tapvpwrvgnd_1
Xload_slew754 fanout753/X VGND VGND VPWR VPWR load_slew754/X sky130_fd_sc_hd__clkbuf_4
XTAP_TAPCELL_ROW_4_309 VGND VPWR sky130_fd_sc_hd__tapvpwrvgnd_1
X_5062_ _6366_/Q _5061_/X _5062_/S VGND VGND VPWR VPWR _6366_/D sky130_fd_sc_hd__mux2_1
Xhold1507 _6570_/Q VGND VGND VPWR VPWR _5458_/A1 sky130_fd_sc_hd__dlygate4sd3_1
Xhold1518 _6543_/Q VGND VGND VPWR VPWR _5431_/A1 sky130_fd_sc_hd__dlygate4sd3_1
Xhold1529 _6554_/Q VGND VGND VPWR VPWR _5442_/A1 sky130_fd_sc_hd__dlygate4sd3_1
X_4013_ _4013_/A _4013_/B _4013_/C VGND VGND VPWR VPWR _4013_/X sky130_fd_sc_hd__and3_2
XFILLER_80_500 VGND VGND VPWR VPWR sky130_fd_sc_hd__decap_3
XFILLER_77_1116 VGND VGND VPWR VPWR sky130_fd_sc_hd__decap_3
XFILLER_0_1401 VGND VGND VPWR VPWR sky130_fd_sc_hd__decap_3
XFILLER_25_405 VGND VGND VPWR VPWR sky130_fd_sc_hd__decap_3
XFILLER_26_928 VGND VGND VPWR VPWR sky130_fd_sc_hd__decap_3
XFILLER_37_265 VGND VGND VPWR VPWR sky130_fd_sc_hd__decap_3
XFILLER_77_1127 VGND VGND VPWR VPWR sky130_fd_sc_hd__decap_3
XFILLER_80_511 VGND VGND VPWR VPWR sky130_fd_sc_hd__decap_3
XFILLER_20_1362 VGND VGND VPWR VPWR sky130_fd_sc_hd__decap_3
XFILLER_37_287 VGND VGND VPWR VPWR sky130_fd_sc_hd__decap_3
XFILLER_80_533 VGND VGND VPWR VPWR sky130_fd_sc_hd__decap_3
XFILLER_20_1373 VGND VGND VPWR VPWR sky130_fd_sc_hd__decap_3
XFILLER_52_224 VGND VGND VPWR VPWR sky130_fd_sc_hd__decap_3
XFILLER_53_747 VGND VGND VPWR VPWR sky130_fd_sc_hd__decap_3
XFILLER_25_449 VGND VGND VPWR VPWR sky130_fd_sc_hd__fill_1
Xclkbuf_leaf_17_clk clkbuf_4_4__f_clk/X VGND VGND VPWR VPWR _7034_/CLK sky130_fd_sc_hd__clkbuf_8
X_5964_ _5964_/A0 _6968_/Q _6033_/S VGND VGND VPWR VPWR _5964_/X sky130_fd_sc_hd__mux2_1
XFILLER_52_268 VGND VGND VPWR VPWR sky130_fd_sc_hd__fill_1
XFILLER_55_1425 VGND VGND VPWR VPWR sky130_fd_sc_hd__decap_3
X_4915_ _6345_/Q _4914_/X _4915_/S VGND VGND VPWR VPWR _6345_/D sky130_fd_sc_hd__mux2_1
XFILLER_21_600 VGND VGND VPWR VPWR sky130_fd_sc_hd__decap_3
X_5895_ _5904_/A0 _5895_/A1 _5896_/S VGND VGND VPWR VPWR _6904_/D sky130_fd_sc_hd__mux2_1
XFILLER_16_1409 VGND VGND VPWR VPWR sky130_fd_sc_hd__decap_3
XFILLER_21_622 VGND VGND VPWR VPWR sky130_fd_sc_hd__fill_1
XFILLER_20_121 VGND VGND VPWR VPWR sky130_fd_sc_hd__decap_3
X_4846_ _4885_/B1 _4843_/X _4844_/Y _4845_/X _4889_/A VGND VGND VPWR VPWR _4846_/X
+ sky130_fd_sc_hd__o221a_2
XFILLER_18_1291 VGND VGND VPWR VPWR sky130_fd_sc_hd__decap_3
XFILLER_53_1171 VGND VGND VPWR VPWR sky130_fd_sc_hd__decap_3
XFILLER_14_1133 VGND VGND VPWR VPWR sky130_fd_sc_hd__decap_3
X_4777_ _4777_/A _4777_/B VGND VGND VPWR VPWR _4777_/Y sky130_fd_sc_hd__nor2_2
X_6516_ _6982_/CLK _6516_/D load_slew742/X VGND VGND VPWR VPWR _6516_/Q sky130_fd_sc_hd__dfrtp_2
XFILLER_10_1008 VGND VGND VPWR VPWR sky130_fd_sc_hd__decap_3
X_3728_ _3722_/A _6319_/Q VGND VGND VPWR VPWR _3728_/X sky130_fd_sc_hd__and2b_2
XFILLER_49_1207 VGND VGND VPWR VPWR sky130_fd_sc_hd__decap_3
X_6447_ _7041_/CLK _6447_/D load_slew726/X VGND VGND VPWR VPWR _6447_/Q sky130_fd_sc_hd__dfrtp_2
X_3659_ _3652_/C _3652_/D _3637_/B VGND VGND VPWR VPWR _3660_/B sky130_fd_sc_hd__a21o_2
X_6378_ _7019_/CLK _6378_/D fanout836/X VGND VGND VPWR VPWR _6378_/Q sky130_fd_sc_hd__dfrtp_2
XFILLER_0_526 VGND VGND VPWR VPWR sky130_fd_sc_hd__decap_3
X_5329_ _6457_/Q _5328_/X _5331_/S VGND VGND VPWR VPWR _6457_/D sky130_fd_sc_hd__mux2_1
XFILLER_62_1418 VGND VGND VPWR VPWR sky130_fd_sc_hd__decap_3
XFILLER_0_548 VGND VGND VPWR VPWR sky130_fd_sc_hd__decap_3
XFILLER_62_1429 VGND VGND VPWR VPWR sky130_fd_sc_hd__decap_3
XFILLER_5_1301 VGND VGND VPWR VPWR sky130_fd_sc_hd__decap_3
XFILLER_76_839 VGND VGND VPWR VPWR sky130_fd_sc_hd__fill_2
XFILLER_25_1251 VGND VGND VPWR VPWR sky130_fd_sc_hd__decap_3
XFILLER_5_1334 VGND VGND VPWR VPWR sky130_fd_sc_hd__decap_3
XFILLER_5_1345 VGND VGND VPWR VPWR sky130_fd_sc_hd__decap_3
XFILLER_25_1284 VGND VGND VPWR VPWR sky130_fd_sc_hd__decap_3
XFILLER_68_390 VGND VGND VPWR VPWR sky130_fd_sc_hd__fill_2
XFILLER_25_1295 VGND VGND VPWR VPWR sky130_fd_sc_hd__decap_3
XFILLER_5_1378 VGND VGND VPWR VPWR sky130_fd_sc_hd__decap_3
XFILLER_28_243 VGND VGND VPWR VPWR sky130_fd_sc_hd__fill_1
XFILLER_16_405 VGND VGND VPWR VPWR sky130_fd_sc_hd__decap_3
XTAP_TAPCELL_ROW_27_901 VGND VPWR sky130_fd_sc_hd__tapvpwrvgnd_1
XFILLER_29_788 VGND VGND VPWR VPWR sky130_fd_sc_hd__decap_3
XFILLER_71_500 VGND VGND VPWR VPWR sky130_fd_sc_hd__decap_3
XTAP_TAPCELL_ROW_27_912 VGND VPWR sky130_fd_sc_hd__tapvpwrvgnd_1
XFILLER_73_24 VGND VGND VPWR VPWR sky130_fd_sc_hd__decap_3
XFILLER_71_511 VGND VGND VPWR VPWR sky130_fd_sc_hd__decap_3
XFILLER_44_736 VGND VGND VPWR VPWR sky130_fd_sc_hd__decap_3
XFILLER_3_1080 VGND VGND VPWR VPWR sky130_fd_sc_hd__decap_3
XFILLER_73_57 VGND VGND VPWR VPWR sky130_fd_sc_hd__decap_3
Xwire80 wire80/A VGND VGND VPWR VPWR uo_out[2] sky130_fd_sc_hd__buf_4
XFILLER_31_408 VGND VGND VPWR VPWR sky130_fd_sc_hd__decap_3
XFILLER_58_1093 VGND VGND VPWR VPWR sky130_fd_sc_hd__decap_3
XFILLER_24_493 VGND VGND VPWR VPWR sky130_fd_sc_hd__decap_3
XFILLER_40_964 VGND VGND VPWR VPWR sky130_fd_sc_hd__fill_2
XFILLER_12_666 VGND VGND VPWR VPWR sky130_fd_sc_hd__fill_2
XFILLER_40_975 VGND VGND VPWR VPWR sky130_fd_sc_hd__decap_3
XFILLER_71_1260 VGND VGND VPWR VPWR sky130_fd_sc_hd__decap_3
XFILLER_36_1391 VGND VGND VPWR VPWR sky130_fd_sc_hd__decap_3
XFILLER_8_648 VGND VGND VPWR VPWR sky130_fd_sc_hd__fill_1
XFILLER_11_187 VGND VGND VPWR VPWR sky130_fd_sc_hd__fill_1
XFILLER_32_1244 VGND VGND VPWR VPWR sky130_fd_sc_hd__decap_3
XFILLER_22_50 VGND VGND VPWR VPWR sky130_fd_sc_hd__decap_3
XFILLER_32_1288 VGND VGND VPWR VPWR sky130_fd_sc_hd__decap_3
XFILLER_67_1307 VGND VGND VPWR VPWR sky130_fd_sc_hd__decap_3
XFILLER_4_843 VGND VGND VPWR VPWR sky130_fd_sc_hd__decap_3
XFILLER_79_600 VGND VGND VPWR VPWR sky130_fd_sc_hd__decap_3
XFILLER_3_364 VGND VGND VPWR VPWR sky130_fd_sc_hd__fill_2
XFILLER_3_375 VGND VGND VPWR VPWR sky130_fd_sc_hd__decap_3
XFILLER_3_386 VGND VGND VPWR VPWR sky130_fd_sc_hd__decap_3
XFILLER_26_1026 VGND VGND VPWR VPWR sky130_fd_sc_hd__decap_3
XFILLER_26_1048 VGND VGND VPWR VPWR sky130_fd_sc_hd__fill_1
XFILLER_65_1097 VGND VGND VPWR VPWR sky130_fd_sc_hd__decap_3
XFILLER_66_305 VGND VGND VPWR VPWR sky130_fd_sc_hd__decap_3
XFILLER_43_1340 VGND VGND VPWR VPWR sky130_fd_sc_hd__decap_3
XFILLER_43_1351 VGND VGND VPWR VPWR sky130_fd_sc_hd__decap_3
XFILLER_43_1384 VGND VGND VPWR VPWR sky130_fd_sc_hd__decap_3
XFILLER_59_390 VGND VGND VPWR VPWR sky130_fd_sc_hd__fill_2
XFILLER_75_850 VGND VGND VPWR VPWR sky130_fd_sc_hd__decap_3
XFILLER_47_541 VGND VGND VPWR VPWR sky130_fd_sc_hd__decap_3
XFILLER_78_1403 VGND VGND VPWR VPWR sky130_fd_sc_hd__decap_3
XFILLER_19_243 VGND VGND VPWR VPWR sky130_fd_sc_hd__fill_1
XFILLER_19_265 VGND VGND VPWR VPWR sky130_fd_sc_hd__decap_3
XFILLER_75_894 VGND VGND VPWR VPWR sky130_fd_sc_hd__fill_2
XFILLER_35_725 VGND VGND VPWR VPWR sky130_fd_sc_hd__decap_3
XFILLER_78_1447 VGND VGND VPWR VPWR sky130_fd_sc_hd__decap_3
XFILLER_35_747 VGND VGND VPWR VPWR sky130_fd_sc_hd__decap_3
XFILLER_74_393 VGND VGND VPWR VPWR sky130_fd_sc_hd__decap_3
XFILLER_34_235 VGND VGND VPWR VPWR sky130_fd_sc_hd__decap_3
XFILLER_16_961 VGND VGND VPWR VPWR sky130_fd_sc_hd__decap_3
XFILLER_15_460 VGND VGND VPWR VPWR sky130_fd_sc_hd__decap_3
XFILLER_22_419 VGND VGND VPWR VPWR sky130_fd_sc_hd__fill_1
XFILLER_76_1182 VGND VGND VPWR VPWR sky130_fd_sc_hd__decap_3
XFILLER_43_791 VGND VGND VPWR VPWR sky130_fd_sc_hd__decap_3
XTAP_TAPCELL_ROW_44_1334 VGND VPWR sky130_fd_sc_hd__tapvpwrvgnd_1
XFILLER_72_1035 VGND VGND VPWR VPWR sky130_fd_sc_hd__fill_1
X_4700_ _6894_/Q wire295/X _4876_/B1 _4699_/X VGND VGND VPWR VPWR _4700_/X sky130_fd_sc_hd__a211o_2
XTAP_TAPCELL_ROW_44_1345 VGND VPWR sky130_fd_sc_hd__tapvpwrvgnd_1
XFILLER_31_953 VGND VGND VPWR VPWR sky130_fd_sc_hd__decap_3
XTAP_TAPCELL_ROW_44_1356 VGND VPWR sky130_fd_sc_hd__tapvpwrvgnd_1
X_5680_ hold885/X _5910_/A0 wire90/A VGND VGND VPWR VPWR _6733_/D sky130_fd_sc_hd__mux2_1
XFILLER_37_1177 VGND VGND VPWR VPWR sky130_fd_sc_hd__decap_3
XFILLER_42_290 VGND VGND VPWR VPWR sky130_fd_sc_hd__decap_3
XFILLER_50_1300 VGND VGND VPWR VPWR sky130_fd_sc_hd__decap_3
XFILLER_8_41 VGND VGND VPWR VPWR sky130_fd_sc_hd__fill_1
XFILLER_30_463 VGND VGND VPWR VPWR sky130_fd_sc_hd__decap_3
XFILLER_15_1431 VGND VGND VPWR VPWR sky130_fd_sc_hd__decap_3
X_4631_ _4710_/A _4808_/B VGND VGND VPWR VPWR _4631_/Y sky130_fd_sc_hd__nor2_2
XFILLER_8_74 VGND VGND VPWR VPWR sky130_fd_sc_hd__decap_3
XFILLER_50_1344 VGND VGND VPWR VPWR sky130_fd_sc_hd__decap_3
X_4562_ _4586_/A _4562_/B _4562_/C _4586_/D VGND VGND VPWR VPWR _4562_/X sky130_fd_sc_hd__and4_2
XFILLER_11_1328 VGND VGND VPWR VPWR sky130_fd_sc_hd__decap_3
XFILLER_7_670 VGND VGND VPWR VPWR sky130_fd_sc_hd__fill_2
XFILLER_50_1388 VGND VGND VPWR VPWR sky130_fd_sc_hd__decap_3
X_6301_ _7007_/CLK _6301_/D fanout820/X VGND VGND VPWR VPWR _6301_/Q sky130_fd_sc_hd__dfrtp_2
X_3513_ _6276_/Q _6284_/Q _6292_/Q _6228_/Q _5505_/A _4420_/A VGND VGND VPWR VPWR
+ _3513_/X sky130_fd_sc_hd__mux4_2
X_4493_ _6858_/Q _4790_/A2 _4491_/X _4492_/X VGND VGND VPWR VPWR _4493_/X sky130_fd_sc_hd__a211o_2
Xmax_cap367 _3493_/Y VGND VGND VPWR VPWR _5579_/B2 sky130_fd_sc_hd__clkbuf_4
X_6232_ _7000_/CLK _6232_/D fanout693/X VGND VGND VPWR VPWR _6232_/Q sky130_fd_sc_hd__dfrtp_2
X_3444_ _6333_/Q _6453_/Q VGND VGND VPWR VPWR _3444_/X sky130_fd_sc_hd__xor2_2
Xclkbuf_leaf_6_clk clkload0/A VGND VGND VPWR VPWR _6986_/CLK sky130_fd_sc_hd__clkbuf_8
XFILLER_48_1251 VGND VGND VPWR VPWR sky130_fd_sc_hd__decap_3
XFILLER_48_1273 VGND VGND VPWR VPWR sky130_fd_sc_hd__decap_3
X_6163_ _7022_/CLK _6163_/D fanout750/X VGND VGND VPWR VPWR _6163_/Q sky130_fd_sc_hd__dfrtp_2
X_3375_ hold909/X _3374_/X _3453_/S VGND VGND VPWR VPWR _6161_/D sky130_fd_sc_hd__mux2_1
XFILLER_69_121 VGND VGND VPWR VPWR sky130_fd_sc_hd__decap_3
X_5114_ _5276_/A _5115_/B _5287_/A2 VGND VGND VPWR VPWR _5114_/X sky130_fd_sc_hd__a21o_2
Xload_slew562 _3222_/A VGND VGND VPWR VPWR _3172_/S sky130_fd_sc_hd__clkbuf_4
Xhold1304 _6911_/Q VGND VGND VPWR VPWR _5903_/A1 sky130_fd_sc_hd__dlygate4sd3_1
XFILLER_58_828 VGND VGND VPWR VPWR sky130_fd_sc_hd__decap_3
X_6094_ _7025_/CLK _6094_/D load_slew728/X VGND VGND VPWR VPWR _6094_/Q sky130_fd_sc_hd__dfrtp_2
XFILLER_61_1440 VGND VGND VPWR VPWR sky130_fd_sc_hd__decap_3
Xhold1315 _6890_/Q VGND VGND VPWR VPWR _5880_/A1 sky130_fd_sc_hd__dlygate4sd3_1
Xhold1326 _6569_/Q VGND VGND VPWR VPWR _5457_/A1 sky130_fd_sc_hd__dlygate4sd3_1
XFILLER_69_187 VGND VGND VPWR VPWR sky130_fd_sc_hd__decap_3
Xhold1337 _6920_/Q VGND VGND VPWR VPWR _5913_/A1 sky130_fd_sc_hd__dlygate4sd3_1
X_5045_ _6396_/Q _5258_/B _5052_/B1 VGND VGND VPWR VPWR _5045_/Y sky130_fd_sc_hd__a21oi_2
XFILLER_22_1424 VGND VGND VPWR VPWR sky130_fd_sc_hd__decap_3
Xhold1348 _6818_/Q VGND VGND VPWR VPWR _5788_/A1 sky130_fd_sc_hd__dlygate4sd3_1
XFILLER_57_349 VGND VGND VPWR VPWR sky130_fd_sc_hd__decap_3
XFILLER_22_1435 VGND VGND VPWR VPWR sky130_fd_sc_hd__decap_3
Xhold1359 _6507_/Q VGND VGND VPWR VPWR _5395_/A1 sky130_fd_sc_hd__dlygate4sd3_1
XFILLER_22_1468 VGND VGND VPWR VPWR sky130_fd_sc_hd__fill_1
XFILLER_25_213 VGND VGND VPWR VPWR sky130_fd_sc_hd__decap_3
XFILLER_0_1220 VGND VGND VPWR VPWR sky130_fd_sc_hd__decap_3
XFILLER_65_393 VGND VGND VPWR VPWR sky130_fd_sc_hd__decap_3
XFILLER_0_1242 VGND VGND VPWR VPWR sky130_fd_sc_hd__decap_3
XFILLER_20_1181 VGND VGND VPWR VPWR sky130_fd_sc_hd__decap_3
X_6996_ _7027_/CLK _6996_/D load_slew843/X VGND VGND VPWR VPWR _6996_/Q sky130_fd_sc_hd__dfrtp_2
XFILLER_0_1264 VGND VGND VPWR VPWR sky130_fd_sc_hd__decap_3
X_5947_ hold904/X hold958/X _6051_/S VGND VGND VPWR VPWR _6951_/D sky130_fd_sc_hd__mux2_1
XFILLER_34_780 VGND VGND VPWR VPWR sky130_fd_sc_hd__fill_1
XFILLER_55_1233 VGND VGND VPWR VPWR sky130_fd_sc_hd__decap_3
XFILLER_22_931 VGND VGND VPWR VPWR sky130_fd_sc_hd__decap_3
XFILLER_22_942 VGND VGND VPWR VPWR sky130_fd_sc_hd__decap_3
XFILLER_40_238 VGND VGND VPWR VPWR sky130_fd_sc_hd__decap_3
XFILLER_16_1217 VGND VGND VPWR VPWR sky130_fd_sc_hd__decap_3
XFILLER_55_1266 VGND VGND VPWR VPWR sky130_fd_sc_hd__decap_3
X_5878_ _5878_/A1 _5868_/Y _5915_/C _5801_/X VGND VGND VPWR VPWR _6889_/D sky130_fd_sc_hd__a22o_2
XFILLER_51_1108 VGND VGND VPWR VPWR sky130_fd_sc_hd__decap_3
XFILLER_21_452 VGND VGND VPWR VPWR sky130_fd_sc_hd__decap_3
X_4829_ _4829_/A _4829_/B VGND VGND VPWR VPWR _4829_/Y sky130_fd_sc_hd__nor2_2
XFILLER_21_496 VGND VGND VPWR VPWR sky130_fd_sc_hd__fill_1
XFILLER_5_629 VGND VGND VPWR VPWR sky130_fd_sc_hd__decap_3
XFILLER_4_128 VGND VGND VPWR VPWR sky130_fd_sc_hd__decap_3
XFILLER_49_1026 VGND VGND VPWR VPWR sky130_fd_sc_hd__decap_3
XTAP_TAPCELL_ROW_8_401 VGND VPWR sky130_fd_sc_hd__tapvpwrvgnd_1
XTAP_TAPCELL_ROW_8_412 VGND VPWR sky130_fd_sc_hd__tapvpwrvgnd_1
XFILLER_1_824 VGND VGND VPWR VPWR sky130_fd_sc_hd__decap_3
XFILLER_68_24 VGND VGND VPWR VPWR sky130_fd_sc_hd__decap_3
XFILLER_0_312 VGND VGND VPWR VPWR sky130_fd_sc_hd__decap_3
XFILLER_27_1313 VGND VGND VPWR VPWR sky130_fd_sc_hd__decap_3
XFILLER_66_1362 VGND VGND VPWR VPWR sky130_fd_sc_hd__decap_3
XFILLER_68_35 VGND VGND VPWR VPWR sky130_fd_sc_hd__decap_3
XFILLER_66_1373 VGND VGND VPWR VPWR sky130_fd_sc_hd__decap_3
XFILLER_7_1407 VGND VGND VPWR VPWR sky130_fd_sc_hd__decap_3
XFILLER_1_868 VGND VGND VPWR VPWR sky130_fd_sc_hd__decap_3
XFILLER_62_1226 VGND VGND VPWR VPWR sky130_fd_sc_hd__decap_3
XFILLER_68_68 VGND VGND VPWR VPWR sky130_fd_sc_hd__decap_3
XFILLER_76_603 VGND VGND VPWR VPWR sky130_fd_sc_hd__decap_3
XFILLER_27_1357 VGND VGND VPWR VPWR sky130_fd_sc_hd__decap_3
XFILLER_49_839 VGND VGND VPWR VPWR sky130_fd_sc_hd__fill_1
XFILLER_62_1259 VGND VGND VPWR VPWR sky130_fd_sc_hd__fill_1
XFILLER_0_389 VGND VGND VPWR VPWR sky130_fd_sc_hd__decap_3
XFILLER_75_113 VGND VGND VPWR VPWR sky130_fd_sc_hd__decap_3
XFILLER_5_1142 VGND VGND VPWR VPWR sky130_fd_sc_hd__decap_3
XFILLER_64_809 VGND VGND VPWR VPWR sky130_fd_sc_hd__decap_3
XFILLER_25_1081 VGND VGND VPWR VPWR sky130_fd_sc_hd__decap_3
XFILLER_5_1175 VGND VGND VPWR VPWR sky130_fd_sc_hd__fill_1
XFILLER_5_1186 VGND VGND VPWR VPWR sky130_fd_sc_hd__decap_3
XFILLER_1_1039 VGND VGND VPWR VPWR sky130_fd_sc_hd__decap_3
XFILLER_16_213 VGND VGND VPWR VPWR sky130_fd_sc_hd__decap_3
XFILLER_72_842 VGND VGND VPWR VPWR sky130_fd_sc_hd__fill_1
XFILLER_44_533 VGND VGND VPWR VPWR sky130_fd_sc_hd__decap_3
XFILLER_17_758 VGND VGND VPWR VPWR sky130_fd_sc_hd__decap_3
XFILLER_16_268 VGND VGND VPWR VPWR sky130_fd_sc_hd__fill_2
XFILLER_17_94 VGND VGND VPWR VPWR sky130_fd_sc_hd__fill_1
XFILLER_44_577 VGND VGND VPWR VPWR sky130_fd_sc_hd__decap_3
XFILLER_73_1322 VGND VGND VPWR VPWR sky130_fd_sc_hd__decap_3
XFILLER_71_396 VGND VGND VPWR VPWR sky130_fd_sc_hd__decap_3
XFILLER_25_791 VGND VGND VPWR VPWR sky130_fd_sc_hd__decap_3
XFILLER_38_1453 VGND VGND VPWR VPWR sky130_fd_sc_hd__decap_3
XTAP_TAPCELL_ROW_80_2268 VGND VPWR sky130_fd_sc_hd__tapvpwrvgnd_1
XTAP_TAPCELL_ROW_80_2279 VGND VPWR sky130_fd_sc_hd__tapvpwrvgnd_1
XFILLER_34_1306 VGND VGND VPWR VPWR sky130_fd_sc_hd__decap_3
XFILLER_13_953 VGND VGND VPWR VPWR sky130_fd_sc_hd__decap_3
XFILLER_12_430 VGND VGND VPWR VPWR sky130_fd_sc_hd__decap_3
XFILLER_73_1366 VGND VGND VPWR VPWR sky130_fd_sc_hd__decap_3
XFILLER_34_1317 VGND VGND VPWR VPWR sky130_fd_sc_hd__decap_3
XFILLER_8_401 VGND VGND VPWR VPWR sky130_fd_sc_hd__decap_3
XFILLER_33_60 VGND VGND VPWR VPWR sky130_fd_sc_hd__fill_2
XFILLER_73_1399 VGND VGND VPWR VPWR sky130_fd_sc_hd__fill_1
XFILLER_40_772 VGND VGND VPWR VPWR sky130_fd_sc_hd__decap_3
XFILLER_8_445 VGND VGND VPWR VPWR sky130_fd_sc_hd__decap_3
XFILLER_76_9 VGND VGND VPWR VPWR sky130_fd_sc_hd__decap_3
XFILLER_10_1350 VGND VGND VPWR VPWR sky130_fd_sc_hd__decap_3
XFILLER_4_673 VGND VGND VPWR VPWR sky130_fd_sc_hd__decap_3
XFILLER_10_1394 VGND VGND VPWR VPWR sky130_fd_sc_hd__decap_3
XFILLER_45_1413 VGND VGND VPWR VPWR sky130_fd_sc_hd__decap_3
XFILLER_80_1304 VGND VGND VPWR VPWR sky130_fd_sc_hd__decap_3
XFILLER_3_183 VGND VGND VPWR VPWR sky130_fd_sc_hd__decap_3
XTAP_TAPCELL_ROW_37_1160 VGND VPWR sky130_fd_sc_hd__tapvpwrvgnd_1
XFILLER_80_1326 VGND VGND VPWR VPWR sky130_fd_sc_hd__decap_3
XFILLER_79_452 VGND VGND VPWR VPWR sky130_fd_sc_hd__decap_3
XTAP_TAPCELL_ROW_37_1171 VGND VPWR sky130_fd_sc_hd__tapvpwrvgnd_1
XFILLER_45_1446 VGND VGND VPWR VPWR sky130_fd_sc_hd__decap_3
XFILLER_45_1457 VGND VGND VPWR VPWR sky130_fd_sc_hd__decap_3
X_3160_ _3217_/A _3160_/B _3160_/C VGND VGND VPWR VPWR _3160_/X sky130_fd_sc_hd__and3_2
XFILLER_80_1348 VGND VGND VPWR VPWR sky130_fd_sc_hd__decap_3
XFILLER_79_474 VGND VGND VPWR VPWR sky130_fd_sc_hd__fill_2
XFILLER_39_305 VGND VGND VPWR VPWR sky130_fd_sc_hd__decap_3
XFILLER_67_614 VGND VGND VPWR VPWR sky130_fd_sc_hd__fill_2
XTAP_TAPCELL_ROW_33_1046 VGND VPWR sky130_fd_sc_hd__tapvpwrvgnd_1
XTAP_TAPCELL_ROW_33_1057 VGND VPWR sky130_fd_sc_hd__tapvpwrvgnd_1
XFILLER_0_890 VGND VGND VPWR VPWR sky130_fd_sc_hd__decap_3
XTAP_TAPCELL_ROW_33_1068 VGND VPWR sky130_fd_sc_hd__tapvpwrvgnd_1
X_3091_ _3722_/A _6608_/Q VGND VGND VPWR VPWR _3092_/B sky130_fd_sc_hd__nand2_2
XFILLER_78_1200 VGND VGND VPWR VPWR sky130_fd_sc_hd__decap_3
XFILLER_48_872 VGND VGND VPWR VPWR sky130_fd_sc_hd__decap_3
XFILLER_78_1211 VGND VGND VPWR VPWR sky130_fd_sc_hd__decap_3
XFILLER_35_511 VGND VGND VPWR VPWR sky130_fd_sc_hd__decap_3
XFILLER_78_1244 VGND VGND VPWR VPWR sky130_fd_sc_hd__decap_3
XFILLER_75_691 VGND VGND VPWR VPWR sky130_fd_sc_hd__fill_1
XFILLER_47_393 VGND VGND VPWR VPWR sky130_fd_sc_hd__fill_1
X_6850_ _6986_/CLK _6850_/D load_slew650/X VGND VGND VPWR VPWR _6850_/Q sky130_fd_sc_hd__dfrtp_2
XFILLER_63_853 VGND VGND VPWR VPWR sky130_fd_sc_hd__decap_3
XFILLER_39_1217 VGND VGND VPWR VPWR sky130_fd_sc_hd__fill_2
XTAP_TAPCELL_ROW_46_1407 VGND VPWR sky130_fd_sc_hd__tapvpwrvgnd_1
XFILLER_74_1108 VGND VGND VPWR VPWR sky130_fd_sc_hd__decap_3
XFILLER_78_1288 VGND VGND VPWR VPWR sky130_fd_sc_hd__decap_3
XFILLER_39_1239 VGND VGND VPWR VPWR sky130_fd_sc_hd__decap_3
X_5801_ _5801_/A_N _5868_/B _5801_/C VGND VGND VPWR VPWR _5801_/X sky130_fd_sc_hd__and3b_2
XFILLER_63_897 VGND VGND VPWR VPWR sky130_fd_sc_hd__decap_3
XPHY_EDGE_ROW_8_Right_8 VGND VGND VPWR VPWR sky130_fd_sc_hd__decap_3
X_6781_ _7076_/CLK _6781_/D load_slew681/X VGND VGND VPWR VPWR _6781_/Q sky130_fd_sc_hd__dfrtp_2
XFILLER_50_536 VGND VGND VPWR VPWR sky130_fd_sc_hd__decap_3
X_3993_ _3485_/B _3990_/X _3991_/Y _3992_/X _4734_/C1 VGND VGND VPWR VPWR _3993_/X
+ sky130_fd_sc_hd__o221a_2
XFILLER_62_396 VGND VGND VPWR VPWR sky130_fd_sc_hd__decap_3
X_5732_ _5889_/A0 _5732_/A1 _5739_/S VGND VGND VPWR VPWR _6778_/D sky130_fd_sc_hd__mux2_1
XFILLER_52_1406 VGND VGND VPWR VPWR sky130_fd_sc_hd__decap_3
XFILLER_31_761 VGND VGND VPWR VPWR sky130_fd_sc_hd__fill_2
XFILLER_31_794 VGND VGND VPWR VPWR sky130_fd_sc_hd__decap_3
X_5663_ _5902_/A0 _5663_/A1 _5666_/S VGND VGND VPWR VPWR _6718_/D sky130_fd_sc_hd__mux2_1
XFILLER_30_282 VGND VGND VPWR VPWR sky130_fd_sc_hd__decap_3
X_4614_ _6882_/Q _4790_/A2 _4612_/X _4613_/X VGND VGND VPWR VPWR _4614_/X sky130_fd_sc_hd__a211o_2
XFILLER_15_1272 VGND VGND VPWR VPWR sky130_fd_sc_hd__decap_3
X_5594_ _5594_/A1 _5569_/Y _5601_/B1 _6666_/Q VGND VGND VPWR VPWR _6666_/D sky130_fd_sc_hd__a22o_2
X_4545_ _6865_/Q _4898_/A2 _4606_/B1 _4544_/X VGND VGND VPWR VPWR _4545_/X sky130_fd_sc_hd__a211o_2
XFILLER_50_1196 VGND VGND VPWR VPWR sky130_fd_sc_hd__decap_3
Xmax_cap142 _4241_/A VGND VGND VPWR VPWR _4171_/B sky130_fd_sc_hd__clkbuf_2
Xmax_cap164 _5593_/Y VGND VGND VPWR VPWR _5601_/B1 sky130_fd_sc_hd__buf_4
X_4476_ _4831_/A1 _4473_/X _4474_/Y _4475_/X _4831_/C1 VGND VGND VPWR VPWR _4476_/X
+ sky130_fd_sc_hd__o221a_2
X_6215_ _7092_/CLK _6215_/D load_slew677/X VGND VGND VPWR VPWR _7110_/A sky130_fd_sc_hd__dfrtp_2
X_3427_ hold927/X _3426_/X _3477_/S VGND VGND VPWR VPWR _6187_/D sky130_fd_sc_hd__mux2_1
XPHY_EDGE_ROW_39_Right_39 VGND VGND VPWR VPWR sky130_fd_sc_hd__decap_3
X_6146_ _7077_/CLK _6146_/D load_slew679/X VGND VGND VPWR VPWR _6146_/Q sky130_fd_sc_hd__dfrtp_2
X_3358_ _6298_/Q _6410_/Q VGND VGND VPWR VPWR _3358_/X sky130_fd_sc_hd__xor2_2
Xhold1101 _6149_/Q VGND VGND VPWR VPWR _5996_/A0 sky130_fd_sc_hd__dlygate4sd3_1
Xhold1112 _6150_/Q VGND VGND VPWR VPWR _5997_/A0 sky130_fd_sc_hd__dlygate4sd3_1
Xhold1123 _6707_/Q VGND VGND VPWR VPWR _5651_/A0 sky130_fd_sc_hd__dlygate4sd3_1
Xhold1134 _6815_/Q VGND VGND VPWR VPWR _5780_/A0 sky130_fd_sc_hd__dlygate4sd3_1
XFILLER_58_669 VGND VGND VPWR VPWR sky130_fd_sc_hd__fill_1
X_6077_ _6081_/A _6081_/B VGND VGND VPWR VPWR _6077_/Y sky130_fd_sc_hd__nand2_2
XFILLER_6_1462 VGND VGND VPWR VPWR sky130_fd_sc_hd__decap_3
XFILLER_22_1221 VGND VGND VPWR VPWR sky130_fd_sc_hd__decap_3
Xhold1145 _6698_/Q VGND VGND VPWR VPWR _5641_/A1 sky130_fd_sc_hd__dlygate4sd3_1
X_3289_ hold862/X _3288_/X _3353_/S VGND VGND VPWR VPWR _6118_/D sky130_fd_sc_hd__mux2_1
Xhold1156 _5946_/X VGND VGND VPWR VPWR _6950_/D sky130_fd_sc_hd__dlygate4sd3_1
XFILLER_61_1281 VGND VGND VPWR VPWR sky130_fd_sc_hd__decap_3
XFILLER_73_617 VGND VGND VPWR VPWR sky130_fd_sc_hd__decap_3
Xhold1167 _6052_/X VGND VGND VPWR VPWR _7056_/D sky130_fd_sc_hd__dlygate4sd3_1
XFILLER_2_1315 VGND VGND VPWR VPWR sky130_fd_sc_hd__fill_1
XFILLER_61_1292 VGND VGND VPWR VPWR sky130_fd_sc_hd__decap_3
XFILLER_72_105 VGND VGND VPWR VPWR sky130_fd_sc_hd__decap_3
Xhold1178 _6703_/Q VGND VGND VPWR VPWR _5646_/A1 sky130_fd_sc_hd__dlygate4sd3_1
X_5028_ _6458_/Q _6676_/Q VGND VGND VPWR VPWR _5029_/B sky130_fd_sc_hd__xor2_2
XFILLER_22_1254 VGND VGND VPWR VPWR sky130_fd_sc_hd__decap_3
XFILLER_26_500 VGND VGND VPWR VPWR sky130_fd_sc_hd__decap_3
XFILLER_2_1326 VGND VGND VPWR VPWR sky130_fd_sc_hd__decap_3
XFILLER_38_360 VGND VGND VPWR VPWR sky130_fd_sc_hd__decap_3
XFILLER_39_894 VGND VGND VPWR VPWR sky130_fd_sc_hd__fill_2
Xhold1189 _6751_/Q VGND VGND VPWR VPWR _5700_/A0 sky130_fd_sc_hd__dlygate4sd3_1
XFILLER_22_1276 VGND VGND VPWR VPWR sky130_fd_sc_hd__decap_3
XFILLER_2_1359 VGND VGND VPWR VPWR sky130_fd_sc_hd__decap_3
XFILLER_26_533 VGND VGND VPWR VPWR sky130_fd_sc_hd__decap_3
XFILLER_54_15 VGND VGND VPWR VPWR sky130_fd_sc_hd__decap_3
XFILLER_54_864 VGND VGND VPWR VPWR sky130_fd_sc_hd__decap_3
XTAP_TAPCELL_ROW_0_164 VGND VPWR sky130_fd_sc_hd__tapvpwrvgnd_1
XFILLER_54_875 VGND VGND VPWR VPWR sky130_fd_sc_hd__fill_2
XFILLER_57_1328 VGND VGND VPWR VPWR sky130_fd_sc_hd__decap_3
XTAP_TAPCELL_ROW_0_175 VGND VPWR sky130_fd_sc_hd__tapvpwrvgnd_1
XTAP_TAPCELL_ROW_0_186 VGND VPWR sky130_fd_sc_hd__tapvpwrvgnd_1
XFILLER_0_1061 VGND VGND VPWR VPWR sky130_fd_sc_hd__decap_3
XFILLER_41_514 VGND VGND VPWR VPWR sky130_fd_sc_hd__decap_3
XFILLER_54_897 VGND VGND VPWR VPWR sky130_fd_sc_hd__decap_3
XFILLER_13_216 VGND VGND VPWR VPWR sky130_fd_sc_hd__decap_3
XTAP_TAPCELL_ROW_0_197 VGND VPWR sky130_fd_sc_hd__tapvpwrvgnd_1
X_6979_ _6987_/CLK _6979_/D load_slew837/X VGND VGND VPWR VPWR _6979_/Q sky130_fd_sc_hd__dfrtp_2
XPHY_EDGE_ROW_48_Right_48 VGND VGND VPWR VPWR sky130_fd_sc_hd__decap_3
XFILLER_0_1083 VGND VGND VPWR VPWR sky130_fd_sc_hd__decap_3
XFILLER_55_1063 VGND VGND VPWR VPWR sky130_fd_sc_hd__fill_1
XFILLER_10_923 VGND VGND VPWR VPWR sky130_fd_sc_hd__fill_1
XFILLER_70_47 VGND VGND VPWR VPWR sky130_fd_sc_hd__decap_3
XFILLER_6_905 VGND VGND VPWR VPWR sky130_fd_sc_hd__decap_3
XFILLER_33_1372 VGND VGND VPWR VPWR sky130_fd_sc_hd__decap_3
XFILLER_5_426 VGND VGND VPWR VPWR sky130_fd_sc_hd__fill_2
XFILLER_79_12 VGND VGND VPWR VPWR sky130_fd_sc_hd__decap_3
XFILLER_68_1424 VGND VGND VPWR VPWR sky130_fd_sc_hd__decap_3
XFILLER_68_1435 VGND VGND VPWR VPWR sky130_fd_sc_hd__decap_3
XFILLER_79_45 VGND VGND VPWR VPWR sky130_fd_sc_hd__decap_3
XFILLER_29_1419 VGND VGND VPWR VPWR sky130_fd_sc_hd__decap_3
XFILLER_68_1468 VGND VGND VPWR VPWR sky130_fd_sc_hd__fill_1
XPHY_EDGE_ROW_57_Right_57 VGND VGND VPWR VPWR sky130_fd_sc_hd__decap_3
XFILLER_79_78 VGND VGND VPWR VPWR sky130_fd_sc_hd__decap_3
XFILLER_1_610 VGND VGND VPWR VPWR sky130_fd_sc_hd__decap_3
XTAP_TAPCELL_ROW_73_2094 VGND VPWR sky130_fd_sc_hd__tapvpwrvgnd_1
Xhold990 _6167_/Q VGND VGND VPWR VPWR hold990/X sky130_fd_sc_hd__dlygate4sd3_1
XFILLER_7_1204 VGND VGND VPWR VPWR sky130_fd_sc_hd__decap_3
XFILLER_0_131 VGND VGND VPWR VPWR sky130_fd_sc_hd__decap_3
XFILLER_1_654 VGND VGND VPWR VPWR sky130_fd_sc_hd__decap_3
XFILLER_27_1132 VGND VGND VPWR VPWR sky130_fd_sc_hd__decap_3
XFILLER_77_912 VGND VGND VPWR VPWR sky130_fd_sc_hd__decap_3
XFILLER_66_1192 VGND VGND VPWR VPWR sky130_fd_sc_hd__decap_3
XFILLER_0_153 VGND VGND VPWR VPWR sky130_fd_sc_hd__decap_3
XFILLER_1_676 VGND VGND VPWR VPWR sky130_fd_sc_hd__decap_3
XFILLER_7_1248 VGND VGND VPWR VPWR sky130_fd_sc_hd__decap_3
XFILLER_0_175 VGND VGND VPWR VPWR sky130_fd_sc_hd__decap_3
XFILLER_49_636 VGND VGND VPWR VPWR sky130_fd_sc_hd__decap_3
XFILLER_0_197 VGND VGND VPWR VPWR sky130_fd_sc_hd__decap_3
XFILLER_27_1198 VGND VGND VPWR VPWR sky130_fd_sc_hd__decap_3
XFILLER_77_978 VGND VGND VPWR VPWR sky130_fd_sc_hd__decap_3
XFILLER_62_1089 VGND VGND VPWR VPWR sky130_fd_sc_hd__decap_3
XFILLER_76_455 VGND VGND VPWR VPWR sky130_fd_sc_hd__decap_3
XFILLER_40_1332 VGND VGND VPWR VPWR sky130_fd_sc_hd__decap_3
XFILLER_17_500 VGND VGND VPWR VPWR sky130_fd_sc_hd__decap_3
XFILLER_17_511 VGND VGND VPWR VPWR sky130_fd_sc_hd__fill_1
XFILLER_29_371 VGND VGND VPWR VPWR sky130_fd_sc_hd__decap_3
XFILLER_40_1365 VGND VGND VPWR VPWR sky130_fd_sc_hd__decap_3
XFILLER_40_1376 VGND VGND VPWR VPWR sky130_fd_sc_hd__decap_3
XFILLER_45_831 VGND VGND VPWR VPWR sky130_fd_sc_hd__decap_3
XFILLER_29_393 VGND VGND VPWR VPWR sky130_fd_sc_hd__decap_3
XPHY_EDGE_ROW_66_Right_66 VGND VGND VPWR VPWR sky130_fd_sc_hd__decap_3
XFILLER_75_1428 VGND VGND VPWR VPWR sky130_fd_sc_hd__decap_3
XFILLER_45_897 VGND VGND VPWR VPWR sky130_fd_sc_hd__decap_3
XFILLER_73_1130 VGND VGND VPWR VPWR sky130_fd_sc_hd__decap_3
XFILLER_32_558 VGND VGND VPWR VPWR sky130_fd_sc_hd__decap_3
XFILLER_38_1261 VGND VGND VPWR VPWR sky130_fd_sc_hd__decap_3
XFILLER_73_1163 VGND VGND VPWR VPWR sky130_fd_sc_hd__decap_3
XFILLER_13_772 VGND VGND VPWR VPWR sky130_fd_sc_hd__decap_3
XFILLER_38_1294 VGND VGND VPWR VPWR sky130_fd_sc_hd__decap_3
XFILLER_34_1136 VGND VGND VPWR VPWR sky130_fd_sc_hd__decap_3
XFILLER_40_580 VGND VGND VPWR VPWR sky130_fd_sc_hd__decap_3
XFILLER_74_6 VGND VGND VPWR VPWR sky130_fd_sc_hd__decap_3
XFILLER_9_765 VGND VGND VPWR VPWR sky130_fd_sc_hd__fill_1
XFILLER_8_253 VGND VGND VPWR VPWR sky130_fd_sc_hd__fill_2
XFILLER_12_1412 VGND VGND VPWR VPWR sky130_fd_sc_hd__decap_3
XTAP_TAPCELL_ROW_10_450 VGND VPWR sky130_fd_sc_hd__tapvpwrvgnd_1
XFILLER_12_1456 VGND VGND VPWR VPWR sky130_fd_sc_hd__decap_3
XTAP_TAPCELL_ROW_10_461 VGND VPWR sky130_fd_sc_hd__tapvpwrvgnd_1
XTAP_TAPCELL_ROW_10_472 VGND VPWR sky130_fd_sc_hd__tapvpwrvgnd_1
XPHY_EDGE_ROW_75_Right_75 VGND VGND VPWR VPWR sky130_fd_sc_hd__decap_3
XTAP_TAPCELL_ROW_39_1211 VGND VPWR sky130_fd_sc_hd__tapvpwrvgnd_1
XTAP_TAPCELL_ROW_39_1222 VGND VPWR sky130_fd_sc_hd__tapvpwrvgnd_1
X_4330_ _6493_/Q _4330_/A2 _4325_/X _4329_/Y VGND VGND VPWR VPWR _4330_/X sky130_fd_sc_hd__o211a_2
XFILLER_5_42 VGND VGND VPWR VPWR sky130_fd_sc_hd__decap_3
XFILLER_4_470 VGND VGND VPWR VPWR sky130_fd_sc_hd__decap_3
XTAP_TAPCELL_ROW_35_1108 VGND VPWR sky130_fd_sc_hd__tapvpwrvgnd_1
XFILLER_10_1191 VGND VGND VPWR VPWR sky130_fd_sc_hd__decap_3
XFILLER_5_86 VGND VGND VPWR VPWR sky130_fd_sc_hd__decap_3
XTAP_TAPCELL_ROW_35_1119 VGND VPWR sky130_fd_sc_hd__tapvpwrvgnd_1
X_4261_ _6487_/Q _4261_/A2 _4896_/C1 _4260_/X VGND VGND VPWR VPWR _4261_/X sky130_fd_sc_hd__o211a_2
XFILLER_49_1390 VGND VGND VPWR VPWR sky130_fd_sc_hd__decap_3
X_6000_ _6000_/A0 _7004_/Q _6015_/S VGND VGND VPWR VPWR _6000_/X sky130_fd_sc_hd__mux2_1
X_3212_ _3212_/A1 _7033_/Q _7041_/Q _3107_/X VGND VGND VPWR VPWR _3212_/X sky130_fd_sc_hd__a22o_2
XFILLER_45_1254 VGND VGND VPWR VPWR sky130_fd_sc_hd__decap_3
XFILLER_80_1145 VGND VGND VPWR VPWR sky130_fd_sc_hd__decap_3
X_4192_ _4269_/A _4230_/B VGND VGND VPWR VPWR _4193_/B sky130_fd_sc_hd__xor2_2
XFILLER_68_934 VGND VGND VPWR VPWR sky130_fd_sc_hd__decap_3
XFILLER_80_1167 VGND VGND VPWR VPWR sky130_fd_sc_hd__decap_3
XFILLER_41_1118 VGND VGND VPWR VPWR sky130_fd_sc_hd__fill_2
XFILLER_45_1287 VGND VGND VPWR VPWR sky130_fd_sc_hd__fill_1
X_3143_ _6948_/Q _6956_/Q _3149_/S VGND VGND VPWR VPWR _3143_/X sky130_fd_sc_hd__mux2_1
XFILLER_41_1129 VGND VGND VPWR VPWR sky130_fd_sc_hd__decap_3
XFILLER_45_1298 VGND VGND VPWR VPWR sky130_fd_sc_hd__decap_3
XFILLER_80_1189 VGND VGND VPWR VPWR sky130_fd_sc_hd__decap_3
XFILLER_68_989 VGND VGND VPWR VPWR sky130_fd_sc_hd__decap_3
XFILLER_55_617 VGND VGND VPWR VPWR sky130_fd_sc_hd__fill_2
X_3074_ _5306_/S VGND VGND VPWR VPWR _3074_/Y sky130_fd_sc_hd__inv_2
XFILLER_67_488 VGND VGND VPWR VPWR sky130_fd_sc_hd__decap_3
X_6902_ _7063_/CLK _6902_/D fanout776/X VGND VGND VPWR VPWR _6902_/Q sky130_fd_sc_hd__dfrtp_2
XTAP_TAPCELL_ROW_69_1985 VGND VPWR sky130_fd_sc_hd__tapvpwrvgnd_1
XFILLER_35_352 VGND VGND VPWR VPWR sky130_fd_sc_hd__decap_3
XTAP_TAPCELL_ROW_69_1996 VGND VPWR sky130_fd_sc_hd__tapvpwrvgnd_1
XFILLER_78_1085 VGND VGND VPWR VPWR sky130_fd_sc_hd__decap_3
X_6833_ _6993_/CLK _6833_/D load_slew710/X VGND VGND VPWR VPWR _6833_/Q sky130_fd_sc_hd__dfrtp_2
XFILLER_51_823 VGND VGND VPWR VPWR sky130_fd_sc_hd__decap_3
XFILLER_78_1096 VGND VGND VPWR VPWR sky130_fd_sc_hd__decap_3
XFILLER_1_1381 VGND VGND VPWR VPWR sky130_fd_sc_hd__decap_3
XFILLER_24_18 VGND VGND VPWR VPWR sky130_fd_sc_hd__fill_2
XFILLER_35_396 VGND VGND VPWR VPWR sky130_fd_sc_hd__decap_3
XFILLER_17_1301 VGND VGND VPWR VPWR sky130_fd_sc_hd__decap_3
XFILLER_56_1350 VGND VGND VPWR VPWR sky130_fd_sc_hd__decap_3
XFILLER_11_709 VGND VGND VPWR VPWR sky130_fd_sc_hd__decap_3
X_6764_ _7020_/CLK _6764_/D fanout806/X VGND VGND VPWR VPWR _6764_/Q sky130_fd_sc_hd__dfrtp_2
XFILLER_51_878 VGND VGND VPWR VPWR sky130_fd_sc_hd__decap_3
XFILLER_52_1203 VGND VGND VPWR VPWR sky130_fd_sc_hd__fill_1
X_3976_ _3342_/X _4743_/B2 _4744_/A2 _6868_/Q _4068_/C1 VGND VGND VPWR VPWR _3976_/X
+ sky130_fd_sc_hd__a221o_2
XFILLER_17_1334 VGND VGND VPWR VPWR sky130_fd_sc_hd__decap_3
XFILLER_17_1345 VGND VGND VPWR VPWR sky130_fd_sc_hd__decap_3
XFILLER_56_1394 VGND VGND VPWR VPWR sky130_fd_sc_hd__decap_3
X_5715_ _5908_/A0 _5715_/A1 wire88/X VGND VGND VPWR VPWR _6763_/D sky130_fd_sc_hd__mux2_1
X_6695_ _6991_/CLK _6695_/D load_slew792/X VGND VGND VPWR VPWR _6695_/Q sky130_fd_sc_hd__dfrtp_2
XTAP_TAPCELL_ROW_21_737 VGND VPWR sky130_fd_sc_hd__tapvpwrvgnd_1
XFILLER_13_1209 VGND VGND VPWR VPWR sky130_fd_sc_hd__decap_3
XFILLER_17_1378 VGND VGND VPWR VPWR sky130_fd_sc_hd__decap_3
XTAP_TAPCELL_ROW_21_748 VGND VPWR sky130_fd_sc_hd__tapvpwrvgnd_1
XFILLER_52_1258 VGND VGND VPWR VPWR sky130_fd_sc_hd__fill_2
XTAP_TAPCELL_ROW_21_759 VGND VPWR sky130_fd_sc_hd__tapvpwrvgnd_1
X_5646_ _5797_/C _5646_/A1 wire92/X VGND VGND VPWR VPWR _6703_/D sky130_fd_sc_hd__mux2_1
X_5577_ _5577_/A _5577_/B VGND VGND VPWR VPWR _5578_/A sky130_fd_sc_hd__nand2_2
XFILLER_2_407 VGND VGND VPWR VPWR sky130_fd_sc_hd__decap_3
X_4528_ _4683_/A _4528_/B _4528_/C VGND VGND VPWR VPWR _4528_/X sky130_fd_sc_hd__and3_2
XFILLER_6_9 VGND VGND VPWR VPWR sky130_fd_sc_hd__decap_3
X_4459_ _4312_/B _6516_/Q _4480_/S VGND VGND VPWR VPWR _4459_/X sky130_fd_sc_hd__mux2_1
XFILLER_63_1310 VGND VGND VPWR VPWR sky130_fd_sc_hd__decap_3
Xfanout711 fanout713/X VGND VGND VPWR VPWR wire712/A sky130_fd_sc_hd__clkdlybuf4s25_1
XFILLER_28_1441 VGND VGND VPWR VPWR sky130_fd_sc_hd__decap_3
Xfanout722 fanout724/X VGND VGND VPWR VPWR fanout722/X sky130_fd_sc_hd__clkdlybuf4s25_1
Xfanout733 fanout739/X VGND VGND VPWR VPWR wire734/A sky130_fd_sc_hd__clkdlybuf4s25_1
XFILLER_63_1343 VGND VGND VPWR VPWR sky130_fd_sc_hd__fill_1
XFILLER_63_1354 VGND VGND VPWR VPWR sky130_fd_sc_hd__decap_3
Xfanout755 fanout758/X VGND VGND VPWR VPWR fanout755/X sky130_fd_sc_hd__clkdlybuf4s25_1
Xfanout766 fanout779/A VGND VGND VPWR VPWR fanout766/X sky130_fd_sc_hd__clkdlybuf4s25_1
X_6129_ _6988_/CLK _6129_/D load_slew813/X VGND VGND VPWR VPWR _6129_/Q sky130_fd_sc_hd__dfrtp_2
XFILLER_24_1338 VGND VGND VPWR VPWR sky130_fd_sc_hd__decap_3
Xfanout777 fanout779/X VGND VGND VPWR VPWR fanout777/X sky130_fd_sc_hd__clkdlybuf4s25_1
XFILLER_63_1387 VGND VGND VPWR VPWR sky130_fd_sc_hd__decap_3
Xfanout788 fanout790/X VGND VGND VPWR VPWR fanout788/X sky130_fd_sc_hd__clkdlybuf4s25_1
XFILLER_58_477 VGND VGND VPWR VPWR sky130_fd_sc_hd__fill_1
XFILLER_6_1270 VGND VGND VPWR VPWR sky130_fd_sc_hd__decap_3
XFILLER_22_1040 VGND VGND VPWR VPWR sky130_fd_sc_hd__decap_3
XFILLER_45_116 VGND VGND VPWR VPWR sky130_fd_sc_hd__fill_2
XFILLER_2_1123 VGND VGND VPWR VPWR sky130_fd_sc_hd__decap_3
XFILLER_65_69 VGND VGND VPWR VPWR sky130_fd_sc_hd__decap_3
XFILLER_2_1167 VGND VGND VPWR VPWR sky130_fd_sc_hd__decap_3
XFILLER_27_886 VGND VGND VPWR VPWR sky130_fd_sc_hd__decap_3
XFILLER_26_374 VGND VGND VPWR VPWR sky130_fd_sc_hd__fill_2
XFILLER_42_834 VGND VGND VPWR VPWR sky130_fd_sc_hd__fill_1
XFILLER_26_396 VGND VGND VPWR VPWR sky130_fd_sc_hd__decap_3
XFILLER_53_182 VGND VGND VPWR VPWR sky130_fd_sc_hd__decap_3
XFILLER_57_1169 VGND VGND VPWR VPWR sky130_fd_sc_hd__decap_3
XFILLER_74_1450 VGND VGND VPWR VPWR sky130_fd_sc_hd__decap_3
XFILLER_14_558 VGND VGND VPWR VPWR sky130_fd_sc_hd__decap_3
XFILLER_35_1401 VGND VGND VPWR VPWR sky130_fd_sc_hd__decap_3
XFILLER_42_867 VGND VGND VPWR VPWR sky130_fd_sc_hd__fill_1
XFILLER_70_1303 VGND VGND VPWR VPWR sky130_fd_sc_hd__decap_3
XFILLER_35_1434 VGND VGND VPWR VPWR sky130_fd_sc_hd__decap_3
XFILLER_70_1347 VGND VGND VPWR VPWR sky130_fd_sc_hd__decap_3
XFILLER_10_720 VGND VGND VPWR VPWR sky130_fd_sc_hd__decap_3
XFILLER_10_742 VGND VGND VPWR VPWR sky130_fd_sc_hd__decap_3
XFILLER_6_713 VGND VGND VPWR VPWR sky130_fd_sc_hd__fill_2
XTAP_TAPCELL_ROW_75_2145 VGND VPWR sky130_fd_sc_hd__tapvpwrvgnd_1
XTAP_TAPCELL_ROW_75_2156 VGND VPWR sky130_fd_sc_hd__tapvpwrvgnd_1
XFILLER_68_1232 VGND VGND VPWR VPWR sky130_fd_sc_hd__decap_3
XFILLER_29_1205 VGND VGND VPWR VPWR sky130_fd_sc_hd__fill_1
XFILLER_68_1276 VGND VGND VPWR VPWR sky130_fd_sc_hd__decap_3
XFILLER_2_952 VGND VGND VPWR VPWR sky130_fd_sc_hd__decap_3
XFILLER_64_1129 VGND VGND VPWR VPWR sky130_fd_sc_hd__decap_3
XFILLER_1_440 VGND VGND VPWR VPWR sky130_fd_sc_hd__decap_3
XFILLER_39_9 VGND VGND VPWR VPWR sky130_fd_sc_hd__decap_3
XFILLER_2_996 VGND VGND VPWR VPWR sky130_fd_sc_hd__decap_3
XFILLER_1_484 VGND VGND VPWR VPWR sky130_fd_sc_hd__decap_3
XFILLER_49_422 VGND VGND VPWR VPWR sky130_fd_sc_hd__decap_3
XFILLER_42_1427 VGND VGND VPWR VPWR sky130_fd_sc_hd__fill_1
XFILLER_42_1438 VGND VGND VPWR VPWR sky130_fd_sc_hd__decap_3
XFILLER_77_775 VGND VGND VPWR VPWR sky130_fd_sc_hd__decap_3
XFILLER_37_617 VGND VGND VPWR VPWR sky130_fd_sc_hd__decap_3
XFILLER_65_926 VGND VGND VPWR VPWR sky130_fd_sc_hd__decap_3
XFILLER_7_1089 VGND VGND VPWR VPWR sky130_fd_sc_hd__decap_3
XFILLER_49_488 VGND VGND VPWR VPWR sky130_fd_sc_hd__decap_3
XFILLER_49_499 VGND VGND VPWR VPWR sky130_fd_sc_hd__decap_3
XFILLER_64_436 VGND VGND VPWR VPWR sky130_fd_sc_hd__decap_3
XFILLER_40_1173 VGND VGND VPWR VPWR sky130_fd_sc_hd__decap_3
XFILLER_29_190 VGND VGND VPWR VPWR sky130_fd_sc_hd__decap_3
XFILLER_64_469 VGND VGND VPWR VPWR sky130_fd_sc_hd__decap_3
XFILLER_79_1372 VGND VGND VPWR VPWR sky130_fd_sc_hd__decap_3
XFILLER_51_108 VGND VGND VPWR VPWR sky130_fd_sc_hd__decap_3
XFILLER_75_1225 VGND VGND VPWR VPWR sky130_fd_sc_hd__decap_3
XFILLER_75_1236 VGND VGND VPWR VPWR sky130_fd_sc_hd__decap_3
XFILLER_72_480 VGND VGND VPWR VPWR sky130_fd_sc_hd__fill_1
XFILLER_44_182 VGND VGND VPWR VPWR sky130_fd_sc_hd__fill_2
XFILLER_75_1269 VGND VGND VPWR VPWR sky130_fd_sc_hd__decap_3
XFILLER_60_642 VGND VGND VPWR VPWR sky130_fd_sc_hd__fill_2
X_3830_ _3830_/A _3830_/B VGND VGND VPWR VPWR _3830_/Y sky130_fd_sc_hd__xnor2_2
XFILLER_33_878 VGND VGND VPWR VPWR sky130_fd_sc_hd__decap_3
XTAP_TAPCELL_ROW_64_1860 VGND VPWR sky130_fd_sc_hd__tapvpwrvgnd_1
XTAP_TAPCELL_ROW_64_1871 VGND VPWR sky130_fd_sc_hd__tapvpwrvgnd_1
XFILLER_60_697 VGND VGND VPWR VPWR sky130_fd_sc_hd__decap_3
XTAP_TAPCELL_ROW_15_586 VGND VPWR sky130_fd_sc_hd__tapvpwrvgnd_1
X_3761_ _3789_/A _3789_/B VGND VGND VPWR VPWR _3763_/A sky130_fd_sc_hd__nor2_2
XFILLER_20_539 VGND VGND VPWR VPWR sky130_fd_sc_hd__decap_3
XFILLER_32_399 VGND VGND VPWR VPWR sky130_fd_sc_hd__decap_3
XTAP_TAPCELL_ROW_15_597 VGND VPWR sky130_fd_sc_hd__tapvpwrvgnd_1
XTAP_TAPCELL_ROW_60_1757 VGND VPWR sky130_fd_sc_hd__tapvpwrvgnd_1
X_5500_ _5500_/A1 _5498_/A _5499_/Y _7082_/Q VGND VGND VPWR VPWR _6603_/D sky130_fd_sc_hd__a22o_2
XTAP_TAPCELL_ROW_60_1768 VGND VPWR sky130_fd_sc_hd__tapvpwrvgnd_1
Xtt_um_aes128_optimized_858 VGND VGND VPWR VPWR uio_oe[5] tt_um_aes128_optimized_858/LO
+ sky130_fd_sc_hd__conb_1
XFILLER_72_3 VGND VGND VPWR VPWR sky130_fd_sc_hd__decap_3
X_6480_ _6888_/CLK _6480_/D fanout704/X VGND VGND VPWR VPWR _6480_/Q sky130_fd_sc_hd__dfrtp_2
X_3692_ _3648_/X wire26/X _3748_/A VGND VGND VPWR VPWR _3692_/X sky130_fd_sc_hd__a21o_2
XFILLER_12_1220 VGND VGND VPWR VPWR sky130_fd_sc_hd__decap_3
XFILLER_9_595 VGND VGND VPWR VPWR sky130_fd_sc_hd__fill_2
X_5431_ _5431_/A1 _5487_/A2 _4604_/X VGND VGND VPWR VPWR _6543_/D sky130_fd_sc_hd__a21o_2
XFILLER_12_1253 VGND VGND VPWR VPWR sky130_fd_sc_hd__decap_3
XFILLER_12_1264 VGND VGND VPWR VPWR sky130_fd_sc_hd__decap_3
X_5362_ _5362_/A1 _5461_/A2 _4135_/X VGND VGND VPWR VPWR _6474_/D sky130_fd_sc_hd__a21o_2
XFILLER_12_1297 VGND VGND VPWR VPWR sky130_fd_sc_hd__decap_3
XFILLER_47_1316 VGND VGND VPWR VPWR sky130_fd_sc_hd__decap_3
X_4313_ _4723_/B wire154/X _4694_/C _4267_/X _6492_/Q VGND VGND VPWR VPWR _4313_/X
+ sky130_fd_sc_hd__a32o_2
XTAP_TAPCELL_ROW_58_1697 VGND VPWR sky130_fd_sc_hd__tapvpwrvgnd_1
X_5293_ _6439_/Q _5293_/A2 _5292_/X VGND VGND VPWR VPWR _6439_/D sky130_fd_sc_hd__a21o_2
X_7032_ _7032_/CLK _7032_/D fanout697/X VGND VGND VPWR VPWR _7032_/Q sky130_fd_sc_hd__dfrtp_2
X_4244_ _4859_/C1 _4239_/X _4243_/X VGND VGND VPWR VPWR _4244_/X sky130_fd_sc_hd__o21a_2
XFILLER_68_731 VGND VGND VPWR VPWR sky130_fd_sc_hd__decap_3
XFILLER_45_1073 VGND VGND VPWR VPWR sky130_fd_sc_hd__decap_3
X_4175_ _5358_/C _4169_/X _4174_/X VGND VGND VPWR VPWR _4175_/X sky130_fd_sc_hd__o21a_2
XFILLER_56_915 VGND VGND VPWR VPWR sky130_fd_sc_hd__decap_3
XFILLER_3_1410 VGND VGND VPWR VPWR sky130_fd_sc_hd__decap_3
XFILLER_27_105 VGND VGND VPWR VPWR sky130_fd_sc_hd__decap_3
X_3126_ _3149_/S _7011_/Q _7019_/Q _7075_/Q _3193_/A1 VGND VGND VPWR VPWR _3126_/X
+ sky130_fd_sc_hd__o221a_2
XFILLER_23_1360 VGND VGND VPWR VPWR sky130_fd_sc_hd__decap_3
XTAP_TAPCELL_ROW_2_248 VGND VPWR sky130_fd_sc_hd__tapvpwrvgnd_1
XFILLER_67_296 VGND VGND VPWR VPWR sky130_fd_sc_hd__decap_3
XFILLER_3_1443 VGND VGND VPWR VPWR sky130_fd_sc_hd__decap_3
XTAP_TAPCELL_ROW_2_259 VGND VPWR sky130_fd_sc_hd__tapvpwrvgnd_1
XFILLER_23_1393 VGND VGND VPWR VPWR sky130_fd_sc_hd__decap_3
X_3057_ _6353_/Q VGND VGND VPWR VPWR _3057_/Y sky130_fd_sc_hd__inv_2
XFILLER_71_929 VGND VGND VPWR VPWR sky130_fd_sc_hd__fill_1
XFILLER_58_1412 VGND VGND VPWR VPWR sky130_fd_sc_hd__decap_3
XFILLER_35_39 VGND VGND VPWR VPWR sky130_fd_sc_hd__decap_3
XFILLER_64_970 VGND VGND VPWR VPWR sky130_fd_sc_hd__fill_2
XFILLER_19_1407 VGND VGND VPWR VPWR sky130_fd_sc_hd__decap_3
XFILLER_51_620 VGND VGND VPWR VPWR sky130_fd_sc_hd__decap_3
XFILLER_58_1456 VGND VGND VPWR VPWR sky130_fd_sc_hd__decap_3
XFILLER_23_333 VGND VGND VPWR VPWR sky130_fd_sc_hd__decap_3
XFILLER_54_1309 VGND VGND VPWR VPWR sky130_fd_sc_hd__decap_3
X_6816_ _7073_/CLK _6816_/D fanout675/X VGND VGND VPWR VPWR _6816_/Q sky130_fd_sc_hd__dfrtp_2
XFILLER_50_141 VGND VGND VPWR VPWR sky130_fd_sc_hd__fill_1
XFILLER_51_697 VGND VGND VPWR VPWR sky130_fd_sc_hd__decap_3
XFILLER_23_399 VGND VGND VPWR VPWR sky130_fd_sc_hd__decap_3
X_6747_ _7027_/CLK _6747_/D load_slew845/X VGND VGND VPWR VPWR _6747_/Q sky130_fd_sc_hd__dfrtp_2
X_3959_ _4444_/A _3957_/X _3958_/Y _6528_/Q VGND VGND VPWR VPWR _3959_/X sky130_fd_sc_hd__a2bb2o_2
Xwire419 _3108_/A VGND VGND VPWR VPWR wire419/X sky130_fd_sc_hd__buf_4
XFILLER_17_1175 VGND VGND VPWR VPWR sky130_fd_sc_hd__fill_1
X_6678_ _7054_/CLK _6678_/D load_slew754/X VGND VGND VPWR VPWR _6678_/Q sky130_fd_sc_hd__dfrtp_2
XFILLER_30_1320 VGND VGND VPWR VPWR sky130_fd_sc_hd__decap_3
X_5629_ _5658_/B _5703_/B VGND VGND VPWR VPWR _5685_/C sky130_fd_sc_hd__nor2_2
XFILLER_30_1353 VGND VGND VPWR VPWR sky130_fd_sc_hd__decap_3
XFILLER_3_738 VGND VGND VPWR VPWR sky130_fd_sc_hd__decap_3
XFILLER_2_215 VGND VGND VPWR VPWR sky130_fd_sc_hd__decap_3
XFILLER_30_1397 VGND VGND VPWR VPWR sky130_fd_sc_hd__decap_3
XFILLER_65_1416 VGND VGND VPWR VPWR sky130_fd_sc_hd__decap_3
XFILLER_4_6 VGND VGND VPWR VPWR sky130_fd_sc_hd__decap_3
XTAP_TAPCELL_ROW_70_2020 VGND VPWR sky130_fd_sc_hd__tapvpwrvgnd_1
XFILLER_2_248 VGND VGND VPWR VPWR sky130_fd_sc_hd__decap_3
XTAP_TAPCELL_ROW_70_2031 VGND VPWR sky130_fd_sc_hd__tapvpwrvgnd_1
XFILLER_65_1449 VGND VGND VPWR VPWR sky130_fd_sc_hd__decap_3
XFILLER_78_528 VGND VGND VPWR VPWR sky130_fd_sc_hd__decap_3
XFILLER_8_1332 VGND VGND VPWR VPWR sky130_fd_sc_hd__decap_3
Xfanout530 fanout535/X VGND VGND VPWR VPWR _5354_/S sky130_fd_sc_hd__clkdlybuf4s25_1
XFILLER_76_24 VGND VGND VPWR VPWR sky130_fd_sc_hd__decap_3
Xfanout541 _5352_/S VGND VGND VPWR VPWR _5210_/A sky130_fd_sc_hd__clkdlybuf4s25_1
XFILLER_76_35 VGND VGND VPWR VPWR sky130_fd_sc_hd__decap_3
XFILLER_28_1282 VGND VGND VPWR VPWR sky130_fd_sc_hd__decap_3
Xfanout552 _5304_/S VGND VGND VPWR VPWR _5298_/S sky130_fd_sc_hd__clkdlybuf4s25_1
XFILLER_58_230 VGND VGND VPWR VPWR sky130_fd_sc_hd__fill_1
Xfanout563 _7074_/Q VGND VGND VPWR VPWR _3203_/S sky130_fd_sc_hd__clkdlybuf4s25_1
XFILLER_8_1365 VGND VGND VPWR VPWR sky130_fd_sc_hd__decap_3
Xfanout574 _5517_/B2 VGND VGND VPWR VPWR _4010_/A sky130_fd_sc_hd__clkdlybuf4s25_1
XFILLER_8_1376 VGND VGND VPWR VPWR sky130_fd_sc_hd__decap_3
XFILLER_76_68 VGND VGND VPWR VPWR sky130_fd_sc_hd__decap_3
XFILLER_74_701 VGND VGND VPWR VPWR sky130_fd_sc_hd__decap_3
XFILLER_19_617 VGND VGND VPWR VPWR sky130_fd_sc_hd__decap_3
Xfanout585 _4420_/A VGND VGND VPWR VPWR _4386_/A sky130_fd_sc_hd__clkdlybuf4s25_1
XFILLER_4_1229 VGND VGND VPWR VPWR sky130_fd_sc_hd__decap_3
XFILLER_74_723 VGND VGND VPWR VPWR sky130_fd_sc_hd__decap_3
XFILLER_41_1460 VGND VGND VPWR VPWR sky130_fd_sc_hd__decap_3
XFILLER_18_138 VGND VGND VPWR VPWR sky130_fd_sc_hd__fill_2
XFILLER_27_661 VGND VGND VPWR VPWR sky130_fd_sc_hd__decap_3
XFILLER_15_812 VGND VGND VPWR VPWR sky130_fd_sc_hd__decap_3
XFILLER_54_480 VGND VGND VPWR VPWR sky130_fd_sc_hd__fill_1
XFILLER_72_1409 VGND VGND VPWR VPWR sky130_fd_sc_hd__decap_3
XFILLER_42_642 VGND VGND VPWR VPWR sky130_fd_sc_hd__fill_2
XTAP_TAPCELL_ROW_25_840 VGND VPWR sky130_fd_sc_hd__tapvpwrvgnd_1
XTAP_TAPCELL_ROW_25_851 VGND VPWR sky130_fd_sc_hd__tapvpwrvgnd_1
XFILLER_15_889 VGND VGND VPWR VPWR sky130_fd_sc_hd__decap_3
XTAP_TAPCELL_ROW_25_862 VGND VPWR sky130_fd_sc_hd__tapvpwrvgnd_1
XFILLER_14_377 VGND VGND VPWR VPWR sky130_fd_sc_hd__decap_3
XTAP_TAPCELL_ROW_12_501 VGND VPWR sky130_fd_sc_hd__tapvpwrvgnd_1
XTAP_TAPCELL_ROW_12_512 VGND VPWR sky130_fd_sc_hd__tapvpwrvgnd_1
XFILLER_74_1291 VGND VGND VPWR VPWR sky130_fd_sc_hd__decap_3
XFILLER_35_1242 VGND VGND VPWR VPWR sky130_fd_sc_hd__decap_3
XTAP_TAPCELL_ROW_12_523 VGND VPWR sky130_fd_sc_hd__tapvpwrvgnd_1
XFILLER_41_196 VGND VGND VPWR VPWR sky130_fd_sc_hd__decap_3
XFILLER_70_1144 VGND VGND VPWR VPWR sky130_fd_sc_hd__decap_3
XTAP_TAPCELL_ROW_77_2207 VGND VPWR sky130_fd_sc_hd__tapvpwrvgnd_1
XFILLER_70_1155 VGND VGND VPWR VPWR sky130_fd_sc_hd__decap_3
XFILLER_35_1275 VGND VGND VPWR VPWR sky130_fd_sc_hd__decap_3
XFILLER_10_561 VGND VGND VPWR VPWR sky130_fd_sc_hd__decap_3
XFILLER_6_510 VGND VGND VPWR VPWR sky130_fd_sc_hd__decap_3
XFILLER_70_1188 VGND VGND VPWR VPWR sky130_fd_sc_hd__decap_3
XFILLER_6_554 VGND VGND VPWR VPWR sky130_fd_sc_hd__fill_1
XFILLER_41_93 VGND VGND VPWR VPWR sky130_fd_sc_hd__decap_3
XFILLER_6_565 VGND VGND VPWR VPWR sky130_fd_sc_hd__fill_1
XFILLER_68_1062 VGND VGND VPWR VPWR sky130_fd_sc_hd__decap_3
XFILLER_2_760 VGND VGND VPWR VPWR sky130_fd_sc_hd__decap_3
XFILLER_69_517 VGND VGND VPWR VPWR sky130_fd_sc_hd__fill_1
XFILLER_37_6 VGND VGND VPWR VPWR sky130_fd_sc_hd__decap_3
XFILLER_2_782 VGND VGND VPWR VPWR sky130_fd_sc_hd__decap_3
XFILLER_1_270 VGND VGND VPWR VPWR sky130_fd_sc_hd__decap_3
XFILLER_1_281 VGND VGND VPWR VPWR sky130_fd_sc_hd__decap_3
XFILLER_2_21 VGND VGND VPWR VPWR sky130_fd_sc_hd__decap_3
XFILLER_46_1371 VGND VGND VPWR VPWR sky130_fd_sc_hd__fill_1
XFILLER_2_32 VGND VGND VPWR VPWR sky130_fd_sc_hd__decap_3
XFILLER_46_1382 VGND VGND VPWR VPWR sky130_fd_sc_hd__decap_3
XTAP_TAPCELL_ROW_53_1572 VGND VPWR sky130_fd_sc_hd__tapvpwrvgnd_1
XTAP_TAPCELL_ROW_53_1583 VGND VPWR sky130_fd_sc_hd__tapvpwrvgnd_1
XFILLER_77_561 VGND VGND VPWR VPWR sky130_fd_sc_hd__decap_3
XFILLER_42_1246 VGND VGND VPWR VPWR sky130_fd_sc_hd__decap_3
XFILLER_2_65 VGND VGND VPWR VPWR sky130_fd_sc_hd__decap_3
XFILLER_64_200 VGND VGND VPWR VPWR sky130_fd_sc_hd__decap_3
XFILLER_77_594 VGND VGND VPWR VPWR sky130_fd_sc_hd__decap_3
XFILLER_42_1279 VGND VGND VPWR VPWR sky130_fd_sc_hd__decap_3
XFILLER_37_436 VGND VGND VPWR VPWR sky130_fd_sc_hd__decap_3
XFILLER_49_296 VGND VGND VPWR VPWR sky130_fd_sc_hd__decap_3
XFILLER_37_458 VGND VGND VPWR VPWR sky130_fd_sc_hd__decap_3
XFILLER_80_704 VGND VGND VPWR VPWR sky130_fd_sc_hd__decap_3
X_5980_ _5980_/A0 _6984_/Q _6044_/S VGND VGND VPWR VPWR _5980_/X sky130_fd_sc_hd__mux2_1
XTAP_TAPCELL_ROW_66_1911 VGND VPWR sky130_fd_sc_hd__tapvpwrvgnd_1
XFILLER_24_108 VGND VGND VPWR VPWR sky130_fd_sc_hd__decap_3
XFILLER_46_981 VGND VGND VPWR VPWR sky130_fd_sc_hd__decap_3
XTAP_TAPCELL_ROW_66_1922 VGND VPWR sky130_fd_sc_hd__tapvpwrvgnd_1
XFILLER_79_1180 VGND VGND VPWR VPWR sky130_fd_sc_hd__decap_3
XFILLER_18_683 VGND VGND VPWR VPWR sky130_fd_sc_hd__decap_3
XFILLER_46_992 VGND VGND VPWR VPWR sky130_fd_sc_hd__fill_2
X_4931_ _6412_/Q _4931_/B VGND VGND VPWR VPWR _5210_/B sky130_fd_sc_hd__xnor2_2
XFILLER_33_620 VGND VGND VPWR VPWR sky130_fd_sc_hd__decap_3
XFILLER_64_299 VGND VGND VPWR VPWR sky130_fd_sc_hd__decap_3
XFILLER_33_642 VGND VGND VPWR VPWR sky130_fd_sc_hd__decap_3
XFILLER_75_1055 VGND VGND VPWR VPWR sky130_fd_sc_hd__fill_1
XTAP_TAPCELL_ROW_62_1808 VGND VPWR sky130_fd_sc_hd__tapvpwrvgnd_1
XTAP_TAPCELL_ROW_62_1819 VGND VPWR sky130_fd_sc_hd__tapvpwrvgnd_1
X_4862_ _6924_/Q _4862_/A2 _4862_/B1 _4861_/X VGND VGND VPWR VPWR _4862_/X sky130_fd_sc_hd__a211o_2
XFILLER_32_141 VGND VGND VPWR VPWR sky130_fd_sc_hd__fill_1
XFILLER_20_303 VGND VGND VPWR VPWR sky130_fd_sc_hd__decap_3
XFILLER_61_995 VGND VGND VPWR VPWR sky130_fd_sc_hd__fill_2
X_6601_ _6617_/CLK _6601_/D fanout722/X VGND VGND VPWR VPWR _6601_/Q sky130_fd_sc_hd__dfrtp_2
XFILLER_75_1099 VGND VGND VPWR VPWR sky130_fd_sc_hd__decap_3
X_3813_ _4210_/A _3813_/B VGND VGND VPWR VPWR _4071_/B sky130_fd_sc_hd__xnor2_2
XFILLER_53_1331 VGND VGND VPWR VPWR sky130_fd_sc_hd__decap_3
XFILLER_32_185 VGND VGND VPWR VPWR sky130_fd_sc_hd__decap_3
XANTENNA_15 _4562_/B VGND VGND VPWR VPWR sky130_fd_sc_hd__diode_2
XFILLER_18_1462 VGND VGND VPWR VPWR sky130_fd_sc_hd__decap_3
XANTENNA_26 _5887_/S VGND VGND VPWR VPWR sky130_fd_sc_hd__diode_2
X_4793_ _4793_/A _4793_/B VGND VGND VPWR VPWR _4796_/B sky130_fd_sc_hd__nor2_2
XANTENNA_37 fanout47/X VGND VGND VPWR VPWR sky130_fd_sc_hd__diode_2
XFILLER_14_1315 VGND VGND VPWR VPWR sky130_fd_sc_hd__fill_1
XANTENNA_48 _5840_/S VGND VGND VPWR VPWR sky130_fd_sc_hd__diode_2
XFILLER_14_1326 VGND VGND VPWR VPWR sky130_fd_sc_hd__decap_3
XFILLER_53_1375 VGND VGND VPWR VPWR sky130_fd_sc_hd__decap_3
X_6532_ _7001_/CLK _6532_/D load_slew769/X VGND VGND VPWR VPWR _6532_/Q sky130_fd_sc_hd__dfrtp_2
XANTENNA_59 _5601_/B1 VGND VGND VPWR VPWR sky130_fd_sc_hd__diode_2
X_3744_ _3274_/X _4080_/A2 _4080_/B1 _6834_/Q _4080_/C1 VGND VGND VPWR VPWR _3744_/X
+ sky130_fd_sc_hd__a221o_2
XFILLER_14_1359 VGND VGND VPWR VPWR sky130_fd_sc_hd__decap_3
X_6463_ _6993_/CLK _6463_/D load_slew707/X VGND VGND VPWR VPWR _6463_/Q sky130_fd_sc_hd__dfrtp_2
X_3675_ _3676_/A _3676_/B VGND VGND VPWR VPWR _3693_/C sky130_fd_sc_hd__xnor2_2
XFILLER_12_1061 VGND VGND VPWR VPWR sky130_fd_sc_hd__decap_3
X_5414_ _5414_/A1 _5478_/A2 _4536_/X VGND VGND VPWR VPWR _6526_/D sky130_fd_sc_hd__a21o_2
X_6394_ _7020_/CLK _6394_/D load_slew808/X VGND VGND VPWR VPWR _6394_/Q sky130_fd_sc_hd__dfrtp_2
X_5345_ _6465_/Q _5344_/X _5345_/S VGND VGND VPWR VPWR _6465_/D sky130_fd_sc_hd__mux2_1
XFILLER_0_719 VGND VGND VPWR VPWR sky130_fd_sc_hd__decap_3
X_5276_ _5276_/A _5276_/B VGND VGND VPWR VPWR _5276_/Y sky130_fd_sc_hd__nand2_2
XFILLER_25_1422 VGND VGND VPWR VPWR sky130_fd_sc_hd__decap_3
X_7015_ _7015_/CLK _7015_/D fanout793/X VGND VGND VPWR VPWR _7015_/Q sky130_fd_sc_hd__dfrtp_2
X_4227_ _6821_/Q _4869_/A2 _4869_/B1 _4226_/X VGND VGND VPWR VPWR _4227_/X sky130_fd_sc_hd__a211o_2
XFILLER_25_1455 VGND VGND VPWR VPWR sky130_fd_sc_hd__fill_1
XFILLER_60_1335 VGND VGND VPWR VPWR sky130_fd_sc_hd__decap_3
XFILLER_25_1466 VGND VGND VPWR VPWR sky130_fd_sc_hd__decap_3
XFILLER_28_403 VGND VGND VPWR VPWR sky130_fd_sc_hd__decap_3
XFILLER_56_712 VGND VGND VPWR VPWR sky130_fd_sc_hd__fill_1
XFILLER_29_937 VGND VGND VPWR VPWR sky130_fd_sc_hd__decap_3
XFILLER_21_1319 VGND VGND VPWR VPWR sky130_fd_sc_hd__decap_3
X_4158_ _6252_/Q wire60/A _4155_/X _4157_/X VGND VGND VPWR VPWR _6252_/D sky130_fd_sc_hd__o22a_2
XFILLER_56_734 VGND VGND VPWR VPWR sky130_fd_sc_hd__fill_1
XFILLER_60_1368 VGND VGND VPWR VPWR sky130_fd_sc_hd__decap_3
XFILLER_60_1379 VGND VGND VPWR VPWR sky130_fd_sc_hd__decap_3
XFILLER_28_458 VGND VGND VPWR VPWR sky130_fd_sc_hd__decap_3
XFILLER_44_907 VGND VGND VPWR VPWR sky130_fd_sc_hd__decap_3
X_3109_ _6978_/Q _6986_/Q _6075_/S VGND VGND VPWR VPWR _3109_/X sky130_fd_sc_hd__mux2_1
XFILLER_3_1251 VGND VGND VPWR VPWR sky130_fd_sc_hd__decap_3
X_4089_ _4762_/B wire69/X VGND VGND VPWR VPWR _4089_/Y sky130_fd_sc_hd__nor2_2
XFILLER_71_726 VGND VGND VPWR VPWR sky130_fd_sc_hd__fill_2
XFILLER_3_1284 VGND VGND VPWR VPWR sky130_fd_sc_hd__decap_3
XFILLER_3_1295 VGND VGND VPWR VPWR sky130_fd_sc_hd__decap_3
XFILLER_58_1231 VGND VGND VPWR VPWR sky130_fd_sc_hd__decap_3
XFILLER_36_480 VGND VGND VPWR VPWR sky130_fd_sc_hd__decap_3
XFILLER_52_951 VGND VGND VPWR VPWR sky130_fd_sc_hd__fill_1
XFILLER_58_1264 VGND VGND VPWR VPWR sky130_fd_sc_hd__decap_3
XFILLER_70_247 VGND VGND VPWR VPWR sky130_fd_sc_hd__decap_3
XFILLER_19_1226 VGND VGND VPWR VPWR sky130_fd_sc_hd__decap_3
XFILLER_54_1106 VGND VGND VPWR VPWR sky130_fd_sc_hd__decap_3
XFILLER_19_1248 VGND VGND VPWR VPWR sky130_fd_sc_hd__decap_3
XFILLER_58_1297 VGND VGND VPWR VPWR sky130_fd_sc_hd__decap_3
XFILLER_51_472 VGND VGND VPWR VPWR sky130_fd_sc_hd__decap_3
XFILLER_52_995 VGND VGND VPWR VPWR sky130_fd_sc_hd__decap_3
XFILLER_11_314 VGND VGND VPWR VPWR sky130_fd_sc_hd__decap_3
XFILLER_71_1431 VGND VGND VPWR VPWR sky130_fd_sc_hd__decap_3
XFILLER_7_307 VGND VGND VPWR VPWR sky130_fd_sc_hd__fill_1
XFILLER_32_1415 VGND VGND VPWR VPWR sky130_fd_sc_hd__decap_3
XFILLER_20_892 VGND VGND VPWR VPWR sky130_fd_sc_hd__decap_3
XFILLER_32_1459 VGND VGND VPWR VPWR sky130_fd_sc_hd__decap_3
XFILLER_11_52 VGND VGND VPWR VPWR sky130_fd_sc_hd__decap_3
XFILLER_69_1360 VGND VGND VPWR VPWR sky130_fd_sc_hd__decap_3
XFILLER_11_85 VGND VGND VPWR VPWR sky130_fd_sc_hd__decap_3
XFILLER_3_546 VGND VGND VPWR VPWR sky130_fd_sc_hd__fill_2
XFILLER_65_1213 VGND VGND VPWR VPWR sky130_fd_sc_hd__decap_3
XFILLER_2_3 VGND VGND VPWR VPWR sky130_fd_sc_hd__decap_3
XFILLER_69_1393 VGND VGND VPWR VPWR sky130_fd_sc_hd__decap_3
XFILLER_3_579 VGND VGND VPWR VPWR sky130_fd_sc_hd__fill_1
XFILLER_65_1257 VGND VGND VPWR VPWR sky130_fd_sc_hd__decap_3
XTAP_TAPCELL_ROW_6_351 VGND VPWR sky130_fd_sc_hd__tapvpwrvgnd_1
XTAP_TAPCELL_ROW_6_362 VGND VPWR sky130_fd_sc_hd__tapvpwrvgnd_1
Xfanout360 _3496_/X VGND VGND VPWR VPWR _5610_/A1 sky130_fd_sc_hd__clkdlybuf4s25_1
XFILLER_8_1173 VGND VGND VPWR VPWR sky130_fd_sc_hd__decap_3
Xfanout371 _4832_/B2 VGND VGND VPWR VPWR _4115_/B2 sky130_fd_sc_hd__clkdlybuf4s25_1
XFILLER_59_561 VGND VGND VPWR VPWR sky130_fd_sc_hd__decap_3
Xfanout382 fanout395/X VGND VGND VPWR VPWR wire383/A sky130_fd_sc_hd__clkdlybuf4s25_1
Xfanout393 _4735_/B2 VGND VGND VPWR VPWR _4765_/B2 sky130_fd_sc_hd__clkdlybuf4s25_1
XFILLER_19_425 VGND VGND VPWR VPWR sky130_fd_sc_hd__decap_3
XFILLER_4_1037 VGND VGND VPWR VPWR sky130_fd_sc_hd__decap_3
XFILLER_62_715 VGND VGND VPWR VPWR sky130_fd_sc_hd__decap_3
XFILLER_46_266 VGND VGND VPWR VPWR sky130_fd_sc_hd__decap_3
XFILLER_76_1320 VGND VGND VPWR VPWR sky130_fd_sc_hd__decap_3
XFILLER_34_439 VGND VGND VPWR VPWR sky130_fd_sc_hd__decap_3
XFILLER_46_299 VGND VGND VPWR VPWR sky130_fd_sc_hd__decap_3
XFILLER_62_748 VGND VGND VPWR VPWR sky130_fd_sc_hd__decap_3
XTAP_TAPCELL_ROW_17_637 VGND VPWR sky130_fd_sc_hd__tapvpwrvgnd_1
XTAP_TAPCELL_ROW_17_648 VGND VPWR sky130_fd_sc_hd__tapvpwrvgnd_1
XFILLER_61_236 VGND VGND VPWR VPWR sky130_fd_sc_hd__decap_3
XFILLER_76_1353 VGND VGND VPWR VPWR sky130_fd_sc_hd__decap_3
XFILLER_37_1304 VGND VGND VPWR VPWR sky130_fd_sc_hd__decap_3
XFILLER_43_951 VGND VGND VPWR VPWR sky130_fd_sc_hd__fill_1
XFILLER_15_653 VGND VGND VPWR VPWR sky130_fd_sc_hd__decap_3
XFILLER_43_962 VGND VGND VPWR VPWR sky130_fd_sc_hd__decap_3
XFILLER_72_1217 VGND VGND VPWR VPWR sky130_fd_sc_hd__decap_3
XFILLER_14_141 VGND VGND VPWR VPWR sky130_fd_sc_hd__decap_3
XFILLER_37_1337 VGND VGND VPWR VPWR sky130_fd_sc_hd__decap_3
XFILLER_76_1397 VGND VGND VPWR VPWR sky130_fd_sc_hd__decap_3
XFILLER_37_1348 VGND VGND VPWR VPWR sky130_fd_sc_hd__decap_3
XFILLER_30_645 VGND VGND VPWR VPWR sky130_fd_sc_hd__decap_3
XFILLER_35_1050 VGND VGND VPWR VPWR sky130_fd_sc_hd__decap_3
Xinput13 uio_in[3] VGND VGND VPWR VPWR _7094_/D sky130_fd_sc_hd__clkdlybuf4s25_1
XTAP_TAPCELL_ROW_42_1284 VGND VPWR sky130_fd_sc_hd__tapvpwrvgnd_1
XFILLER_11_892 VGND VGND VPWR VPWR sky130_fd_sc_hd__decap_3
XFILLER_7_841 VGND VGND VPWR VPWR sky130_fd_sc_hd__decap_3
XTAP_TAPCELL_ROW_42_1295 VGND VPWR sky130_fd_sc_hd__tapvpwrvgnd_1
XFILLER_10_391 VGND VGND VPWR VPWR sky130_fd_sc_hd__fill_2
XFILLER_13_1381 VGND VGND VPWR VPWR sky130_fd_sc_hd__decap_3
X_3460_ _6341_/Q _6461_/Q VGND VGND VPWR VPWR _3460_/X sky130_fd_sc_hd__xor2_2
XFILLER_48_1400 VGND VGND VPWR VPWR sky130_fd_sc_hd__decap_3
XTAP_TAPCELL_ROW_55_1623 VGND VPWR sky130_fd_sc_hd__tapvpwrvgnd_1
X_3391_ hold878/X _3390_/X _3455_/S VGND VGND VPWR VPWR _6169_/D sky130_fd_sc_hd__mux2_1
XFILLER_48_1444 VGND VGND VPWR VPWR sky130_fd_sc_hd__decap_3
XTAP_TAPCELL_ROW_55_1634 VGND VPWR sky130_fd_sc_hd__tapvpwrvgnd_1
Xload_slew700 fanout699/X VGND VGND VPWR VPWR load_slew700/X sky130_fd_sc_hd__buf_4
X_5130_ _5219_/A _5131_/B _5221_/A2 VGND VGND VPWR VPWR _5130_/X sky130_fd_sc_hd__a21o_2
XFILLER_35_3 VGND VGND VPWR VPWR sky130_fd_sc_hd__decap_3
Xload_slew744 fanout743/X VGND VGND VPWR VPWR load_slew744/X sky130_fd_sc_hd__clkbuf_4
X_5061_ _6704_/Q _3070_/Y _5338_/S VGND VGND VPWR VPWR _5061_/X sky130_fd_sc_hd__mux2_1
Xhold1508 _6509_/Q VGND VGND VPWR VPWR _5397_/A1 sky130_fd_sc_hd__dlygate4sd3_1
Xhold1519 _6536_/Q VGND VGND VPWR VPWR _5424_/A1 sky130_fd_sc_hd__dlygate4sd3_1
XFILLER_38_712 VGND VGND VPWR VPWR sky130_fd_sc_hd__fill_2
Xload_slew799 fanout798/X VGND VGND VPWR VPWR load_slew799/X sky130_fd_sc_hd__buf_4
XFILLER_42_1043 VGND VGND VPWR VPWR sky130_fd_sc_hd__decap_3
X_4012_ _4059_/B _4572_/B _4011_/Y _4061_/A1 VGND VGND VPWR VPWR _4013_/C sky130_fd_sc_hd__o211ai_2
XFILLER_20_1341 VGND VGND VPWR VPWR sky130_fd_sc_hd__decap_3
XFILLER_65_575 VGND VGND VPWR VPWR sky130_fd_sc_hd__decap_3
XFILLER_0_1413 VGND VGND VPWR VPWR sky130_fd_sc_hd__decap_3
XFILLER_77_1139 VGND VGND VPWR VPWR sky130_fd_sc_hd__decap_3
XFILLER_80_523 VGND VGND VPWR VPWR sky130_fd_sc_hd__decap_3
XFILLER_0_1435 VGND VGND VPWR VPWR sky130_fd_sc_hd__decap_3
XFILLER_25_439 VGND VGND VPWR VPWR sky130_fd_sc_hd__decap_3
XFILLER_37_299 VGND VGND VPWR VPWR sky130_fd_sc_hd__decap_3
X_5963_ hold955/X _6967_/Q _5971_/S VGND VGND VPWR VPWR _5963_/X sky130_fd_sc_hd__mux2_1
XFILLER_0_1457 VGND VGND VPWR VPWR sky130_fd_sc_hd__decap_3
XFILLER_20_1385 VGND VGND VPWR VPWR sky130_fd_sc_hd__decap_3
XFILLER_34_940 VGND VGND VPWR VPWR sky130_fd_sc_hd__fill_2
XFILLER_52_236 VGND VGND VPWR VPWR sky130_fd_sc_hd__decap_3
XFILLER_34_951 VGND VGND VPWR VPWR sky130_fd_sc_hd__fill_2
XFILLER_55_1404 VGND VGND VPWR VPWR sky130_fd_sc_hd__decap_3
X_4914_ _6683_/Q _3049_/Y _5213_/A VGND VGND VPWR VPWR _4914_/X sky130_fd_sc_hd__mux2_1
XFILLER_80_589 VGND VGND VPWR VPWR sky130_fd_sc_hd__decap_3
XFILLER_55_1437 VGND VGND VPWR VPWR sky130_fd_sc_hd__decap_3
XFILLER_61_770 VGND VGND VPWR VPWR sky130_fd_sc_hd__decap_3
X_5894_ _5930_/A0 _5894_/A1 _5896_/S VGND VGND VPWR VPWR _6903_/D sky130_fd_sc_hd__mux2_1
XFILLER_21_612 VGND VGND VPWR VPWR sky130_fd_sc_hd__decap_3
X_4845_ _6584_/Q _4894_/A _4885_/B1 VGND VGND VPWR VPWR _4845_/X sky130_fd_sc_hd__a21bo_2
XFILLER_60_280 VGND VGND VPWR VPWR sky130_fd_sc_hd__decap_3
XFILLER_21_656 VGND VGND VPWR VPWR sky130_fd_sc_hd__decap_3
XFILLER_18_1270 VGND VGND VPWR VPWR sky130_fd_sc_hd__decap_3
XFILLER_20_155 VGND VGND VPWR VPWR sky130_fd_sc_hd__fill_1
X_4776_ _4738_/A _4420_/X _4723_/X _6575_/Q VGND VGND VPWR VPWR _4776_/X sky130_fd_sc_hd__a2bb2o_2
X_6515_ _7024_/CLK _6515_/D fanout657/A VGND VGND VPWR VPWR _6515_/Q sky130_fd_sc_hd__dfrtp_2
X_3727_ _6336_/Q _4829_/A _3725_/X _3726_/X VGND VGND VPWR VPWR _4111_/A sky130_fd_sc_hd__o22a_2
X_6446_ _6752_/CLK _6446_/D load_slew671/X VGND VGND VPWR VPWR _6446_/Q sky130_fd_sc_hd__dfrtp_2
X_3658_ _3683_/A _3748_/A VGND VGND VPWR VPWR _3658_/Y sky130_fd_sc_hd__nor2_2
X_6377_ _7027_/CLK _6377_/D fanout839/X VGND VGND VPWR VPWR _6377_/Q sky130_fd_sc_hd__dfrtp_2
X_3589_ _3588_/B _3588_/C _3689_/A VGND VGND VPWR VPWR _3649_/B sky130_fd_sc_hd__a21oi_2
XFILLER_0_505 VGND VGND VPWR VPWR sky130_fd_sc_hd__decap_3
X_5328_ _6795_/Q _5022_/B _5328_/S VGND VGND VPWR VPWR _5328_/X sky130_fd_sc_hd__mux2_1
XFILLER_57_15 VGND VGND VPWR VPWR sky130_fd_sc_hd__decap_3
XFILLER_9_1460 VGND VGND VPWR VPWR sky130_fd_sc_hd__decap_3
X_5259_ _6766_/Q _5334_/S _5335_/S _5258_/Y VGND VGND VPWR VPWR _5259_/X sky130_fd_sc_hd__o211a_2
XFILLER_5_1313 VGND VGND VPWR VPWR sky130_fd_sc_hd__decap_3
XFILLER_57_48 VGND VGND VPWR VPWR sky130_fd_sc_hd__decap_3
XFILLER_25_1263 VGND VGND VPWR VPWR sky130_fd_sc_hd__decap_3
XFILLER_28_200 VGND VGND VPWR VPWR sky130_fd_sc_hd__decap_3
XFILLER_5_1357 VGND VGND VPWR VPWR sky130_fd_sc_hd__decap_3
XFILLER_21_1138 VGND VGND VPWR VPWR sky130_fd_sc_hd__decap_3
XFILLER_56_564 VGND VGND VPWR VPWR sky130_fd_sc_hd__decap_3
XFILLER_17_929 VGND VGND VPWR VPWR sky130_fd_sc_hd__decap_3
XTAP_TAPCELL_ROW_27_902 VGND VPWR sky130_fd_sc_hd__tapvpwrvgnd_1
XFILLER_16_417 VGND VGND VPWR VPWR sky130_fd_sc_hd__decap_3
XTAP_TAPCELL_ROW_27_913 VGND VPWR sky130_fd_sc_hd__tapvpwrvgnd_1
XFILLER_73_36 VGND VGND VPWR VPWR sky130_fd_sc_hd__decap_3
XFILLER_71_523 VGND VGND VPWR VPWR sky130_fd_sc_hd__decap_3
XFILLER_43_225 VGND VGND VPWR VPWR sky130_fd_sc_hd__decap_3
XFILLER_3_1092 VGND VGND VPWR VPWR sky130_fd_sc_hd__decap_3
XFILLER_73_69 VGND VGND VPWR VPWR sky130_fd_sc_hd__decap_3
Xwire81 wire81/A VGND VGND VPWR VPWR uo_out[1] sky130_fd_sc_hd__buf_4
XFILLER_25_962 VGND VGND VPWR VPWR sky130_fd_sc_hd__decap_3
XFILLER_71_578 VGND VGND VPWR VPWR sky130_fd_sc_hd__decap_3
Xwire92 wire92/A VGND VGND VPWR VPWR wire92/X sky130_fd_sc_hd__clkbuf_8
XFILLER_24_450 VGND VGND VPWR VPWR sky130_fd_sc_hd__decap_3
XFILLER_12_601 VGND VGND VPWR VPWR sky130_fd_sc_hd__decap_3
XFILLER_19_1034 VGND VGND VPWR VPWR sky130_fd_sc_hd__decap_3
XFILLER_11_100 VGND VGND VPWR VPWR sky130_fd_sc_hd__decap_3
XFILLER_52_792 VGND VGND VPWR VPWR sky130_fd_sc_hd__fill_2
XFILLER_12_645 VGND VGND VPWR VPWR sky130_fd_sc_hd__decap_3
XFILLER_11_122 VGND VGND VPWR VPWR sky130_fd_sc_hd__decap_3
XFILLER_40_998 VGND VGND VPWR VPWR sky130_fd_sc_hd__fill_1
XFILLER_71_1272 VGND VGND VPWR VPWR sky130_fd_sc_hd__decap_3
XFILLER_32_1223 VGND VGND VPWR VPWR sky130_fd_sc_hd__decap_3
XFILLER_32_1256 VGND VGND VPWR VPWR sky130_fd_sc_hd__decap_3
XFILLER_22_62 VGND VGND VPWR VPWR sky130_fd_sc_hd__decap_3
XFILLER_32_1267 VGND VGND VPWR VPWR sky130_fd_sc_hd__decap_3
XFILLER_4_800 VGND VGND VPWR VPWR sky130_fd_sc_hd__decap_3
XFILLER_67_1319 VGND VGND VPWR VPWR sky130_fd_sc_hd__decap_3
XFILLER_4_855 VGND VGND VPWR VPWR sky130_fd_sc_hd__decap_3
XFILLER_3_343 VGND VGND VPWR VPWR sky130_fd_sc_hd__decap_3
XFILLER_4_888 VGND VGND VPWR VPWR sky130_fd_sc_hd__decap_3
XFILLER_79_612 VGND VGND VPWR VPWR sky130_fd_sc_hd__decap_3
XFILLER_79_623 VGND VGND VPWR VPWR sky130_fd_sc_hd__decap_3
XFILLER_65_1043 VGND VGND VPWR VPWR sky130_fd_sc_hd__decap_3
XFILLER_78_133 VGND VGND VPWR VPWR sky130_fd_sc_hd__decap_3
XFILLER_21_9 VGND VGND VPWR VPWR sky130_fd_sc_hd__decap_3
XFILLER_67_829 VGND VGND VPWR VPWR sky130_fd_sc_hd__decap_3
XFILLER_19_200 VGND VGND VPWR VPWR sky130_fd_sc_hd__decap_3
XFILLER_43_1363 VGND VGND VPWR VPWR sky130_fd_sc_hd__decap_3
Xfanout190 fanout192/X VGND VGND VPWR VPWR _3353_/S sky130_fd_sc_hd__clkdlybuf4s25_1
XFILLER_43_1396 VGND VGND VPWR VPWR sky130_fd_sc_hd__decap_3
XFILLER_47_553 VGND VGND VPWR VPWR sky130_fd_sc_hd__decap_3
XFILLER_78_1415 VGND VGND VPWR VPWR sky130_fd_sc_hd__decap_3
XFILLER_47_92 VGND VGND VPWR VPWR sky130_fd_sc_hd__decap_3
XFILLER_62_501 VGND VGND VPWR VPWR sky130_fd_sc_hd__decap_3
XFILLER_19_277 VGND VGND VPWR VPWR sky130_fd_sc_hd__decap_3
XFILLER_47_586 VGND VGND VPWR VPWR sky130_fd_sc_hd__decap_3
XFILLER_78_1459 VGND VGND VPWR VPWR sky130_fd_sc_hd__decap_3
XFILLER_35_759 VGND VGND VPWR VPWR sky130_fd_sc_hd__decap_3
XFILLER_50_707 VGND VGND VPWR VPWR sky130_fd_sc_hd__decap_3
XFILLER_16_973 VGND VGND VPWR VPWR sky130_fd_sc_hd__decap_3
XTAP_TAPCELL_ROW_48_1460 VGND VPWR sky130_fd_sc_hd__tapvpwrvgnd_1
XFILLER_62_578 VGND VGND VPWR VPWR sky130_fd_sc_hd__decap_3
XFILLER_76_1161 VGND VGND VPWR VPWR sky130_fd_sc_hd__decap_3
XFILLER_62_589 VGND VGND VPWR VPWR sky130_fd_sc_hd__fill_1
XFILLER_43_770 VGND VGND VPWR VPWR sky130_fd_sc_hd__decap_3
XFILLER_72_1014 VGND VGND VPWR VPWR sky130_fd_sc_hd__decap_3
XFILLER_15_472 VGND VGND VPWR VPWR sky130_fd_sc_hd__decap_3
XFILLER_37_1134 VGND VGND VPWR VPWR sky130_fd_sc_hd__decap_3
XFILLER_76_1194 VGND VGND VPWR VPWR sky130_fd_sc_hd__decap_3
XFILLER_31_932 VGND VGND VPWR VPWR sky130_fd_sc_hd__decap_3
XTAP_TAPCELL_ROW_44_1335 VGND VPWR sky130_fd_sc_hd__tapvpwrvgnd_1
XTAP_TAPCELL_ROW_44_1346 VGND VPWR sky130_fd_sc_hd__tapvpwrvgnd_1
XTAP_TAPCELL_ROW_44_1357 VGND VPWR sky130_fd_sc_hd__tapvpwrvgnd_1
XFILLER_31_965 VGND VGND VPWR VPWR sky130_fd_sc_hd__decap_3
XFILLER_15_1410 VGND VGND VPWR VPWR sky130_fd_sc_hd__decap_3
X_4630_ _4300_/B _6547_/Q _4658_/S VGND VGND VPWR VPWR _4630_/X sky130_fd_sc_hd__mux2_1
XFILLER_31_987 VGND VGND VPWR VPWR sky130_fd_sc_hd__fill_2
XFILLER_50_1312 VGND VGND VPWR VPWR sky130_fd_sc_hd__decap_3
XFILLER_50_1323 VGND VGND VPWR VPWR sky130_fd_sc_hd__decap_3
XFILLER_15_1443 VGND VGND VPWR VPWR sky130_fd_sc_hd__decap_3
XFILLER_30_486 VGND VGND VPWR VPWR sky130_fd_sc_hd__decap_3
XFILLER_11_1307 VGND VGND VPWR VPWR sky130_fd_sc_hd__decap_3
XFILLER_50_1356 VGND VGND VPWR VPWR sky130_fd_sc_hd__decap_3
X_4561_ _6297_/Q _4745_/A2 _4558_/X _4560_/X VGND VGND VPWR VPWR _6297_/D sky130_fd_sc_hd__o22a_2
X_6300_ _6974_/CLK _6300_/D load_slew767/X VGND VGND VPWR VPWR _6300_/Q sky130_fd_sc_hd__dfrtp_2
X_3512_ _5514_/A _3512_/B VGND VGND VPWR VPWR _3512_/Y sky130_fd_sc_hd__nor2_2
X_4492_ _6264_/Q _4847_/A2 _3322_/X _4789_/B2 VGND VGND VPWR VPWR _4492_/X sky130_fd_sc_hd__a22o_2
X_6231_ _6905_/CLK _6231_/D wire738/X VGND VGND VPWR VPWR _6231_/Q sky130_fd_sc_hd__dfrtp_2
X_3443_ hold932/X _3442_/X _3459_/S VGND VGND VPWR VPWR _6195_/D sky130_fd_sc_hd__mux2_1
XFILLER_48_1230 VGND VGND VPWR VPWR sky130_fd_sc_hd__decap_3
X_6162_ clkload8/A _6162_/D load_slew643/X VGND VGND VPWR VPWR _6162_/Q sky130_fd_sc_hd__dfrtp_2
X_3374_ _6306_/Q _6418_/Q VGND VGND VPWR VPWR _3374_/X sky130_fd_sc_hd__xor2_2
XFILLER_69_111 VGND VGND VPWR VPWR sky130_fd_sc_hd__fill_1
XFILLER_48_1285 VGND VGND VPWR VPWR sky130_fd_sc_hd__decap_3
XFILLER_69_133 VGND VGND VPWR VPWR sky130_fd_sc_hd__decap_3
X_5113_ _6405_/Q _5285_/B VGND VGND VPWR VPWR _5115_/B sky130_fd_sc_hd__xor2_2
X_6093_ _7073_/CLK _6093_/D load_slew674/X VGND VGND VPWR VPWR _6093_/Q sky130_fd_sc_hd__dfrtp_2
XFILLER_44_1149 VGND VGND VPWR VPWR sky130_fd_sc_hd__decap_3
Xhold1305 _6705_/Q VGND VGND VPWR VPWR _5648_/A1 sky130_fd_sc_hd__dlygate4sd3_1
Xhold1316 _6496_/Q VGND VGND VPWR VPWR _5384_/A1 sky130_fd_sc_hd__dlygate4sd3_1
Xhold1327 _6855_/Q VGND VGND VPWR VPWR _5838_/A1 sky130_fd_sc_hd__dlygate4sd3_1
XFILLER_22_1403 VGND VGND VPWR VPWR sky130_fd_sc_hd__decap_3
XFILLER_61_1452 VGND VGND VPWR VPWR sky130_fd_sc_hd__decap_3
X_5044_ _6396_/Q _5258_/B VGND VGND VPWR VPWR _5044_/X sky130_fd_sc_hd__or2_2
Xload_slew596 _3597_/S0 VGND VGND VPWR VPWR _3550_/B sky130_fd_sc_hd__buf_4
XFILLER_61_1463 VGND VGND VPWR VPWR sky130_fd_sc_hd__decap_3
Xhold1338 _6474_/Q VGND VGND VPWR VPWR _5362_/A1 sky130_fd_sc_hd__dlygate4sd3_1
Xhold1349 _6475_/Q VGND VGND VPWR VPWR _5363_/A1 sky130_fd_sc_hd__dlygate4sd3_1
XFILLER_38_542 VGND VGND VPWR VPWR sky130_fd_sc_hd__decap_3
XFILLER_66_851 VGND VGND VPWR VPWR sky130_fd_sc_hd__decap_3
XFILLER_22_1447 VGND VGND VPWR VPWR sky130_fd_sc_hd__decap_3
XFILLER_72_309 VGND VGND VPWR VPWR sky130_fd_sc_hd__decap_3
XFILLER_26_704 VGND VGND VPWR VPWR sky130_fd_sc_hd__decap_3
XFILLER_65_372 VGND VGND VPWR VPWR sky130_fd_sc_hd__decap_3
XFILLER_66_895 VGND VGND VPWR VPWR sky130_fd_sc_hd__decap_3
XFILLER_26_748 VGND VGND VPWR VPWR sky130_fd_sc_hd__decap_3
Xtt_um_aes128_optimized VGND VGND VPWR VPWR tt_um_aes128_optimized/HI uio_oe[0] sky130_fd_sc_hd__conb_1
X_6995_ _7035_/CLK _6995_/D load_slew843/X VGND VGND VPWR VPWR _6995_/Q sky130_fd_sc_hd__dfrtp_2
XFILLER_0_1254 VGND VGND VPWR VPWR sky130_fd_sc_hd__decap_3
XFILLER_0_1276 VGND VGND VPWR VPWR sky130_fd_sc_hd__decap_3
XFILLER_22_910 VGND VGND VPWR VPWR sky130_fd_sc_hd__decap_3
X_5946_ _5946_/A0 _6950_/Q _6050_/S VGND VGND VPWR VPWR _5946_/X sky130_fd_sc_hd__mux2_1
XFILLER_34_770 VGND VGND VPWR VPWR sky130_fd_sc_hd__fill_1
XFILLER_59_1381 VGND VGND VPWR VPWR sky130_fd_sc_hd__decap_3
XFILLER_0_1298 VGND VGND VPWR VPWR sky130_fd_sc_hd__decap_3
XFILLER_55_1245 VGND VGND VPWR VPWR sky130_fd_sc_hd__decap_3
X_5877_ _5877_/A1 _5868_/Y _5915_/C _5799_/X VGND VGND VPWR VPWR _6888_/D sky130_fd_sc_hd__a22o_2
XFILLER_16_1229 VGND VGND VPWR VPWR sky130_fd_sc_hd__decap_3
XFILLER_55_1278 VGND VGND VPWR VPWR sky130_fd_sc_hd__decap_3
XFILLER_55_1289 VGND VGND VPWR VPWR sky130_fd_sc_hd__decap_3
X_4828_ _5609_/A3 _6582_/Q _4835_/S VGND VGND VPWR VPWR _4828_/X sky130_fd_sc_hd__mux2_1
XFILLER_21_464 VGND VGND VPWR VPWR sky130_fd_sc_hd__fill_2
XFILLER_22_987 VGND VGND VPWR VPWR sky130_fd_sc_hd__decap_3
X_4759_ _6324_/Q _4759_/A2 _4756_/X _4758_/X VGND VGND VPWR VPWR _6324_/D sky130_fd_sc_hd__o22a_2
XFILLER_49_1005 VGND VGND VPWR VPWR sky130_fd_sc_hd__decap_3
XTAP_TAPCELL_ROW_8_402 VGND VPWR sky130_fd_sc_hd__tapvpwrvgnd_1
X_6429_ _6991_/CLK _6429_/D load_slew792/X VGND VGND VPWR VPWR _6429_/Q sky130_fd_sc_hd__dfrtp_2
XTAP_TAPCELL_ROW_8_413 VGND VPWR sky130_fd_sc_hd__tapvpwrvgnd_1
XFILLER_1_803 VGND VGND VPWR VPWR sky130_fd_sc_hd__decap_3
XFILLER_66_1341 VGND VGND VPWR VPWR sky130_fd_sc_hd__decap_3
XFILLER_0_302 VGND VGND VPWR VPWR sky130_fd_sc_hd__decap_3
XFILLER_1_836 VGND VGND VPWR VPWR sky130_fd_sc_hd__decap_3
XFILLER_1_847 VGND VGND VPWR VPWR sky130_fd_sc_hd__decap_3
XFILLER_0_324 VGND VGND VPWR VPWR sky130_fd_sc_hd__decap_3
XFILLER_27_1325 VGND VGND VPWR VPWR sky130_fd_sc_hd__decap_3
XFILLER_62_1205 VGND VGND VPWR VPWR sky130_fd_sc_hd__decap_3
XFILLER_68_47 VGND VGND VPWR VPWR sky130_fd_sc_hd__decap_3
XFILLER_66_1385 VGND VGND VPWR VPWR sky130_fd_sc_hd__decap_3
XFILLER_0_346 VGND VGND VPWR VPWR sky130_fd_sc_hd__decap_3
XFILLER_7_1419 VGND VGND VPWR VPWR sky130_fd_sc_hd__decap_3
XFILLER_62_1238 VGND VGND VPWR VPWR sky130_fd_sc_hd__decap_3
XFILLER_0_368 VGND VGND VPWR VPWR sky130_fd_sc_hd__decap_3
XFILLER_27_1369 VGND VGND VPWR VPWR sky130_fd_sc_hd__decap_3
XFILLER_48_306 VGND VGND VPWR VPWR sky130_fd_sc_hd__fill_2
XFILLER_5_1110 VGND VGND VPWR VPWR sky130_fd_sc_hd__decap_3
XFILLER_5_1121 VGND VGND VPWR VPWR sky130_fd_sc_hd__decap_3
XFILLER_5_1154 VGND VGND VPWR VPWR sky130_fd_sc_hd__decap_3
XFILLER_29_553 VGND VGND VPWR VPWR sky130_fd_sc_hd__decap_3
XFILLER_1_1007 VGND VGND VPWR VPWR sky130_fd_sc_hd__fill_1
XFILLER_57_873 VGND VGND VPWR VPWR sky130_fd_sc_hd__decap_3
XFILLER_1_1018 VGND VGND VPWR VPWR sky130_fd_sc_hd__decap_3
XFILLER_5_1198 VGND VGND VPWR VPWR sky130_fd_sc_hd__decap_3
XFILLER_16_225 VGND VGND VPWR VPWR sky130_fd_sc_hd__fill_1
XFILLER_72_854 VGND VGND VPWR VPWR sky130_fd_sc_hd__decap_3
XFILLER_71_331 VGND VGND VPWR VPWR sky130_fd_sc_hd__decap_3
XFILLER_56_1009 VGND VGND VPWR VPWR sky130_fd_sc_hd__decap_3
XFILLER_73_1301 VGND VGND VPWR VPWR sky130_fd_sc_hd__decap_3
XFILLER_38_1421 VGND VGND VPWR VPWR sky130_fd_sc_hd__decap_3
XFILLER_32_729 VGND VGND VPWR VPWR sky130_fd_sc_hd__decap_3
XFILLER_38_1432 VGND VGND VPWR VPWR sky130_fd_sc_hd__decap_3
XFILLER_44_589 VGND VGND VPWR VPWR sky130_fd_sc_hd__fill_1
XFILLER_25_781 VGND VGND VPWR VPWR sky130_fd_sc_hd__decap_3
XTAP_TAPCELL_ROW_80_2269 VGND VPWR sky130_fd_sc_hd__tapvpwrvgnd_1
XFILLER_73_1334 VGND VGND VPWR VPWR sky130_fd_sc_hd__decap_3
XFILLER_13_932 VGND VGND VPWR VPWR sky130_fd_sc_hd__decap_3
XFILLER_73_1345 VGND VGND VPWR VPWR sky130_fd_sc_hd__decap_3
XFILLER_38_1465 VGND VGND VPWR VPWR sky130_fd_sc_hd__decap_3
XFILLER_9_903 VGND VGND VPWR VPWR sky130_fd_sc_hd__decap_3
XFILLER_73_1378 VGND VGND VPWR VPWR sky130_fd_sc_hd__decap_3
XFILLER_12_442 VGND VGND VPWR VPWR sky130_fd_sc_hd__decap_3
XFILLER_34_1329 VGND VGND VPWR VPWR sky130_fd_sc_hd__decap_3
XFILLER_40_751 VGND VGND VPWR VPWR sky130_fd_sc_hd__decap_3
XFILLER_12_464 VGND VGND VPWR VPWR sky130_fd_sc_hd__decap_3
XFILLER_8_413 VGND VGND VPWR VPWR sky130_fd_sc_hd__decap_3
XFILLER_8_424 VGND VGND VPWR VPWR sky130_fd_sc_hd__decap_3
XFILLER_8_457 VGND VGND VPWR VPWR sky130_fd_sc_hd__decap_3
XFILLER_69_9 VGND VGND VPWR VPWR sky130_fd_sc_hd__decap_3
XFILLER_10_1362 VGND VGND VPWR VPWR sky130_fd_sc_hd__decap_3
XFILLER_4_652 VGND VGND VPWR VPWR sky130_fd_sc_hd__decap_3
XFILLER_10_1373 VGND VGND VPWR VPWR sky130_fd_sc_hd__decap_3
XFILLER_4_685 VGND VGND VPWR VPWR sky130_fd_sc_hd__decap_3
XFILLER_3_162 VGND VGND VPWR VPWR sky130_fd_sc_hd__decap_3
XTAP_TAPCELL_ROW_37_1150 VGND VPWR sky130_fd_sc_hd__tapvpwrvgnd_1
XTAP_TAPCELL_ROW_37_1161 VGND VPWR sky130_fd_sc_hd__tapvpwrvgnd_1
XFILLER_45_1425 VGND VGND VPWR VPWR sky130_fd_sc_hd__decap_3
XFILLER_3_195 VGND VGND VPWR VPWR sky130_fd_sc_hd__decap_3
XTAP_TAPCELL_ROW_37_1172 VGND VPWR sky130_fd_sc_hd__tapvpwrvgnd_1
XFILLER_80_1338 VGND VGND VPWR VPWR sky130_fd_sc_hd__decap_3
XFILLER_79_464 VGND VGND VPWR VPWR sky130_fd_sc_hd__decap_3
XFILLER_39_317 VGND VGND VPWR VPWR sky130_fd_sc_hd__decap_3
XTAP_TAPCELL_ROW_33_1047 VGND VPWR sky130_fd_sc_hd__tapvpwrvgnd_1
XTAP_TAPCELL_ROW_33_1058 VGND VPWR sky130_fd_sc_hd__tapvpwrvgnd_1
XTAP_TAPCELL_ROW_33_1069 VGND VPWR sky130_fd_sc_hd__tapvpwrvgnd_1
X_3090_ _3722_/A _6608_/Q VGND VGND VPWR VPWR _3090_/X sky130_fd_sc_hd__and2_2
XFILLER_48_862 VGND VGND VPWR VPWR sky130_fd_sc_hd__decap_3
XFILLER_75_670 VGND VGND VPWR VPWR sky130_fd_sc_hd__fill_2
XFILLER_78_1223 VGND VGND VPWR VPWR sky130_fd_sc_hd__decap_3
XFILLER_75_681 VGND VGND VPWR VPWR sky130_fd_sc_hd__fill_2
XFILLER_47_372 VGND VGND VPWR VPWR sky130_fd_sc_hd__decap_3
XFILLER_35_523 VGND VGND VPWR VPWR sky130_fd_sc_hd__decap_3
XFILLER_78_1256 VGND VGND VPWR VPWR sky130_fd_sc_hd__decap_3
XFILLER_39_1207 VGND VGND VPWR VPWR sky130_fd_sc_hd__fill_1
XFILLER_78_1267 VGND VGND VPWR VPWR sky130_fd_sc_hd__decap_3
XFILLER_35_556 VGND VGND VPWR VPWR sky130_fd_sc_hd__decap_3
XTAP_TAPCELL_ROW_46_1408 VGND VPWR sky130_fd_sc_hd__tapvpwrvgnd_1
XFILLER_35_567 VGND VGND VPWR VPWR sky130_fd_sc_hd__fill_2
X_5800_ _5800_/A1 _5783_/X _5841_/C _5799_/X VGND VGND VPWR VPWR _6824_/D sky130_fd_sc_hd__a22o_2
XFILLER_23_729 VGND VGND VPWR VPWR sky130_fd_sc_hd__decap_3
X_6780_ _6987_/CLK _6780_/D fanout835/X VGND VGND VPWR VPWR _6780_/Q sky130_fd_sc_hd__dfrtp_2
XFILLER_22_206 VGND VGND VPWR VPWR sky130_fd_sc_hd__decap_3
X_3992_ _6533_/Q _3991_/B _3485_/B VGND VGND VPWR VPWR _3992_/X sky130_fd_sc_hd__a21bo_2
XFILLER_16_781 VGND VGND VPWR VPWR sky130_fd_sc_hd__decap_3
X_5731_ _7068_/Q _5731_/B _5758_/C VGND VGND VPWR VPWR _5738_/S sky130_fd_sc_hd__or3_2
XFILLER_52_1418 VGND VGND VPWR VPWR sky130_fd_sc_hd__decap_3
XFILLER_52_1429 VGND VGND VPWR VPWR sky130_fd_sc_hd__decap_3
X_5662_ _5928_/A0 _5662_/A1 _5665_/S VGND VGND VPWR VPWR _6717_/D sky130_fd_sc_hd__mux2_1
XFILLER_30_272 VGND VGND VPWR VPWR sky130_fd_sc_hd__fill_1
XFILLER_15_1251 VGND VGND VPWR VPWR sky130_fd_sc_hd__decap_3
X_4613_ _6256_/Q _4847_/A2 _3370_/X _4789_/B2 VGND VGND VPWR VPWR _4613_/X sky130_fd_sc_hd__a22o_2
X_5593_ _5607_/A1 _4312_/A _5602_/B1 VGND VGND VPWR VPWR _5593_/Y sky130_fd_sc_hd__a21oi_4
XFILLER_15_1284 VGND VGND VPWR VPWR sky130_fd_sc_hd__decap_3
XFILLER_15_1295 VGND VGND VPWR VPWR sky130_fd_sc_hd__decap_3
X_4544_ _6271_/Q wire503/X _3336_/X wire383/X VGND VGND VPWR VPWR _4544_/X sky130_fd_sc_hd__a22o_2
X_4475_ _6518_/Q _4534_/B _4831_/A1 VGND VGND VPWR VPWR _4475_/X sky130_fd_sc_hd__a21bo_2
Xmax_cap165 _5584_/Y VGND VGND VPWR VPWR _5592_/B1 sky130_fd_sc_hd__buf_4
X_6214_ _7065_/CLK _6214_/D load_slew736/X VGND VGND VPWR VPWR _6214_/Q sky130_fd_sc_hd__dfrtp_2
X_3426_ _6324_/Q _6444_/Q VGND VGND VPWR VPWR _3426_/X sky130_fd_sc_hd__xor2_2
X_6145_ _7035_/CLK _6145_/D load_slew843/X VGND VGND VPWR VPWR _6145_/Q sky130_fd_sc_hd__dfrtp_2
X_3357_ hold960/X _3356_/X _3421_/S VGND VGND VPWR VPWR _6152_/D sky130_fd_sc_hd__mux2_1
Xhold1102 _5996_/X VGND VGND VPWR VPWR _7000_/D sky130_fd_sc_hd__dlygate4sd3_1
Xhold1113 _6141_/Q VGND VGND VPWR VPWR _5988_/A0 sky130_fd_sc_hd__dlygate4sd3_1
XFILLER_57_125 VGND VGND VPWR VPWR sky130_fd_sc_hd__fill_1
XFILLER_58_648 VGND VGND VPWR VPWR sky130_fd_sc_hd__decap_3
XFILLER_6_1441 VGND VGND VPWR VPWR sky130_fd_sc_hd__decap_3
X_6076_ _6076_/A1 _6081_/C _6074_/Y _7075_/Q VGND VGND VPWR VPWR _7075_/D sky130_fd_sc_hd__a22o_2
Xhold1124 _6779_/Q VGND VGND VPWR VPWR _5733_/A1 sky130_fd_sc_hd__dlygate4sd3_1
Xhold1135 _6990_/Q VGND VGND VPWR VPWR _5986_/A1 sky130_fd_sc_hd__dlygate4sd3_1
XFILLER_57_136 VGND VGND VPWR VPWR sky130_fd_sc_hd__decap_3
XFILLER_61_1260 VGND VGND VPWR VPWR sky130_fd_sc_hd__decap_3
X_3288_ _6223_/Q _6375_/Q VGND VGND VPWR VPWR _3288_/X sky130_fd_sc_hd__xor2_2
Xhold1146 _6948_/Q VGND VGND VPWR VPWR _5944_/A1 sky130_fd_sc_hd__dlygate4sd3_1
XFILLER_26_1391 VGND VGND VPWR VPWR sky130_fd_sc_hd__decap_3
XFILLER_79_1009 VGND VGND VPWR VPWR sky130_fd_sc_hd__decap_3
XFILLER_22_1233 VGND VGND VPWR VPWR sky130_fd_sc_hd__decap_3
Xhold1157 _6927_/Q VGND VGND VPWR VPWR _5921_/A0 sky130_fd_sc_hd__dlygate4sd3_1
X_5027_ _6361_/Q _5026_/X _5027_/S VGND VGND VPWR VPWR _6361_/D sky130_fd_sc_hd__mux2_1
Xhold1168 _6868_/Q VGND VGND VPWR VPWR _5853_/A0 sky130_fd_sc_hd__dlygate4sd3_1
Xhold1179 _6694_/Q VGND VGND VPWR VPWR _5635_/A1 sky130_fd_sc_hd__dlygate4sd3_1
XFILLER_72_117 VGND VGND VPWR VPWR sky130_fd_sc_hd__fill_2
XFILLER_2_1338 VGND VGND VPWR VPWR sky130_fd_sc_hd__decap_3
XFILLER_22_1288 VGND VGND VPWR VPWR sky130_fd_sc_hd__decap_3
XFILLER_57_1307 VGND VGND VPWR VPWR sky130_fd_sc_hd__decap_3
XTAP_TAPCELL_ROW_0_165 VGND VPWR sky130_fd_sc_hd__tapvpwrvgnd_1
XFILLER_0_1040 VGND VGND VPWR VPWR sky130_fd_sc_hd__decap_3
XFILLER_54_49 VGND VGND VPWR VPWR sky130_fd_sc_hd__decap_3
XFILLER_14_718 VGND VGND VPWR VPWR sky130_fd_sc_hd__decap_3
XTAP_TAPCELL_ROW_0_176 VGND VPWR sky130_fd_sc_hd__tapvpwrvgnd_1
XTAP_TAPCELL_ROW_0_187 VGND VPWR sky130_fd_sc_hd__tapvpwrvgnd_1
XFILLER_26_589 VGND VGND VPWR VPWR sky130_fd_sc_hd__decap_3
XTAP_TAPCELL_ROW_0_198 VGND VPWR sky130_fd_sc_hd__tapvpwrvgnd_1
X_6978_ _6986_/CLK _6978_/D load_slew648/X VGND VGND VPWR VPWR _6978_/Q sky130_fd_sc_hd__dfrtp_2
X_5929_ _5929_/A0 _5929_/A1 _5932_/S VGND VGND VPWR VPWR _6934_/D sky130_fd_sc_hd__mux2_1
XFILLER_70_15 VGND VGND VPWR VPWR sky130_fd_sc_hd__decap_3
XFILLER_16_1037 VGND VGND VPWR VPWR sky130_fd_sc_hd__fill_1
XFILLER_33_1340 VGND VGND VPWR VPWR sky130_fd_sc_hd__decap_3
XFILLER_33_1351 VGND VGND VPWR VPWR sky130_fd_sc_hd__decap_3
XFILLER_10_979 VGND VGND VPWR VPWR sky130_fd_sc_hd__fill_1
XFILLER_5_405 VGND VGND VPWR VPWR sky130_fd_sc_hd__decap_3
XFILLER_33_1384 VGND VGND VPWR VPWR sky130_fd_sc_hd__decap_3
XFILLER_68_1403 VGND VGND VPWR VPWR sky130_fd_sc_hd__decap_3
XFILLER_5_449 VGND VGND VPWR VPWR sky130_fd_sc_hd__decap_3
XFILLER_79_24 VGND VGND VPWR VPWR sky130_fd_sc_hd__decap_3
XFILLER_68_1447 VGND VGND VPWR VPWR sky130_fd_sc_hd__decap_3
XFILLER_79_57 VGND VGND VPWR VPWR sky130_fd_sc_hd__decap_3
Xhold980 _6963_/Q VGND VGND VPWR VPWR hold980/X sky130_fd_sc_hd__dlygate4sd3_1
XTAP_TAPCELL_ROW_73_2095 VGND VPWR sky130_fd_sc_hd__tapvpwrvgnd_1
Xhold991 _6014_/X VGND VGND VPWR VPWR _7018_/D sky130_fd_sc_hd__dlygate4sd3_1
XFILLER_66_1171 VGND VGND VPWR VPWR sky130_fd_sc_hd__decap_3
XFILLER_1_666 VGND VGND VPWR VPWR sky130_fd_sc_hd__decap_3
XFILLER_7_1216 VGND VGND VPWR VPWR sky130_fd_sc_hd__decap_3
XFILLER_49_604 VGND VGND VPWR VPWR sky130_fd_sc_hd__decap_3
XFILLER_76_401 VGND VGND VPWR VPWR sky130_fd_sc_hd__decap_3
XFILLER_0_165 VGND VGND VPWR VPWR sky130_fd_sc_hd__decap_3
XFILLER_1_688 VGND VGND VPWR VPWR sky130_fd_sc_hd__decap_3
XFILLER_48_103 VGND VGND VPWR VPWR sky130_fd_sc_hd__decap_3
XFILLER_0_187 VGND VGND VPWR VPWR sky130_fd_sc_hd__decap_3
XFILLER_40_1300 VGND VGND VPWR VPWR sky130_fd_sc_hd__decap_3
XFILLER_48_147 VGND VGND VPWR VPWR sky130_fd_sc_hd__decap_3
XFILLER_76_467 VGND VGND VPWR VPWR sky130_fd_sc_hd__fill_2
XFILLER_36_309 VGND VGND VPWR VPWR sky130_fd_sc_hd__decap_3
XFILLER_28_61 VGND VGND VPWR VPWR sky130_fd_sc_hd__fill_1
XFILLER_40_1344 VGND VGND VPWR VPWR sky130_fd_sc_hd__decap_3
XFILLER_28_83 VGND VGND VPWR VPWR sky130_fd_sc_hd__fill_1
XFILLER_57_681 VGND VGND VPWR VPWR sky130_fd_sc_hd__decap_3
XFILLER_29_383 VGND VGND VPWR VPWR sky130_fd_sc_hd__decap_3
XFILLER_17_534 VGND VGND VPWR VPWR sky130_fd_sc_hd__fill_2
XFILLER_40_1388 VGND VGND VPWR VPWR sky130_fd_sc_hd__decap_3
XFILLER_75_1407 VGND VGND VPWR VPWR sky130_fd_sc_hd__decap_3
XFILLER_32_504 VGND VGND VPWR VPWR sky130_fd_sc_hd__decap_3
XFILLER_60_813 VGND VGND VPWR VPWR sky130_fd_sc_hd__fill_1
XFILLER_72_684 VGND VGND VPWR VPWR sky130_fd_sc_hd__decap_3
XFILLER_71_172 VGND VGND VPWR VPWR sky130_fd_sc_hd__decap_3
XFILLER_44_60 VGND VGND VPWR VPWR sky130_fd_sc_hd__fill_1
XFILLER_38_1251 VGND VGND VPWR VPWR sky130_fd_sc_hd__decap_3
XFILLER_73_1142 VGND VGND VPWR VPWR sky130_fd_sc_hd__decap_3
XFILLER_44_82 VGND VGND VPWR VPWR sky130_fd_sc_hd__fill_2
XFILLER_13_751 VGND VGND VPWR VPWR sky130_fd_sc_hd__decap_3
XFILLER_38_1273 VGND VGND VPWR VPWR sky130_fd_sc_hd__decap_3
XFILLER_73_1175 VGND VGND VPWR VPWR sky130_fd_sc_hd__fill_1
XFILLER_9_722 VGND VGND VPWR VPWR sky130_fd_sc_hd__decap_3
XFILLER_73_1186 VGND VGND VPWR VPWR sky130_fd_sc_hd__decap_3
XFILLER_12_272 VGND VGND VPWR VPWR sky130_fd_sc_hd__decap_3
XTAP_TAPCELL_ROW_23_790 VGND VPWR sky130_fd_sc_hd__tapvpwrvgnd_1
XFILLER_51_1440 VGND VGND VPWR VPWR sky130_fd_sc_hd__decap_3
XFILLER_12_1424 VGND VGND VPWR VPWR sky130_fd_sc_hd__decap_3
XFILLER_12_1435 VGND VGND VPWR VPWR sky130_fd_sc_hd__decap_3
XTAP_TAPCELL_ROW_10_451 VGND VPWR sky130_fd_sc_hd__tapvpwrvgnd_1
XFILLER_67_6 VGND VGND VPWR VPWR sky130_fd_sc_hd__decap_3
XTAP_TAPCELL_ROW_10_462 VGND VPWR sky130_fd_sc_hd__tapvpwrvgnd_1
XFILLER_12_1468 VGND VGND VPWR VPWR sky130_fd_sc_hd__fill_1
XTAP_TAPCELL_ROW_10_473 VGND VPWR sky130_fd_sc_hd__tapvpwrvgnd_1
XTAP_TAPCELL_ROW_39_1212 VGND VPWR sky130_fd_sc_hd__tapvpwrvgnd_1
XFILLER_5_21 VGND VGND VPWR VPWR sky130_fd_sc_hd__decap_3
XTAP_TAPCELL_ROW_39_1223 VGND VPWR sky130_fd_sc_hd__tapvpwrvgnd_1
XFILLER_5_972 VGND VGND VPWR VPWR sky130_fd_sc_hd__decap_3
XFILLER_5_54 VGND VGND VPWR VPWR sky130_fd_sc_hd__fill_2
XFILLER_10_1170 VGND VGND VPWR VPWR sky130_fd_sc_hd__decap_3
XFILLER_4_482 VGND VGND VPWR VPWR sky130_fd_sc_hd__decap_3
X_4260_ _3933_/A _4836_/B _4257_/X _4896_/A1 VGND VGND VPWR VPWR _4260_/X sky130_fd_sc_hd__o2bb2a_2
XTAP_TAPCELL_ROW_35_1109 VGND VPWR sky130_fd_sc_hd__tapvpwrvgnd_1
XFILLER_80_1102 VGND VGND VPWR VPWR sky130_fd_sc_hd__decap_3
X_3211_ _7049_/Q _7057_/Q _3211_/S VGND VGND VPWR VPWR _3211_/X sky130_fd_sc_hd__mux2_1
XFILLER_45_1233 VGND VGND VPWR VPWR sky130_fd_sc_hd__decap_3
XFILLER_80_1124 VGND VGND VPWR VPWR sky130_fd_sc_hd__decap_3
X_4191_ _4886_/A1 _4190_/X _4257_/S _6480_/Q VGND VGND VPWR VPWR _4191_/X sky130_fd_sc_hd__a2bb2o_2
XFILLER_67_401 VGND VGND VPWR VPWR sky130_fd_sc_hd__decap_3
XFILLER_45_1266 VGND VGND VPWR VPWR sky130_fd_sc_hd__decap_3
XFILLER_41_1108 VGND VGND VPWR VPWR sky130_fd_sc_hd__fill_1
X_3142_ _3193_/A1 _3140_/X _3141_/X _3213_/C1 VGND VGND VPWR VPWR _3145_/B sky130_fd_sc_hd__a211o_2
XFILLER_67_434 VGND VGND VPWR VPWR sky130_fd_sc_hd__decap_3
XFILLER_39_136 VGND VGND VPWR VPWR sky130_fd_sc_hd__decap_3
XFILLER_68_968 VGND VGND VPWR VPWR sky130_fd_sc_hd__decap_3
X_3073_ _6608_/Q VGND VGND VPWR VPWR _3073_/Y sky130_fd_sc_hd__inv_2
XFILLER_48_681 VGND VGND VPWR VPWR sky130_fd_sc_hd__fill_2
X_6901_ _7032_/CLK _6901_/D load_slew696/X VGND VGND VPWR VPWR _6901_/Q sky130_fd_sc_hd__dfrtp_2
XTAP_TAPCELL_ROW_69_1986 VGND VPWR sky130_fd_sc_hd__tapvpwrvgnd_1
XFILLER_1_1360 VGND VGND VPWR VPWR sky130_fd_sc_hd__decap_3
XTAP_TAPCELL_ROW_69_1997 VGND VPWR sky130_fd_sc_hd__tapvpwrvgnd_1
X_6832_ _6897_/CLK _6832_/D fanout699/A VGND VGND VPWR VPWR _6832_/Q sky130_fd_sc_hd__dfrtp_2
XFILLER_35_386 VGND VGND VPWR VPWR sky130_fd_sc_hd__decap_3
XFILLER_39_1048 VGND VGND VPWR VPWR sky130_fd_sc_hd__decap_3
XFILLER_51_835 VGND VGND VPWR VPWR sky130_fd_sc_hd__decap_3
XFILLER_1_1393 VGND VGND VPWR VPWR sky130_fd_sc_hd__decap_3
XFILLER_17_1313 VGND VGND VPWR VPWR sky130_fd_sc_hd__decap_3
X_6763_ _6988_/CLK _6763_/D fanout812/X VGND VGND VPWR VPWR _6763_/Q sky130_fd_sc_hd__dfrtp_2
XFILLER_56_1362 VGND VGND VPWR VPWR sky130_fd_sc_hd__decap_3
X_3975_ _4123_/B2 _3972_/X _3973_/Y _3974_/X _4734_/C1 VGND VGND VPWR VPWR _3975_/X
+ sky130_fd_sc_hd__o221a_2
XFILLER_56_1373 VGND VGND VPWR VPWR sky130_fd_sc_hd__decap_3
X_5714_ _5907_/A0 _5714_/A1 wire88/A VGND VGND VPWR VPWR _6762_/D sky130_fd_sc_hd__mux2_1
X_6694_ _6918_/CLK _6694_/D load_slew742/X VGND VGND VPWR VPWR _6694_/Q sky130_fd_sc_hd__dfrtp_2
XFILLER_17_1357 VGND VGND VPWR VPWR sky130_fd_sc_hd__decap_3
XFILLER_31_570 VGND VGND VPWR VPWR sky130_fd_sc_hd__decap_3
XFILLER_52_1237 VGND VGND VPWR VPWR sky130_fd_sc_hd__decap_3
XTAP_TAPCELL_ROW_21_738 VGND VPWR sky130_fd_sc_hd__tapvpwrvgnd_1
XPHY_EDGE_ROW_17_Left_98 VGND VGND VPWR VPWR sky130_fd_sc_hd__decap_3
XTAP_TAPCELL_ROW_21_749 VGND VPWR sky130_fd_sc_hd__tapvpwrvgnd_1
X_5645_ _5911_/A0 _5645_/A1 wire92/X VGND VGND VPWR VPWR _6702_/D sky130_fd_sc_hd__mux2_1
XFILLER_40_18 VGND VGND VPWR VPWR sky130_fd_sc_hd__decap_3
XFILLER_40_29 VGND VGND VPWR VPWR sky130_fd_sc_hd__fill_1
X_5576_ _3044_/A _5576_/A2 _5589_/A3 _5583_/A2 _5576_/B2 VGND VGND VPWR VPWR _6654_/D
+ sky130_fd_sc_hd__a32o_2
XFILLER_3_909 VGND VGND VPWR VPWR sky130_fd_sc_hd__decap_3
X_4527_ _4526_/B _4703_/B _4526_/Y _4880_/C1 VGND VGND VPWR VPWR _4528_/C sky130_fd_sc_hd__o211ai_2
XFILLER_2_419 VGND VGND VPWR VPWR sky130_fd_sc_hd__fill_1
X_4458_ _6283_/Q _4457_/X wire49/X VGND VGND VPWR VPWR _6283_/D sky130_fd_sc_hd__mux2_1
Xfanout701 fanout703/X VGND VGND VPWR VPWR fanout701/X sky130_fd_sc_hd__clkdlybuf4s25_1
XFILLER_49_49 VGND VGND VPWR VPWR sky130_fd_sc_hd__decap_3
XFILLER_63_1322 VGND VGND VPWR VPWR sky130_fd_sc_hd__decap_3
XFILLER_28_1453 VGND VGND VPWR VPWR sky130_fd_sc_hd__decap_3
X_3409_ hold896/X _3408_/X _3473_/S VGND VGND VPWR VPWR _6178_/D sky130_fd_sc_hd__mux2_1
X_4389_ _6507_/Q _4388_/A _4769_/B1 VGND VGND VPWR VPWR _4389_/X sky130_fd_sc_hd__a21bo_2
XFILLER_58_401 VGND VGND VPWR VPWR sky130_fd_sc_hd__decap_3
Xfanout745 fanout746/X VGND VGND VPWR VPWR fanout745/X sky130_fd_sc_hd__clkdlybuf4s25_1
XFILLER_24_1306 VGND VGND VPWR VPWR sky130_fd_sc_hd__decap_3
XFILLER_59_935 VGND VGND VPWR VPWR sky130_fd_sc_hd__decap_3
Xfanout756 fanout758/X VGND VGND VPWR VPWR fanout756/X sky130_fd_sc_hd__clkdlybuf4s25_1
XFILLER_24_1317 VGND VGND VPWR VPWR sky130_fd_sc_hd__decap_3
XFILLER_63_1366 VGND VGND VPWR VPWR sky130_fd_sc_hd__decap_3
X_6128_ _7011_/CLK _6128_/D fanout814/X VGND VGND VPWR VPWR _6128_/Q sky130_fd_sc_hd__dfrtp_2
XFILLER_63_1399 VGND VGND VPWR VPWR sky130_fd_sc_hd__fill_1
XFILLER_65_15 VGND VGND VPWR VPWR sky130_fd_sc_hd__decap_3
XFILLER_18_309 VGND VGND VPWR VPWR sky130_fd_sc_hd__decap_3
X_6059_ hold966/X _6059_/A1 _6059_/S VGND VGND VPWR VPWR _7063_/D sky130_fd_sc_hd__mux2_1
XFILLER_2_1102 VGND VGND VPWR VPWR sky130_fd_sc_hd__decap_3
XFILLER_61_1090 VGND VGND VPWR VPWR sky130_fd_sc_hd__decap_3
XFILLER_73_426 VGND VGND VPWR VPWR sky130_fd_sc_hd__fill_2
XFILLER_6_1282 VGND VGND VPWR VPWR sky130_fd_sc_hd__decap_3
XFILLER_22_1052 VGND VGND VPWR VPWR sky130_fd_sc_hd__decap_3
XFILLER_67_990 VGND VGND VPWR VPWR sky130_fd_sc_hd__decap_3
XFILLER_2_1135 VGND VGND VPWR VPWR sky130_fd_sc_hd__decap_3
XFILLER_2_1179 VGND VGND VPWR VPWR sky130_fd_sc_hd__decap_3
XFILLER_57_1115 VGND VGND VPWR VPWR sky130_fd_sc_hd__decap_3
XFILLER_14_504 VGND VGND VPWR VPWR sky130_fd_sc_hd__decap_3
XFILLER_42_813 VGND VGND VPWR VPWR sky130_fd_sc_hd__decap_3
XFILLER_54_684 VGND VGND VPWR VPWR sky130_fd_sc_hd__fill_1
XFILLER_74_1462 VGND VGND VPWR VPWR sky130_fd_sc_hd__decap_3
XFILLER_35_1413 VGND VGND VPWR VPWR sky130_fd_sc_hd__decap_3
XFILLER_70_1315 VGND VGND VPWR VPWR sky130_fd_sc_hd__fill_1
XFILLER_14_41 VGND VGND VPWR VPWR sky130_fd_sc_hd__decap_3
XFILLER_41_378 VGND VGND VPWR VPWR sky130_fd_sc_hd__decap_3
XFILLER_70_1326 VGND VGND VPWR VPWR sky130_fd_sc_hd__decap_3
XFILLER_35_1446 VGND VGND VPWR VPWR sky130_fd_sc_hd__decap_3
XFILLER_35_1457 VGND VGND VPWR VPWR sky130_fd_sc_hd__decap_3
XFILLER_22_581 VGND VGND VPWR VPWR sky130_fd_sc_hd__decap_3
XFILLER_70_1359 VGND VGND VPWR VPWR sky130_fd_sc_hd__decap_3
XTAP_TAPCELL_ROW_79_2260 VGND VPWR sky130_fd_sc_hd__tapvpwrvgnd_1
XFILLER_6_736 VGND VGND VPWR VPWR sky130_fd_sc_hd__decap_3
XFILLER_33_1192 VGND VGND VPWR VPWR sky130_fd_sc_hd__decap_3
XFILLER_68_1211 VGND VGND VPWR VPWR sky130_fd_sc_hd__decap_3
XTAP_TAPCELL_ROW_75_2146 VGND VPWR sky130_fd_sc_hd__tapvpwrvgnd_1
XTAP_TAPCELL_ROW_75_2157 VGND VPWR sky130_fd_sc_hd__tapvpwrvgnd_1
XFILLER_30_73 VGND VGND VPWR VPWR sky130_fd_sc_hd__fill_2
XFILLER_68_1244 VGND VGND VPWR VPWR sky130_fd_sc_hd__decap_3
XFILLER_5_279 VGND VGND VPWR VPWR sky130_fd_sc_hd__fill_1
XFILLER_2_920 VGND VGND VPWR VPWR sky130_fd_sc_hd__decap_3
XFILLER_2_931 VGND VGND VPWR VPWR sky130_fd_sc_hd__decap_3
XFILLER_29_1239 VGND VGND VPWR VPWR sky130_fd_sc_hd__decap_3
XFILLER_68_1288 VGND VGND VPWR VPWR sky130_fd_sc_hd__decap_3
XFILLER_2_964 VGND VGND VPWR VPWR sky130_fd_sc_hd__decap_3
XFILLER_1_452 VGND VGND VPWR VPWR sky130_fd_sc_hd__decap_3
XFILLER_42_1406 VGND VGND VPWR VPWR sky130_fd_sc_hd__decap_3
XFILLER_77_743 VGND VGND VPWR VPWR sky130_fd_sc_hd__decap_3
XFILLER_49_467 VGND VGND VPWR VPWR sky130_fd_sc_hd__decap_3
XFILLER_79_1340 VGND VGND VPWR VPWR sky130_fd_sc_hd__decap_3
XFILLER_36_139 VGND VGND VPWR VPWR sky130_fd_sc_hd__fill_1
XFILLER_79_1351 VGND VGND VPWR VPWR sky130_fd_sc_hd__decap_3
XFILLER_80_908 VGND VGND VPWR VPWR sky130_fd_sc_hd__decap_3
XFILLER_17_331 VGND VGND VPWR VPWR sky130_fd_sc_hd__decap_3
XFILLER_40_1185 VGND VGND VPWR VPWR sky130_fd_sc_hd__decap_3
XFILLER_75_1204 VGND VGND VPWR VPWR sky130_fd_sc_hd__decap_3
XFILLER_79_1384 VGND VGND VPWR VPWR sky130_fd_sc_hd__decap_3
XFILLER_44_150 VGND VGND VPWR VPWR sky130_fd_sc_hd__decap_3
XFILLER_45_673 VGND VGND VPWR VPWR sky130_fd_sc_hd__decap_3
XFILLER_73_993 VGND VGND VPWR VPWR sky130_fd_sc_hd__fill_2
XFILLER_75_1248 VGND VGND VPWR VPWR sky130_fd_sc_hd__decap_3
XFILLER_44_172 VGND VGND VPWR VPWR sky130_fd_sc_hd__fill_2
XFILLER_32_323 VGND VGND VPWR VPWR sky130_fd_sc_hd__fill_2
XFILLER_33_846 VGND VGND VPWR VPWR sky130_fd_sc_hd__fill_1
XTAP_TAPCELL_ROW_64_1861 VGND VPWR sky130_fd_sc_hd__tapvpwrvgnd_1
XFILLER_32_356 VGND VGND VPWR VPWR sky130_fd_sc_hd__fill_1
XTAP_TAPCELL_ROW_64_1872 VGND VPWR sky130_fd_sc_hd__tapvpwrvgnd_1
X_3760_ _3760_/A _3760_/B _3760_/C VGND VGND VPWR VPWR _3789_/B sky130_fd_sc_hd__and3_2
XFILLER_20_529 VGND VGND VPWR VPWR sky130_fd_sc_hd__decap_3
XFILLER_13_570 VGND VGND VPWR VPWR sky130_fd_sc_hd__decap_3
XTAP_TAPCELL_ROW_15_587 VGND VPWR sky130_fd_sc_hd__tapvpwrvgnd_1
XTAP_TAPCELL_ROW_15_598 VGND VPWR sky130_fd_sc_hd__tapvpwrvgnd_1
XTAP_TAPCELL_ROW_60_1758 VGND VPWR sky130_fd_sc_hd__tapvpwrvgnd_1
XTAP_TAPCELL_ROW_60_1769 VGND VPWR sky130_fd_sc_hd__tapvpwrvgnd_1
Xtt_um_aes128_optimized_859 VGND VGND VPWR VPWR uio_oe[6] tt_um_aes128_optimized_859/LO
+ sky130_fd_sc_hd__conb_1
X_3691_ _3757_/A _3757_/B VGND VGND VPWR VPWR _3709_/A sky130_fd_sc_hd__nand2_2
X_5430_ _5430_/A1 _5456_/A2 _4597_/X VGND VGND VPWR VPWR _6542_/D sky130_fd_sc_hd__a21o_2
XFILLER_12_1232 VGND VGND VPWR VPWR sky130_fd_sc_hd__decap_3
XFILLER_51_1281 VGND VGND VPWR VPWR sky130_fd_sc_hd__decap_3
XFILLER_51_1292 VGND VGND VPWR VPWR sky130_fd_sc_hd__decap_3
XFILLER_65_3 VGND VGND VPWR VPWR sky130_fd_sc_hd__decap_3
XFILLER_12_1276 VGND VGND VPWR VPWR sky130_fd_sc_hd__decap_3
X_5361_ _5361_/A1 _5485_/A2 _4124_/X VGND VGND VPWR VPWR _6473_/D sky130_fd_sc_hd__a21o_2
X_4312_ _4312_/A _4312_/B VGND VGND VPWR VPWR _4694_/C sky130_fd_sc_hd__and2_2
XFILLER_47_1328 VGND VGND VPWR VPWR sky130_fd_sc_hd__decap_3
X_5292_ _6777_/Q _5356_/S wire127/A _5291_/Y VGND VGND VPWR VPWR _5292_/X sky130_fd_sc_hd__o211a_2
XTAP_TAPCELL_ROW_58_1698 VGND VPWR sky130_fd_sc_hd__tapvpwrvgnd_1
X_7031_ _7039_/CLK _7031_/D wire827/X VGND VGND VPWR VPWR _7031_/Q sky130_fd_sc_hd__dfrtp_2
X_4243_ _6485_/Q _4330_/A2 _4683_/A _4242_/Y VGND VGND VPWR VPWR _4243_/X sky130_fd_sc_hd__o211a_2
X_4174_ _6478_/Q _4174_/A2 _4597_/A _4173_/Y VGND VGND VPWR VPWR _4174_/X sky130_fd_sc_hd__o211a_2
XFILLER_68_754 VGND VGND VPWR VPWR sky130_fd_sc_hd__fill_2
XFILLER_67_242 VGND VGND VPWR VPWR sky130_fd_sc_hd__decap_3
X_3125_ _7058_/Q _3124_/X _3225_/S VGND VGND VPWR VPWR uo_out[0] sky130_fd_sc_hd__mux2_1
XFILLER_55_415 VGND VGND VPWR VPWR sky130_fd_sc_hd__decap_3
XFILLER_3_1422 VGND VGND VPWR VPWR sky130_fd_sc_hd__decap_3
XTAP_TAPCELL_ROW_2_249 VGND VPWR sky130_fd_sc_hd__tapvpwrvgnd_1
XFILLER_23_1372 VGND VGND VPWR VPWR sky130_fd_sc_hd__decap_3
XFILLER_3_1455 VGND VGND VPWR VPWR sky130_fd_sc_hd__fill_1
X_3056_ _6352_/Q VGND VGND VPWR VPWR _3056_/Y sky130_fd_sc_hd__inv_2
XFILLER_3_1466 VGND VGND VPWR VPWR sky130_fd_sc_hd__decap_3
XFILLER_36_662 VGND VGND VPWR VPWR sky130_fd_sc_hd__decap_3
XFILLER_58_1424 VGND VGND VPWR VPWR sky130_fd_sc_hd__decap_3
XFILLER_70_429 VGND VGND VPWR VPWR sky130_fd_sc_hd__decap_3
XFILLER_58_1435 VGND VGND VPWR VPWR sky130_fd_sc_hd__decap_3
XFILLER_35_172 VGND VGND VPWR VPWR sky130_fd_sc_hd__decap_3
XFILLER_19_1419 VGND VGND VPWR VPWR sky130_fd_sc_hd__decap_3
XFILLER_35_183 VGND VGND VPWR VPWR sky130_fd_sc_hd__decap_3
XFILLER_58_1468 VGND VGND VPWR VPWR sky130_fd_sc_hd__fill_1
X_6815_ _6847_/CLK _6815_/D load_slew819/X VGND VGND VPWR VPWR _6815_/Q sky130_fd_sc_hd__dfrtp_2
XFILLER_11_518 VGND VGND VPWR VPWR sky130_fd_sc_hd__decap_3
XFILLER_23_378 VGND VGND VPWR VPWR sky130_fd_sc_hd__decap_3
XFILLER_52_1001 VGND VGND VPWR VPWR sky130_fd_sc_hd__decap_3
XFILLER_56_1170 VGND VGND VPWR VPWR sky130_fd_sc_hd__decap_3
X_6746_ _6752_/CLK _6746_/D load_slew671/X VGND VGND VPWR VPWR _6746_/Q sky130_fd_sc_hd__dfrtp_2
XFILLER_56_1192 VGND VGND VPWR VPWR sky130_fd_sc_hd__fill_1
X_3958_ _4783_/A _5512_/A VGND VGND VPWR VPWR _3958_/Y sky130_fd_sc_hd__nand2_2
XFILLER_52_1067 VGND VGND VPWR VPWR sky130_fd_sc_hd__decap_3
X_6677_ _6765_/CLK _6677_/D wire641/X VGND VGND VPWR VPWR _6677_/Q sky130_fd_sc_hd__dfrtp_2
X_3889_ _3889_/A _3889_/B VGND VGND VPWR VPWR _5577_/B sky130_fd_sc_hd__or2_2
XFILLER_30_1332 VGND VGND VPWR VPWR sky130_fd_sc_hd__decap_3
X_5628_ _7069_/Q _5694_/C VGND VGND VPWR VPWR _5703_/B sky130_fd_sc_hd__xnor2_2
XFILLER_3_706 VGND VGND VPWR VPWR sky130_fd_sc_hd__decap_3
XFILLER_30_1365 VGND VGND VPWR VPWR sky130_fd_sc_hd__decap_3
XFILLER_30_1376 VGND VGND VPWR VPWR sky130_fd_sc_hd__decap_3
X_5559_ _6360_/Q _5501_/B _5559_/B1 _5562_/B2 VGND VGND VPWR VPWR _6642_/D sky130_fd_sc_hd__a22o_2
XFILLER_2_227 VGND VGND VPWR VPWR sky130_fd_sc_hd__decap_3
XFILLER_65_1428 VGND VGND VPWR VPWR sky130_fd_sc_hd__decap_3
XTAP_TAPCELL_ROW_70_2010 VGND VPWR sky130_fd_sc_hd__tapvpwrvgnd_1
XTAP_TAPCELL_ROW_70_2021 VGND VPWR sky130_fd_sc_hd__tapvpwrvgnd_1
XTAP_TAPCELL_ROW_70_2032 VGND VPWR sky130_fd_sc_hd__tapvpwrvgnd_1
XFILLER_8_1300 VGND VGND VPWR VPWR sky130_fd_sc_hd__decap_3
Xfanout520 _5322_/S VGND VGND VPWR VPWR _4963_/S sky130_fd_sc_hd__clkdlybuf4s25_1
XFILLER_28_1261 VGND VGND VPWR VPWR sky130_fd_sc_hd__decap_3
XFILLER_8_1344 VGND VGND VPWR VPWR sky130_fd_sc_hd__decap_3
Xfanout553 _7083_/Q VGND VGND VPWR VPWR _5304_/S sky130_fd_sc_hd__clkdlybuf4s25_1
XFILLER_76_47 VGND VGND VPWR VPWR sky130_fd_sc_hd__decap_3
XFILLER_28_1294 VGND VGND VPWR VPWR sky130_fd_sc_hd__decap_3
XFILLER_63_1174 VGND VGND VPWR VPWR sky130_fd_sc_hd__fill_2
XFILLER_4_1208 VGND VGND VPWR VPWR sky130_fd_sc_hd__decap_3
XFILLER_24_1136 VGND VGND VPWR VPWR sky130_fd_sc_hd__decap_3
Xfanout575 _6609_/Q VGND VGND VPWR VPWR _5517_/B2 sky130_fd_sc_hd__clkdlybuf4s25_1
XFILLER_47_916 VGND VGND VPWR VPWR sky130_fd_sc_hd__decap_3
Xfanout586 _6605_/Q VGND VGND VPWR VPWR _4420_/A sky130_fd_sc_hd__clkdlybuf4s25_1
XFILLER_59_776 VGND VGND VPWR VPWR sky130_fd_sc_hd__decap_3
XFILLER_8_1388 VGND VGND VPWR VPWR sky130_fd_sc_hd__decap_3
Xfanout597 _6604_/Q VGND VGND VPWR VPWR _4394_/B sky130_fd_sc_hd__clkdlybuf4s25_1
XFILLER_58_264 VGND VGND VPWR VPWR sky130_fd_sc_hd__decap_3
XFILLER_74_757 VGND VGND VPWR VPWR sky130_fd_sc_hd__decap_3
XFILLER_6_1090 VGND VGND VPWR VPWR sky130_fd_sc_hd__fill_2
XFILLER_62_908 VGND VGND VPWR VPWR sky130_fd_sc_hd__fill_1
XFILLER_26_150 VGND VGND VPWR VPWR sky130_fd_sc_hd__fill_2
XFILLER_27_673 VGND VGND VPWR VPWR sky130_fd_sc_hd__decap_3
XFILLER_54_470 VGND VGND VPWR VPWR sky130_fd_sc_hd__decap_3
XFILLER_14_312 VGND VGND VPWR VPWR sky130_fd_sc_hd__decap_3
XFILLER_70_952 VGND VGND VPWR VPWR sky130_fd_sc_hd__fill_2
XTAP_TAPCELL_ROW_25_841 VGND VPWR sky130_fd_sc_hd__tapvpwrvgnd_1
XFILLER_42_654 VGND VGND VPWR VPWR sky130_fd_sc_hd__decap_3
XTAP_TAPCELL_ROW_25_852 VGND VPWR sky130_fd_sc_hd__tapvpwrvgnd_1
XFILLER_25_73 VGND VGND VPWR VPWR sky130_fd_sc_hd__decap_3
XTAP_TAPCELL_ROW_25_863 VGND VPWR sky130_fd_sc_hd__tapvpwrvgnd_1
XFILLER_42_676 VGND VGND VPWR VPWR sky130_fd_sc_hd__decap_3
XFILLER_30_827 VGND VGND VPWR VPWR sky130_fd_sc_hd__fill_2
XFILLER_74_1270 VGND VGND VPWR VPWR sky130_fd_sc_hd__decap_3
XFILLER_39_1390 VGND VGND VPWR VPWR sky130_fd_sc_hd__decap_3
XFILLER_14_389 VGND VGND VPWR VPWR sky130_fd_sc_hd__decap_3
XTAP_TAPCELL_ROW_12_502 VGND VPWR sky130_fd_sc_hd__tapvpwrvgnd_1
XFILLER_41_175 VGND VGND VPWR VPWR sky130_fd_sc_hd__decap_3
XFILLER_42_698 VGND VGND VPWR VPWR sky130_fd_sc_hd__fill_2
XTAP_TAPCELL_ROW_12_513 VGND VPWR sky130_fd_sc_hd__tapvpwrvgnd_1
XFILLER_30_849 VGND VGND VPWR VPWR sky130_fd_sc_hd__fill_1
XTAP_TAPCELL_ROW_12_524 VGND VPWR sky130_fd_sc_hd__tapvpwrvgnd_1
XFILLER_35_1254 VGND VGND VPWR VPWR sky130_fd_sc_hd__decap_3
XTAP_TAPCELL_ROW_77_2208 VGND VPWR sky130_fd_sc_hd__tapvpwrvgnd_1
XFILLER_70_1167 VGND VGND VPWR VPWR sky130_fd_sc_hd__decap_3
XFILLER_35_1287 VGND VGND VPWR VPWR sky130_fd_sc_hd__fill_1
XFILLER_35_1298 VGND VGND VPWR VPWR sky130_fd_sc_hd__decap_3
XFILLER_6_522 VGND VGND VPWR VPWR sky130_fd_sc_hd__decap_3
XFILLER_6_533 VGND VGND VPWR VPWR sky130_fd_sc_hd__decap_3
XFILLER_6_577 VGND VGND VPWR VPWR sky130_fd_sc_hd__fill_1
XFILLER_51_9 VGND VGND VPWR VPWR sky130_fd_sc_hd__decap_3
XFILLER_9_1108 VGND VGND VPWR VPWR sky130_fd_sc_hd__decap_3
XFILLER_68_1096 VGND VGND VPWR VPWR sky130_fd_sc_hd__fill_2
XFILLER_46_1350 VGND VGND VPWR VPWR sky130_fd_sc_hd__decap_3
XFILLER_2_794 VGND VGND VPWR VPWR sky130_fd_sc_hd__decap_3
XFILLER_42_1203 VGND VGND VPWR VPWR sky130_fd_sc_hd__fill_1
XFILLER_1_293 VGND VGND VPWR VPWR sky130_fd_sc_hd__decap_3
XTAP_TAPCELL_ROW_53_1573 VGND VPWR sky130_fd_sc_hd__tapvpwrvgnd_1
XFILLER_2_44 VGND VGND VPWR VPWR sky130_fd_sc_hd__decap_3
XFILLER_46_1394 VGND VGND VPWR VPWR sky130_fd_sc_hd__decap_3
XTAP_TAPCELL_ROW_53_1584 VGND VPWR sky130_fd_sc_hd__tapvpwrvgnd_1
XFILLER_77_573 VGND VGND VPWR VPWR sky130_fd_sc_hd__fill_1
XFILLER_42_1258 VGND VGND VPWR VPWR sky130_fd_sc_hd__fill_2
XFILLER_2_77 VGND VGND VPWR VPWR sky130_fd_sc_hd__decap_3
XFILLER_2_88 VGND VGND VPWR VPWR sky130_fd_sc_hd__decap_3
XFILLER_65_735 VGND VGND VPWR VPWR sky130_fd_sc_hd__decap_3
XFILLER_66_80 VGND VGND VPWR VPWR sky130_fd_sc_hd__fill_1
XFILLER_65_779 VGND VGND VPWR VPWR sky130_fd_sc_hd__decap_3
XFILLER_80_716 VGND VGND VPWR VPWR sky130_fd_sc_hd__decap_3
XTAP_TAPCELL_ROW_66_1912 VGND VPWR sky130_fd_sc_hd__tapvpwrvgnd_1
XTAP_TAPCELL_ROW_66_1923 VGND VPWR sky130_fd_sc_hd__tapvpwrvgnd_1
XFILLER_80_738 VGND VGND VPWR VPWR sky130_fd_sc_hd__decap_3
X_4930_ _6444_/Q _6662_/Q VGND VGND VPWR VPWR _4931_/B sky130_fd_sc_hd__xor2_2
XFILLER_75_1023 VGND VGND VPWR VPWR sky130_fd_sc_hd__decap_3
XFILLER_79_1192 VGND VGND VPWR VPWR sky130_fd_sc_hd__decap_3
XTAP_TAPCELL_ROW_62_1809 VGND VPWR sky130_fd_sc_hd__tapvpwrvgnd_1
XFILLER_36_1007 VGND VGND VPWR VPWR sky130_fd_sc_hd__decap_3
X_4861_ _6314_/Q _4861_/A2 _3454_/X _4861_/B2 VGND VGND VPWR VPWR _4861_/X sky130_fd_sc_hd__a22o_2
XFILLER_32_131 VGND VGND VPWR VPWR sky130_fd_sc_hd__decap_3
XFILLER_75_1078 VGND VGND VPWR VPWR sky130_fd_sc_hd__decap_3
XFILLER_36_1029 VGND VGND VPWR VPWR sky130_fd_sc_hd__decap_3
XPHY_EDGE_ROW_25_Left_106 VGND VGND VPWR VPWR sky130_fd_sc_hd__decap_3
XFILLER_33_676 VGND VGND VPWR VPWR sky130_fd_sc_hd__decap_3
X_6600_ _6617_/CLK _6600_/D load_slew723/X VGND VGND VPWR VPWR _6600_/Q sky130_fd_sc_hd__dfrtp_2
XFILLER_21_827 VGND VGND VPWR VPWR sky130_fd_sc_hd__decap_3
XFILLER_53_1310 VGND VGND VPWR VPWR sky130_fd_sc_hd__decap_3
XFILLER_18_1441 VGND VGND VPWR VPWR sky130_fd_sc_hd__decap_3
X_3812_ _4292_/B _3812_/B VGND VGND VPWR VPWR _3813_/B sky130_fd_sc_hd__xor2_2
X_4792_ _4277_/B _6577_/Q _4835_/S VGND VGND VPWR VPWR _4793_/B sky130_fd_sc_hd__mux2_1
XANTENNA_16 _3915_/X VGND VGND VPWR VPWR sky130_fd_sc_hd__diode_2
XFILLER_14_890 VGND VGND VPWR VPWR sky130_fd_sc_hd__decap_3
XFILLER_53_1343 VGND VGND VPWR VPWR sky130_fd_sc_hd__fill_1
XANTENNA_27 _5887_/S VGND VGND VPWR VPWR sky130_fd_sc_hd__diode_2
XFILLER_20_337 VGND VGND VPWR VPWR sky130_fd_sc_hd__decap_3
XFILLER_32_197 VGND VGND VPWR VPWR sky130_fd_sc_hd__fill_2
XFILLER_53_1354 VGND VGND VPWR VPWR sky130_fd_sc_hd__decap_3
XANTENNA_38 fanout47/X VGND VGND VPWR VPWR sky130_fd_sc_hd__diode_2
XANTENNA_49 _5840_/S VGND VGND VPWR VPWR sky130_fd_sc_hd__diode_2
X_3743_ _5519_/A2 _3743_/B _4796_/A VGND VGND VPWR VPWR _3743_/X sky130_fd_sc_hd__and3b_2
X_6531_ _7000_/CLK _6531_/D load_slew723/X VGND VGND VPWR VPWR _6531_/Q sky130_fd_sc_hd__dfrtp_2
XFILLER_14_1338 VGND VGND VPWR VPWR sky130_fd_sc_hd__decap_3
XFILLER_53_1387 VGND VGND VPWR VPWR sky130_fd_sc_hd__decap_3
XFILLER_9_393 VGND VGND VPWR VPWR sky130_fd_sc_hd__decap_3
X_6462_ _7056_/CLK _6462_/D load_slew700/X VGND VGND VPWR VPWR _6462_/Q sky130_fd_sc_hd__dfrtp_2
X_3674_ _3674_/A _3674_/B VGND VGND VPWR VPWR _3676_/B sky130_fd_sc_hd__xnor2_2
X_5413_ _5413_/A1 _5477_/A2 _4528_/X VGND VGND VPWR VPWR _6525_/D sky130_fd_sc_hd__a21o_2
XFILLER_12_1073 VGND VGND VPWR VPWR sky130_fd_sc_hd__decap_3
X_6393_ _7051_/CLK _6393_/D fanout812/X VGND VGND VPWR VPWR _6393_/Q sky130_fd_sc_hd__dfrtp_2
X_5344_ _6803_/Q _5080_/B _5352_/S VGND VGND VPWR VPWR _5344_/X sky130_fd_sc_hd__mux2_1
XFILLER_47_1114 VGND VGND VPWR VPWR sky130_fd_sc_hd__decap_3
XPHY_EDGE_ROW_34_Left_115 VGND VGND VPWR VPWR sky130_fd_sc_hd__decap_3
X_5275_ _6433_/Q _5278_/A2 _5274_/X VGND VGND VPWR VPWR _6433_/D sky130_fd_sc_hd__a21o_2
XFILLER_47_1169 VGND VGND VPWR VPWR sky130_fd_sc_hd__decap_3
XFILLER_25_1401 VGND VGND VPWR VPWR sky130_fd_sc_hd__decap_3
XFILLER_64_1450 VGND VGND VPWR VPWR sky130_fd_sc_hd__decap_3
X_4226_ _6307_/Q _4868_/A2 _3248_/X _4868_/B2 VGND VGND VPWR VPWR _4226_/X sky130_fd_sc_hd__a22o_2
X_7014_ _7022_/CLK _7014_/D fanout750/X VGND VGND VPWR VPWR _7014_/Q sky130_fd_sc_hd__dfrtp_2
XFILLER_60_1303 VGND VGND VPWR VPWR sky130_fd_sc_hd__decap_3
XFILLER_25_1434 VGND VGND VPWR VPWR sky130_fd_sc_hd__decap_3
XFILLER_60_1347 VGND VGND VPWR VPWR sky130_fd_sc_hd__decap_3
X_4157_ _6814_/Q _4584_/A2 _4758_/B1 _4156_/X VGND VGND VPWR VPWR _4157_/X sky130_fd_sc_hd__a211o_2
X_3108_ _3108_/A _6081_/B VGND VGND VPWR VPWR _3108_/Y sky130_fd_sc_hd__nor2_2
XFILLER_56_768 VGND VGND VPWR VPWR sky130_fd_sc_hd__decap_3
X_4088_ _4088_/A1 _4768_/A _4586_/B _3085_/Y _6597_/Q VGND VGND VPWR VPWR _4088_/X
+ sky130_fd_sc_hd__a32o_2
XFILLER_3_1263 VGND VGND VPWR VPWR sky130_fd_sc_hd__decap_3
XFILLER_43_407 VGND VGND VPWR VPWR sky130_fd_sc_hd__decap_3
X_3039_ _6600_/Q VGND VGND VPWR VPWR _3039_/Y sky130_fd_sc_hd__inv_2
XFILLER_43_429 VGND VGND VPWR VPWR sky130_fd_sc_hd__decap_3
XFILLER_24_610 VGND VGND VPWR VPWR sky130_fd_sc_hd__decap_3
XFILLER_58_1243 VGND VGND VPWR VPWR sky130_fd_sc_hd__decap_3
XPHY_EDGE_ROW_43_Left_124 VGND VGND VPWR VPWR sky130_fd_sc_hd__decap_3
XTAP_TAPCELL_ROW_19_690 VGND VPWR sky130_fd_sc_hd__tapvpwrvgnd_1
XFILLER_24_643 VGND VGND VPWR VPWR sky130_fd_sc_hd__fill_1
XFILLER_70_259 VGND VGND VPWR VPWR sky130_fd_sc_hd__decap_3
XFILLER_58_1276 VGND VGND VPWR VPWR sky130_fd_sc_hd__decap_3
XFILLER_23_153 VGND VGND VPWR VPWR sky130_fd_sc_hd__decap_3
XFILLER_71_1410 VGND VGND VPWR VPWR sky130_fd_sc_hd__decap_3
XFILLER_12_827 VGND VGND VPWR VPWR sky130_fd_sc_hd__decap_3
XFILLER_11_326 VGND VGND VPWR VPWR sky130_fd_sc_hd__decap_3
XFILLER_71_1443 VGND VGND VPWR VPWR sky130_fd_sc_hd__decap_3
X_6729_ _6990_/CLK _6729_/D fanout747/X VGND VGND VPWR VPWR _6729_/Q sky130_fd_sc_hd__dfrtp_2
XFILLER_32_1427 VGND VGND VPWR VPWR sky130_fd_sc_hd__fill_1
XFILLER_32_1438 VGND VGND VPWR VPWR sky130_fd_sc_hd__decap_3
XPHY_EDGE_ROW_52_Left_133 VGND VGND VPWR VPWR sky130_fd_sc_hd__decap_3
XFILLER_69_1372 VGND VGND VPWR VPWR sky130_fd_sc_hd__decap_3
XFILLER_11_97 VGND VGND VPWR VPWR sky130_fd_sc_hd__decap_3
XFILLER_65_1225 VGND VGND VPWR VPWR sky130_fd_sc_hd__decap_3
XFILLER_65_1236 VGND VGND VPWR VPWR sky130_fd_sc_hd__decap_3
XFILLER_79_827 VGND VGND VPWR VPWR sky130_fd_sc_hd__decap_3
XFILLER_65_1269 VGND VGND VPWR VPWR sky130_fd_sc_hd__decap_3
XFILLER_8_1141 VGND VGND VPWR VPWR sky130_fd_sc_hd__decap_3
XTAP_TAPCELL_ROW_6_352 VGND VPWR sky130_fd_sc_hd__tapvpwrvgnd_1
XFILLER_28_1080 VGND VGND VPWR VPWR sky130_fd_sc_hd__decap_3
Xfanout350 _3903_/A2 VGND VGND VPWR VPWR _4740_/B sky130_fd_sc_hd__clkdlybuf4s25_1
XFILLER_8_1152 VGND VGND VPWR VPWR sky130_fd_sc_hd__decap_3
XTAP_TAPCELL_ROW_6_363 VGND VPWR sky130_fd_sc_hd__tapvpwrvgnd_1
Xfanout361 _3712_/B VGND VGND VPWR VPWR _3630_/C1 sky130_fd_sc_hd__clkdlybuf4s25_1
XFILLER_4_1005 VGND VGND VPWR VPWR sky130_fd_sc_hd__decap_3
XFILLER_47_713 VGND VGND VPWR VPWR sky130_fd_sc_hd__decap_3
XFILLER_8_1185 VGND VGND VPWR VPWR sky130_fd_sc_hd__decap_3
XFILLER_59_573 VGND VGND VPWR VPWR sky130_fd_sc_hd__fill_1
Xfanout394 _4757_/B2 VGND VGND VPWR VPWR _4735_/B2 sky130_fd_sc_hd__clkdlybuf4s25_1
XFILLER_47_735 VGND VGND VPWR VPWR sky130_fd_sc_hd__fill_1
XFILLER_19_437 VGND VGND VPWR VPWR sky130_fd_sc_hd__decap_3
XFILLER_4_1049 VGND VGND VPWR VPWR sky130_fd_sc_hd__decap_3
XFILLER_35_908 VGND VGND VPWR VPWR sky130_fd_sc_hd__fill_2
XFILLER_74_554 VGND VGND VPWR VPWR sky130_fd_sc_hd__fill_1
XFILLER_46_256 VGND VGND VPWR VPWR sky130_fd_sc_hd__fill_2
XFILLER_34_407 VGND VGND VPWR VPWR sky130_fd_sc_hd__decap_3
XFILLER_74_587 VGND VGND VPWR VPWR sky130_fd_sc_hd__fill_1
XPHY_EDGE_ROW_61_Left_142 VGND VGND VPWR VPWR sky130_fd_sc_hd__decap_3
XFILLER_62_727 VGND VGND VPWR VPWR sky130_fd_sc_hd__decap_3
XFILLER_74_598 VGND VGND VPWR VPWR sky130_fd_sc_hd__decap_3
XFILLER_15_610 VGND VGND VPWR VPWR sky130_fd_sc_hd__decap_3
XFILLER_76_1332 VGND VGND VPWR VPWR sky130_fd_sc_hd__decap_3
XTAP_TAPCELL_ROW_17_638 VGND VPWR sky130_fd_sc_hd__tapvpwrvgnd_1
XTAP_TAPCELL_ROW_17_649 VGND VPWR sky130_fd_sc_hd__tapvpwrvgnd_1
XFILLER_76_1365 VGND VGND VPWR VPWR sky130_fd_sc_hd__decap_3
XFILLER_37_1316 VGND VGND VPWR VPWR sky130_fd_sc_hd__decap_3
XFILLER_76_1376 VGND VGND VPWR VPWR sky130_fd_sc_hd__decap_3
XFILLER_43_974 VGND VGND VPWR VPWR sky130_fd_sc_hd__decap_3
XFILLER_72_1229 VGND VGND VPWR VPWR sky130_fd_sc_hd__decap_3
XFILLER_14_153 VGND VGND VPWR VPWR sky130_fd_sc_hd__decap_3
XFILLER_42_462 VGND VGND VPWR VPWR sky130_fd_sc_hd__decap_3
XFILLER_70_782 VGND VGND VPWR VPWR sky130_fd_sc_hd__fill_1
XFILLER_30_624 VGND VGND VPWR VPWR sky130_fd_sc_hd__fill_1
XFILLER_35_1062 VGND VGND VPWR VPWR sky130_fd_sc_hd__fill_2
XFILLER_30_679 VGND VGND VPWR VPWR sky130_fd_sc_hd__decap_3
XFILLER_11_860 VGND VGND VPWR VPWR sky130_fd_sc_hd__fill_1
Xinput14 uio_in[4] VGND VGND VPWR VPWR _7095_/D sky130_fd_sc_hd__clkdlybuf4s25_1
XTAP_TAPCELL_ROW_42_1285 VGND VPWR sky130_fd_sc_hd__tapvpwrvgnd_1
XTAP_TAPCELL_ROW_42_1296 VGND VPWR sky130_fd_sc_hd__tapvpwrvgnd_1
XFILLER_7_853 VGND VGND VPWR VPWR sky130_fd_sc_hd__decap_3
XFILLER_13_1360 VGND VGND VPWR VPWR sky130_fd_sc_hd__decap_3
XFILLER_6_352 VGND VGND VPWR VPWR sky130_fd_sc_hd__decap_3
XPHY_EDGE_ROW_70_Left_151 VGND VGND VPWR VPWR sky130_fd_sc_hd__decap_3
XFILLER_13_1393 VGND VGND VPWR VPWR sky130_fd_sc_hd__decap_3
XFILLER_48_1412 VGND VGND VPWR VPWR sky130_fd_sc_hd__decap_3
X_3390_ _6314_/Q _6426_/Q VGND VGND VPWR VPWR _3390_/X sky130_fd_sc_hd__xor2_2
XTAP_TAPCELL_ROW_55_1624 VGND VPWR sky130_fd_sc_hd__tapvpwrvgnd_1
XTAP_TAPCELL_ROW_55_1635 VGND VPWR sky130_fd_sc_hd__tapvpwrvgnd_1
XFILLER_48_1456 VGND VGND VPWR VPWR sky130_fd_sc_hd__decap_3
XFILLER_69_304 VGND VGND VPWR VPWR sky130_fd_sc_hd__decap_3
XFILLER_44_1309 VGND VGND VPWR VPWR sky130_fd_sc_hd__decap_3
Xload_slew723 fanout722/X VGND VGND VPWR VPWR load_slew723/X sky130_fd_sc_hd__buf_4
XFILLER_69_337 VGND VGND VPWR VPWR sky130_fd_sc_hd__decap_3
X_5060_ _5058_/X _5059_/Y _5269_/A2 VGND VGND VPWR VPWR _5062_/S sky130_fd_sc_hd__a21oi_2
XFILLER_28_3 VGND VGND VPWR VPWR sky130_fd_sc_hd__decap_3
Xhold1509 _6573_/Q VGND VGND VPWR VPWR _5461_/A1 sky130_fd_sc_hd__dlygate4sd3_1
Xload_slew767 fanout766/X VGND VGND VPWR VPWR load_slew767/X sky130_fd_sc_hd__clkbuf_4
Xload_slew778 fanout777/X VGND VGND VPWR VPWR load_slew778/X sky130_fd_sc_hd__buf_4
Xload_slew789 fanout788/X VGND VGND VPWR VPWR fanout779/A sky130_fd_sc_hd__buf_2
XFILLER_42_1033 VGND VGND VPWR VPWR sky130_fd_sc_hd__decap_3
X_4011_ _6560_/Q _4572_/B VGND VGND VPWR VPWR _4011_/Y sky130_fd_sc_hd__nand2_2
XFILLER_65_521 VGND VGND VPWR VPWR sky130_fd_sc_hd__decap_3
XFILLER_37_234 VGND VGND VPWR VPWR sky130_fd_sc_hd__decap_3
XFILLER_20_1320 VGND VGND VPWR VPWR sky130_fd_sc_hd__decap_3
XFILLER_77_1107 VGND VGND VPWR VPWR sky130_fd_sc_hd__decap_3
XFILLER_37_256 VGND VGND VPWR VPWR sky130_fd_sc_hd__decap_3
XFILLER_38_779 VGND VGND VPWR VPWR sky130_fd_sc_hd__decap_3
XFILLER_53_705 VGND VGND VPWR VPWR sky130_fd_sc_hd__fill_2
XFILLER_19_971 VGND VGND VPWR VPWR sky130_fd_sc_hd__decap_3
XFILLER_0_1425 VGND VGND VPWR VPWR sky130_fd_sc_hd__decap_3
XFILLER_20_1353 VGND VGND VPWR VPWR sky130_fd_sc_hd__decap_3
XFILLER_53_738 VGND VGND VPWR VPWR sky130_fd_sc_hd__decap_3
XFILLER_65_598 VGND VGND VPWR VPWR sky130_fd_sc_hd__decap_3
X_5962_ _5962_/A0 _5962_/A1 _5970_/S VGND VGND VPWR VPWR _6966_/D sky130_fd_sc_hd__mux2_1
XFILLER_0_1447 VGND VGND VPWR VPWR sky130_fd_sc_hd__decap_3
XFILLER_46_790 VGND VGND VPWR VPWR sky130_fd_sc_hd__decap_3
XFILLER_18_492 VGND VGND VPWR VPWR sky130_fd_sc_hd__decap_3
XFILLER_20_1397 VGND VGND VPWR VPWR sky130_fd_sc_hd__decap_3
XFILLER_34_963 VGND VGND VPWR VPWR sky130_fd_sc_hd__decap_3
XFILLER_55_1416 VGND VGND VPWR VPWR sky130_fd_sc_hd__decap_3
X_4913_ _4911_/X _4912_/Y _5278_/A2 VGND VGND VPWR VPWR _4915_/S sky130_fd_sc_hd__a21oi_2
X_5893_ _5929_/A0 _5893_/A1 _5896_/S VGND VGND VPWR VPWR _6902_/D sky130_fd_sc_hd__mux2_1
XFILLER_33_473 VGND VGND VPWR VPWR sky130_fd_sc_hd__decap_3
XFILLER_55_1449 VGND VGND VPWR VPWR sky130_fd_sc_hd__decap_3
XFILLER_61_782 VGND VGND VPWR VPWR sky130_fd_sc_hd__fill_2
X_4844_ _4894_/A _4844_/B VGND VGND VPWR VPWR _4844_/Y sky130_fd_sc_hd__nor2_2
XFILLER_20_112 VGND VGND VPWR VPWR sky130_fd_sc_hd__decap_3
XFILLER_33_495 VGND VGND VPWR VPWR sky130_fd_sc_hd__decap_3
XFILLER_60_292 VGND VGND VPWR VPWR sky130_fd_sc_hd__decap_3
XFILLER_18_1282 VGND VGND VPWR VPWR sky130_fd_sc_hd__decap_3
XFILLER_14_1124 VGND VGND VPWR VPWR sky130_fd_sc_hd__decap_3
X_4775_ _6326_/Q _4775_/A2 _4772_/X _4774_/X VGND VGND VPWR VPWR _6326_/D sky130_fd_sc_hd__o22a_2
X_6514_ _6926_/CLK _6514_/D fanout759/X VGND VGND VPWR VPWR _6514_/Q sky130_fd_sc_hd__dfrtp_2
X_3726_ _6288_/Q _3960_/B _3921_/B1 _6264_/Q _3921_/C1 VGND VGND VPWR VPWR _3726_/X
+ sky130_fd_sc_hd__a221o_2
XFILLER_9_190 VGND VGND VPWR VPWR sky130_fd_sc_hd__decap_3
XFILLER_31_1460 VGND VGND VPWR VPWR sky130_fd_sc_hd__decap_3
X_6445_ _7007_/CLK _6445_/D load_slew822/X VGND VGND VPWR VPWR _6445_/Q sky130_fd_sc_hd__dfrtp_2
X_3657_ _3681_/A _3681_/B VGND VGND VPWR VPWR _3693_/A sky130_fd_sc_hd__and2_2
X_3588_ _3689_/A _3588_/B _3588_/C VGND VGND VPWR VPWR _3661_/C sky130_fd_sc_hd__nand3_2
X_6376_ _6752_/CLK _6376_/D load_slew669/X VGND VGND VPWR VPWR _6376_/Q sky130_fd_sc_hd__dfrtp_2
XFILLER_0_517 VGND VGND VPWR VPWR sky130_fd_sc_hd__decap_3
X_5327_ _6456_/Q _5326_/X _5327_/S VGND VGND VPWR VPWR _6456_/D sky130_fd_sc_hd__mux2_1
XFILLER_62_1409 VGND VGND VPWR VPWR sky130_fd_sc_hd__decap_3
XFILLER_0_539 VGND VGND VPWR VPWR sky130_fd_sc_hd__decap_3
X_5258_ _5334_/S _5258_/B VGND VGND VPWR VPWR _5258_/Y sky130_fd_sc_hd__nand2_2
XFILLER_25_1242 VGND VGND VPWR VPWR sky130_fd_sc_hd__decap_3
XFILLER_64_1291 VGND VGND VPWR VPWR sky130_fd_sc_hd__decap_3
XFILLER_29_713 VGND VGND VPWR VPWR sky130_fd_sc_hd__decap_3
XFILLER_60_1133 VGND VGND VPWR VPWR sky130_fd_sc_hd__fill_2
XFILLER_5_1325 VGND VGND VPWR VPWR sky130_fd_sc_hd__decap_3
X_4209_ _5605_/A3 _6482_/Q _4257_/S VGND VGND VPWR VPWR _4209_/X sky130_fd_sc_hd__mux2_1
X_5189_ _5188_/Y _5098_/X _5281_/A2 _6403_/Q VGND VGND VPWR VPWR _6403_/D sky130_fd_sc_hd__a2bb2o_2
XFILLER_25_1275 VGND VGND VPWR VPWR sky130_fd_sc_hd__decap_3
XFILLER_56_521 VGND VGND VPWR VPWR sky130_fd_sc_hd__fill_2
XFILLER_68_381 VGND VGND VPWR VPWR sky130_fd_sc_hd__decap_3
XFILLER_5_1369 VGND VGND VPWR VPWR sky130_fd_sc_hd__decap_3
XFILLER_29_757 VGND VGND VPWR VPWR sky130_fd_sc_hd__decap_3
XFILLER_29_779 VGND VGND VPWR VPWR sky130_fd_sc_hd__decap_3
XTAP_TAPCELL_ROW_27_903 VGND VPWR sky130_fd_sc_hd__tapvpwrvgnd_1
XFILLER_73_15 VGND VGND VPWR VPWR sky130_fd_sc_hd__decap_3
XFILLER_28_267 VGND VGND VPWR VPWR sky130_fd_sc_hd__decap_3
XFILLER_56_576 VGND VGND VPWR VPWR sky130_fd_sc_hd__decap_3
XFILLER_3_1060 VGND VGND VPWR VPWR sky130_fd_sc_hd__decap_3
XTAP_TAPCELL_ROW_27_914 VGND VPWR sky130_fd_sc_hd__tapvpwrvgnd_1
XFILLER_3_1071 VGND VGND VPWR VPWR sky130_fd_sc_hd__decap_3
XFILLER_73_48 VGND VGND VPWR VPWR sky130_fd_sc_hd__decap_3
XFILLER_71_535 VGND VGND VPWR VPWR sky130_fd_sc_hd__decap_3
Xwire60 wire60/A VGND VGND VPWR VPWR wire60/X sky130_fd_sc_hd__buf_4
XFILLER_43_248 VGND VGND VPWR VPWR sky130_fd_sc_hd__decap_3
Xwire93 wire93/A VGND VGND VPWR VPWR wire93/X sky130_fd_sc_hd__clkbuf_8
XFILLER_12_613 VGND VGND VPWR VPWR sky130_fd_sc_hd__fill_2
XFILLER_19_1046 VGND VGND VPWR VPWR sky130_fd_sc_hd__decap_3
XFILLER_40_955 VGND VGND VPWR VPWR sky130_fd_sc_hd__decap_3
XFILLER_51_292 VGND VGND VPWR VPWR sky130_fd_sc_hd__decap_3
XFILLER_11_134 VGND VGND VPWR VPWR sky130_fd_sc_hd__fill_1
XFILLER_71_1251 VGND VGND VPWR VPWR sky130_fd_sc_hd__decap_3
XFILLER_8_617 VGND VGND VPWR VPWR sky130_fd_sc_hd__fill_1
XFILLER_36_1371 VGND VGND VPWR VPWR sky130_fd_sc_hd__fill_1
XFILLER_11_156 VGND VGND VPWR VPWR sky130_fd_sc_hd__decap_3
XFILLER_36_1382 VGND VGND VPWR VPWR sky130_fd_sc_hd__decap_3
XFILLER_71_1284 VGND VGND VPWR VPWR sky130_fd_sc_hd__decap_3
XFILLER_32_1235 VGND VGND VPWR VPWR sky130_fd_sc_hd__decap_3
XFILLER_71_1295 VGND VGND VPWR VPWR sky130_fd_sc_hd__decap_3
XFILLER_20_690 VGND VGND VPWR VPWR sky130_fd_sc_hd__fill_1
XFILLER_32_1279 VGND VGND VPWR VPWR sky130_fd_sc_hd__decap_3
XFILLER_22_85 VGND VGND VPWR VPWR sky130_fd_sc_hd__decap_3
XFILLER_4_834 VGND VGND VPWR VPWR sky130_fd_sc_hd__decap_3
XFILLER_3_311 VGND VGND VPWR VPWR sky130_fd_sc_hd__fill_1
XFILLER_4_867 VGND VGND VPWR VPWR sky130_fd_sc_hd__fill_1
XPHY_EDGE_ROW_5_Left_86 VGND VGND VPWR VPWR sky130_fd_sc_hd__decap_3
XFILLER_69_1180 VGND VGND VPWR VPWR sky130_fd_sc_hd__decap_3
XFILLER_3_355 VGND VGND VPWR VPWR sky130_fd_sc_hd__decap_3
XFILLER_79_635 VGND VGND VPWR VPWR sky130_fd_sc_hd__decap_3
XFILLER_3_399 VGND VGND VPWR VPWR sky130_fd_sc_hd__decap_3
XTAP_TAPCELL_ROW_50_1510 VGND VPWR sky130_fd_sc_hd__tapvpwrvgnd_1
XFILLER_43_1331 VGND VGND VPWR VPWR sky130_fd_sc_hd__decap_3
Xfanout180 wire183/A VGND VGND VPWR VPWR _3473_/S sky130_fd_sc_hd__clkdlybuf4s25_1
XFILLER_14_9 VGND VGND VPWR VPWR sky130_fd_sc_hd__decap_3
XFILLER_43_1375 VGND VGND VPWR VPWR sky130_fd_sc_hd__decap_3
XFILLER_75_841 VGND VGND VPWR VPWR sky130_fd_sc_hd__decap_3
XFILLER_19_234 VGND VGND VPWR VPWR sky130_fd_sc_hd__decap_3
XFILLER_47_60 VGND VGND VPWR VPWR sky130_fd_sc_hd__decap_3
XFILLER_78_1427 VGND VGND VPWR VPWR sky130_fd_sc_hd__fill_1
XFILLER_35_716 VGND VGND VPWR VPWR sky130_fd_sc_hd__decap_3
XFILLER_78_1438 VGND VGND VPWR VPWR sky130_fd_sc_hd__decap_3
XFILLER_16_952 VGND VGND VPWR VPWR sky130_fd_sc_hd__decap_3
XTAP_TAPCELL_ROW_48_1450 VGND VPWR sky130_fd_sc_hd__tapvpwrvgnd_1
XFILLER_34_259 VGND VGND VPWR VPWR sky130_fd_sc_hd__decap_3
XTAP_TAPCELL_ROW_48_1461 VGND VPWR sky130_fd_sc_hd__tapvpwrvgnd_1
XFILLER_31_900 VGND VGND VPWR VPWR sky130_fd_sc_hd__decap_3
XFILLER_37_1113 VGND VGND VPWR VPWR sky130_fd_sc_hd__decap_3
XFILLER_76_1173 VGND VGND VPWR VPWR sky130_fd_sc_hd__decap_3
XFILLER_43_782 VGND VGND VPWR VPWR sky130_fd_sc_hd__fill_2
XFILLER_15_484 VGND VGND VPWR VPWR sky130_fd_sc_hd__decap_3
XFILLER_30_410 VGND VGND VPWR VPWR sky130_fd_sc_hd__decap_3
XTAP_TAPCELL_ROW_44_1336 VGND VPWR sky130_fd_sc_hd__tapvpwrvgnd_1
XTAP_TAPCELL_ROW_44_1347 VGND VPWR sky130_fd_sc_hd__tapvpwrvgnd_1
XFILLER_8_21 VGND VGND VPWR VPWR sky130_fd_sc_hd__decap_3
XFILLER_8_32 VGND VGND VPWR VPWR sky130_fd_sc_hd__decap_3
XFILLER_30_454 VGND VGND VPWR VPWR sky130_fd_sc_hd__decap_3
XFILLER_15_1422 VGND VGND VPWR VPWR sky130_fd_sc_hd__decap_3
XFILLER_31_999 VGND VGND VPWR VPWR sky130_fd_sc_hd__fill_1
XFILLER_15_1455 VGND VGND VPWR VPWR sky130_fd_sc_hd__fill_1
XFILLER_50_1335 VGND VGND VPWR VPWR sky130_fd_sc_hd__decap_3
XFILLER_30_498 VGND VGND VPWR VPWR sky130_fd_sc_hd__fill_1
X_4560_ _6875_/Q _4744_/A2 _4744_/B1 _4559_/X VGND VGND VPWR VPWR _4560_/X sky130_fd_sc_hd__a211o_2
XFILLER_15_1466 VGND VGND VPWR VPWR sky130_fd_sc_hd__decap_3
XFILLER_11_1319 VGND VGND VPWR VPWR sky130_fd_sc_hd__decap_3
XFILLER_50_1368 VGND VGND VPWR VPWR sky130_fd_sc_hd__decap_3
XFILLER_7_661 VGND VGND VPWR VPWR sky130_fd_sc_hd__decap_3
XFILLER_50_1379 VGND VGND VPWR VPWR sky130_fd_sc_hd__decap_3
X_3511_ _3509_/X _3510_/X _4723_/B VGND VGND VPWR VPWR _3512_/B sky130_fd_sc_hd__mux2_1
X_4491_ _4787_/C1 _4488_/X _4489_/Y _4490_/X _4788_/A VGND VGND VPWR VPWR _4491_/X
+ sky130_fd_sc_hd__o221a_2
X_3442_ _6332_/Q _6452_/Q VGND VGND VPWR VPWR _3442_/X sky130_fd_sc_hd__xor2_2
X_6230_ _7000_/CLK _6230_/D fanout721/X VGND VGND VPWR VPWR _6230_/Q sky130_fd_sc_hd__dfrtp_2
XFILLER_6_193 VGND VGND VPWR VPWR sky130_fd_sc_hd__decap_3
XFILLER_48_1242 VGND VGND VPWR VPWR sky130_fd_sc_hd__decap_3
X_6161_ _6988_/CLK _6161_/D load_slew813/X VGND VGND VPWR VPWR _6161_/Q sky130_fd_sc_hd__dfrtp_2
X_3373_ _6007_/A0 _3372_/X _3453_/S VGND VGND VPWR VPWR _6160_/D sky130_fd_sc_hd__mux2_1
XFILLER_48_1264 VGND VGND VPWR VPWR sky130_fd_sc_hd__decap_3
X_5112_ _6437_/Q _5112_/B VGND VGND VPWR VPWR _5285_/B sky130_fd_sc_hd__xnor2_2
XFILLER_48_1297 VGND VGND VPWR VPWR sky130_fd_sc_hd__decap_3
Xload_slew531 _5354_/S VGND VGND VPWR VPWR _5219_/A sky130_fd_sc_hd__buf_4
XFILLER_44_1139 VGND VGND VPWR VPWR sky130_fd_sc_hd__decap_3
X_6092_ _6943_/CLK _6092_/D fanout818/X VGND VGND VPWR VPWR _6092_/Q sky130_fd_sc_hd__dfrtp_2
Xload_slew542 _5210_/A VGND VGND VPWR VPWR _5350_/S sky130_fd_sc_hd__clkbuf_2
XFILLER_69_145 VGND VGND VPWR VPWR sky130_fd_sc_hd__fill_1
XFILLER_58_819 VGND VGND VPWR VPWR sky130_fd_sc_hd__decap_3
XFILLER_61_1431 VGND VGND VPWR VPWR sky130_fd_sc_hd__decap_3
Xhold1306 _6773_/Q VGND VGND VPWR VPWR _5726_/A1 sky130_fd_sc_hd__dlygate4sd3_1
Xhold1317 _6757_/Q VGND VGND VPWR VPWR _5708_/A1 sky130_fd_sc_hd__dlygate4sd3_1
X_5043_ _6428_/Q _5043_/B VGND VGND VPWR VPWR _5258_/B sky130_fd_sc_hd__xnor2_2
Xhold1328 _6759_/Q VGND VGND VPWR VPWR _5710_/A1 sky130_fd_sc_hd__dlygate4sd3_1
XFILLER_22_1415 VGND VGND VPWR VPWR sky130_fd_sc_hd__decap_3
Xhold1339 _6914_/Q VGND VGND VPWR VPWR _5907_/A1 sky130_fd_sc_hd__dlygate4sd3_1
XFILLER_22_1459 VGND VGND VPWR VPWR sky130_fd_sc_hd__decap_3
XFILLER_26_716 VGND VGND VPWR VPWR sky130_fd_sc_hd__decap_3
XFILLER_65_351 VGND VGND VPWR VPWR sky130_fd_sc_hd__decap_3
XFILLER_25_204 VGND VGND VPWR VPWR sky130_fd_sc_hd__decap_3
XFILLER_0_1211 VGND VGND VPWR VPWR sky130_fd_sc_hd__decap_3
XFILLER_65_384 VGND VGND VPWR VPWR sky130_fd_sc_hd__decap_3
XFILLER_4_1391 VGND VGND VPWR VPWR sky130_fd_sc_hd__decap_3
XFILLER_0_1233 VGND VGND VPWR VPWR sky130_fd_sc_hd__decap_3
X_6994_ _7077_/CLK _6994_/D load_slew679/X VGND VGND VPWR VPWR _6994_/Q sky130_fd_sc_hd__dfrtp_2
XFILLER_59_1360 VGND VGND VPWR VPWR sky130_fd_sc_hd__decap_3
X_5945_ hold971/X hold978/X _6049_/S VGND VGND VPWR VPWR _6949_/D sky130_fd_sc_hd__mux2_1
XFILLER_55_1202 VGND VGND VPWR VPWR sky130_fd_sc_hd__decap_3
XFILLER_43_18 VGND VGND VPWR VPWR sky130_fd_sc_hd__decap_3
XFILLER_59_1393 VGND VGND VPWR VPWR sky130_fd_sc_hd__decap_3
XFILLER_22_922 VGND VGND VPWR VPWR sky130_fd_sc_hd__fill_2
XFILLER_34_793 VGND VGND VPWR VPWR sky130_fd_sc_hd__decap_3
XFILLER_16_1208 VGND VGND VPWR VPWR sky130_fd_sc_hd__decap_3
X_5876_ _6887_/Q _5868_/Y _5915_/C _5797_/X VGND VGND VPWR VPWR _6887_/D sky130_fd_sc_hd__a22o_2
XFILLER_33_281 VGND VGND VPWR VPWR sky130_fd_sc_hd__decap_3
XFILLER_55_1257 VGND VGND VPWR VPWR sky130_fd_sc_hd__decap_3
XFILLER_21_443 VGND VGND VPWR VPWR sky130_fd_sc_hd__decap_3
XFILLER_22_966 VGND VGND VPWR VPWR sky130_fd_sc_hd__decap_3
XFILLER_22_977 VGND VGND VPWR VPWR sky130_fd_sc_hd__decap_3
X_4827_ _6333_/Q _4863_/A2 _4824_/X _4826_/X VGND VGND VPWR VPWR _6333_/D sky130_fd_sc_hd__o22a_2
XFILLER_22_999 VGND VGND VPWR VPWR sky130_fd_sc_hd__decap_3
XFILLER_18_1090 VGND VGND VPWR VPWR sky130_fd_sc_hd__fill_2
XFILLER_21_487 VGND VGND VPWR VPWR sky130_fd_sc_hd__decap_3
X_4758_ _6910_/Q _4758_/A2 _4758_/B1 _4757_/X VGND VGND VPWR VPWR _4758_/X sky130_fd_sc_hd__a211o_2
X_3709_ _3709_/A _3709_/B VGND VGND VPWR VPWR wire25/A sky130_fd_sc_hd__xnor2_4
XFILLER_4_119 VGND VGND VPWR VPWR sky130_fd_sc_hd__decap_3
X_4689_ _6555_/Q _4717_/A _4888_/C1 VGND VGND VPWR VPWR _4689_/X sky130_fd_sc_hd__a21bo_2
X_6428_ _7046_/CLK _6428_/D load_slew754/X VGND VGND VPWR VPWR _6428_/Q sky130_fd_sc_hd__dfrtp_2
XTAP_TAPCELL_ROW_8_403 VGND VPWR sky130_fd_sc_hd__tapvpwrvgnd_1
XFILLER_66_1320 VGND VGND VPWR VPWR sky130_fd_sc_hd__decap_3
XTAP_TAPCELL_ROW_8_414 VGND VPWR sky130_fd_sc_hd__tapvpwrvgnd_1
XFILLER_1_815 VGND VGND VPWR VPWR sky130_fd_sc_hd__decap_3
XFILLER_68_15 VGND VGND VPWR VPWR sky130_fd_sc_hd__decap_3
XFILLER_27_1304 VGND VGND VPWR VPWR sky130_fd_sc_hd__decap_3
XFILLER_66_1353 VGND VGND VPWR VPWR sky130_fd_sc_hd__decap_3
X_6359_ _6819_/CLK _6359_/D fanout749/X VGND VGND VPWR VPWR _6359_/Q sky130_fd_sc_hd__dfrtp_2
XFILLER_1_859 VGND VGND VPWR VPWR sky130_fd_sc_hd__decap_3
XFILLER_62_1217 VGND VGND VPWR VPWR sky130_fd_sc_hd__decap_3
XFILLER_27_1337 VGND VGND VPWR VPWR sky130_fd_sc_hd__decap_3
XFILLER_68_59 VGND VGND VPWR VPWR sky130_fd_sc_hd__decap_3
XFILLER_27_1348 VGND VGND VPWR VPWR sky130_fd_sc_hd__decap_3
XFILLER_66_1397 VGND VGND VPWR VPWR sky130_fd_sc_hd__decap_3
XFILLER_0_358 VGND VGND VPWR VPWR sky130_fd_sc_hd__decap_3
XFILLER_76_638 VGND VGND VPWR VPWR sky130_fd_sc_hd__decap_3
XFILLER_5_1133 VGND VGND VPWR VPWR sky130_fd_sc_hd__decap_3
XFILLER_57_841 VGND VGND VPWR VPWR sky130_fd_sc_hd__fill_2
XFILLER_5_1166 VGND VGND VPWR VPWR sky130_fd_sc_hd__decap_3
XFILLER_5_1177 VGND VGND VPWR VPWR sky130_fd_sc_hd__decap_3
XFILLER_57_885 VGND VGND VPWR VPWR sky130_fd_sc_hd__decap_3
XFILLER_17_727 VGND VGND VPWR VPWR sky130_fd_sc_hd__fill_1
XFILLER_44_513 VGND VGND VPWR VPWR sky130_fd_sc_hd__fill_1
XFILLER_72_833 VGND VGND VPWR VPWR sky130_fd_sc_hd__decap_3
XFILLER_17_738 VGND VGND VPWR VPWR sky130_fd_sc_hd__decap_3
XFILLER_72_866 VGND VGND VPWR VPWR sky130_fd_sc_hd__fill_2
XFILLER_38_1400 VGND VGND VPWR VPWR sky130_fd_sc_hd__decap_3
XFILLER_16_259 VGND VGND VPWR VPWR sky130_fd_sc_hd__decap_3
XFILLER_77_1460 VGND VGND VPWR VPWR sky130_fd_sc_hd__decap_3
XFILLER_73_1313 VGND VGND VPWR VPWR sky130_fd_sc_hd__decap_3
XFILLER_71_376 VGND VGND VPWR VPWR sky130_fd_sc_hd__decap_3
XFILLER_38_1444 VGND VGND VPWR VPWR sky130_fd_sc_hd__decap_3
XFILLER_12_421 VGND VGND VPWR VPWR sky130_fd_sc_hd__decap_3
XFILLER_40_730 VGND VGND VPWR VPWR sky130_fd_sc_hd__decap_3
XFILLER_73_1357 VGND VGND VPWR VPWR sky130_fd_sc_hd__decap_3
XFILLER_12_454 VGND VGND VPWR VPWR sky130_fd_sc_hd__fill_2
XFILLER_40_763 VGND VGND VPWR VPWR sky130_fd_sc_hd__fill_2
XFILLER_9_937 VGND VGND VPWR VPWR sky130_fd_sc_hd__decap_3
XFILLER_32_1032 VGND VGND VPWR VPWR sky130_fd_sc_hd__decap_3
XFILLER_32_1043 VGND VGND VPWR VPWR sky130_fd_sc_hd__fill_2
XFILLER_32_1087 VGND VGND VPWR VPWR sky130_fd_sc_hd__decap_3
XFILLER_10_1341 VGND VGND VPWR VPWR sky130_fd_sc_hd__decap_3
XFILLER_4_631 VGND VGND VPWR VPWR sky130_fd_sc_hd__decap_3
XFILLER_67_1117 VGND VGND VPWR VPWR sky130_fd_sc_hd__decap_3
XFILLER_4_664 VGND VGND VPWR VPWR sky130_fd_sc_hd__decap_3
XFILLER_10_1385 VGND VGND VPWR VPWR sky130_fd_sc_hd__decap_3
XFILLER_79_410 VGND VGND VPWR VPWR sky130_fd_sc_hd__decap_3
XFILLER_45_1404 VGND VGND VPWR VPWR sky130_fd_sc_hd__decap_3
XTAP_TAPCELL_ROW_37_1151 VGND VPWR sky130_fd_sc_hd__tapvpwrvgnd_1
XFILLER_80_1317 VGND VGND VPWR VPWR sky130_fd_sc_hd__decap_3
XTAP_TAPCELL_ROW_37_1162 VGND VPWR sky130_fd_sc_hd__tapvpwrvgnd_1
XTAP_TAPCELL_ROW_37_1173 VGND VPWR sky130_fd_sc_hd__tapvpwrvgnd_1
XFILLER_45_1437 VGND VGND VPWR VPWR sky130_fd_sc_hd__decap_3
XFILLER_67_605 VGND VGND VPWR VPWR sky130_fd_sc_hd__decap_3
XTAP_TAPCELL_ROW_33_1048 VGND VPWR sky130_fd_sc_hd__tapvpwrvgnd_1
XFILLER_0_881 VGND VGND VPWR VPWR sky130_fd_sc_hd__decap_3
XTAP_TAPCELL_ROW_33_1059 VGND VPWR sky130_fd_sc_hd__tapvpwrvgnd_1
XFILLER_66_126 VGND VGND VPWR VPWR sky130_fd_sc_hd__decap_3
XFILLER_12_6 VGND VGND VPWR VPWR sky130_fd_sc_hd__decap_3
XFILLER_43_1183 VGND VGND VPWR VPWR sky130_fd_sc_hd__decap_3
XFILLER_47_340 VGND VGND VPWR VPWR sky130_fd_sc_hd__fill_1
XFILLER_35_502 VGND VGND VPWR VPWR sky130_fd_sc_hd__fill_2
XFILLER_78_1235 VGND VGND VPWR VPWR sky130_fd_sc_hd__decap_3
XFILLER_63_844 VGND VGND VPWR VPWR sky130_fd_sc_hd__decap_3
XTAP_TAPCELL_ROW_46_1409 VGND VPWR sky130_fd_sc_hd__tapvpwrvgnd_1
XFILLER_78_1279 VGND VGND VPWR VPWR sky130_fd_sc_hd__decap_3
XFILLER_74_80 VGND VGND VPWR VPWR sky130_fd_sc_hd__decap_3
XFILLER_74_91 VGND VGND VPWR VPWR sky130_fd_sc_hd__fill_1
XFILLER_16_760 VGND VGND VPWR VPWR sky130_fd_sc_hd__decap_3
XFILLER_50_505 VGND VGND VPWR VPWR sky130_fd_sc_hd__decap_3
XFILLER_63_888 VGND VGND VPWR VPWR sky130_fd_sc_hd__decap_3
X_3991_ wire69/X _3991_/B VGND VGND VPWR VPWR _3991_/Y sky130_fd_sc_hd__nor2_2
XFILLER_50_527 VGND VGND VPWR VPWR sky130_fd_sc_hd__decap_3
XFILLER_62_387 VGND VGND VPWR VPWR sky130_fd_sc_hd__decap_3
X_5730_ _5858_/A1 _5730_/A1 _5730_/S VGND VGND VPWR VPWR _6777_/D sky130_fd_sc_hd__mux2_1
XFILLER_15_270 VGND VGND VPWR VPWR sky130_fd_sc_hd__decap_3
XFILLER_16_793 VGND VGND VPWR VPWR sky130_fd_sc_hd__decap_3
XFILLER_43_590 VGND VGND VPWR VPWR sky130_fd_sc_hd__decap_3
XFILLER_31_752 VGND VGND VPWR VPWR sky130_fd_sc_hd__decap_3
X_5661_ _5826_/A0 _5661_/A1 _5666_/S VGND VGND VPWR VPWR _6716_/D sky130_fd_sc_hd__mux2_1
XFILLER_31_785 VGND VGND VPWR VPWR sky130_fd_sc_hd__decap_3
XFILLER_50_1110 VGND VGND VPWR VPWR sky130_fd_sc_hd__decap_3
X_4612_ _4787_/C1 _4609_/X _4610_/Y _4611_/X _4788_/A VGND VGND VPWR VPWR _4612_/X
+ sky130_fd_sc_hd__o221a_2
XFILLER_15_1263 VGND VGND VPWR VPWR sky130_fd_sc_hd__decap_3
XFILLER_50_1143 VGND VGND VPWR VPWR sky130_fd_sc_hd__decap_3
X_5592_ wire431/X _5582_/Y _5592_/B1 _5592_/B2 VGND VGND VPWR VPWR _6665_/D sky130_fd_sc_hd__a22o_2
XFILLER_11_1105 VGND VGND VPWR VPWR sky130_fd_sc_hd__decap_3
XFILLER_8_981 VGND VGND VPWR VPWR sky130_fd_sc_hd__decap_3
X_4543_ _4896_/A1 _4540_/X _4541_/Y _4542_/X _4896_/C1 VGND VGND VPWR VPWR _4543_/X
+ sky130_fd_sc_hd__o221a_2
Xmax_cap100 _5665_/S VGND VGND VPWR VPWR _5666_/S sky130_fd_sc_hd__buf_6
XFILLER_11_1138 VGND VGND VPWR VPWR sky130_fd_sc_hd__decap_3
Xmax_cap144 _4250_/A VGND VGND VPWR VPWR _4172_/A sky130_fd_sc_hd__clkbuf_2
X_4474_ _4534_/B _4829_/B VGND VGND VPWR VPWR _4474_/Y sky130_fd_sc_hd__nor2_2
Xmax_cap166 _5568_/Y VGND VGND VPWR VPWR _5583_/A2 sky130_fd_sc_hd__buf_2
X_6213_ _6617_/CLK _6213_/D fanout719/X VGND VGND VPWR VPWR _6213_/Q sky130_fd_sc_hd__dfrtp_2
X_3425_ _6033_/A0 _3424_/X _3425_/S VGND VGND VPWR VPWR _6186_/D sky130_fd_sc_hd__mux2_1
X_3356_ _6297_/Q _6409_/Q VGND VGND VPWR VPWR _3356_/X sky130_fd_sc_hd__xor2_2
X_6144_ _7035_/CLK _6144_/D load_slew843/X VGND VGND VPWR VPWR _6144_/Q sky130_fd_sc_hd__dfrtp_2
Xhold1103 _6117_/Q VGND VGND VPWR VPWR _5964_/A0 sky130_fd_sc_hd__dlygate4sd3_1
Xload_slew372 _4115_/B2 VGND VGND VPWR VPWR _4868_/B2 sky130_fd_sc_hd__clkbuf_4
Xhold1114 _6623_/Q VGND VGND VPWR VPWR _5540_/B1 sky130_fd_sc_hd__dlygate4sd3_1
X_3287_ _5964_/A0 _3286_/X _3425_/S VGND VGND VPWR VPWR _6117_/D sky130_fd_sc_hd__mux2_1
X_6075_ _6081_/C _6074_/Y _6075_/S VGND VGND VPWR VPWR _7074_/D sky130_fd_sc_hd__mux2_1
Xhold1125 _6706_/Q VGND VGND VPWR VPWR _5650_/A0 sky130_fd_sc_hd__dlygate4sd3_1
XFILLER_6_1453 VGND VGND VPWR VPWR sky130_fd_sc_hd__decap_3
Xhold1136 _6786_/Q VGND VGND VPWR VPWR _5741_/A1 sky130_fd_sc_hd__dlygate4sd3_1
Xhold1147 _7025_/Q VGND VGND VPWR VPWR _6021_/A1 sky130_fd_sc_hd__dlygate4sd3_1
XFILLER_61_1272 VGND VGND VPWR VPWR sky130_fd_sc_hd__decap_3
XFILLER_2_1306 VGND VGND VPWR VPWR sky130_fd_sc_hd__decap_3
X_5026_ _6699_/Q _3065_/Y _5328_/S VGND VGND VPWR VPWR _5026_/X sky130_fd_sc_hd__mux2_1
Xhold1158 _6835_/Q VGND VGND VPWR VPWR _5816_/A0 sky130_fd_sc_hd__dlygate4sd3_1
XFILLER_22_1245 VGND VGND VPWR VPWR sky130_fd_sc_hd__decap_3
Xhold1169 _6880_/Q VGND VGND VPWR VPWR _5866_/A0 sky130_fd_sc_hd__dlygate4sd3_1
XFILLER_2_1317 VGND VGND VPWR VPWR sky130_fd_sc_hd__decap_3
XFILLER_22_1267 VGND VGND VPWR VPWR sky130_fd_sc_hd__decap_3
XFILLER_54_855 VGND VGND VPWR VPWR sky130_fd_sc_hd__decap_3
XFILLER_0_1030 VGND VGND VPWR VPWR sky130_fd_sc_hd__decap_3
XFILLER_57_1319 VGND VGND VPWR VPWR sky130_fd_sc_hd__decap_3
XTAP_TAPCELL_ROW_0_166 VGND VPWR sky130_fd_sc_hd__tapvpwrvgnd_1
XFILLER_53_354 VGND VGND VPWR VPWR sky130_fd_sc_hd__decap_3
XTAP_TAPCELL_ROW_0_177 VGND VPWR sky130_fd_sc_hd__tapvpwrvgnd_1
XFILLER_0_1052 VGND VGND VPWR VPWR sky130_fd_sc_hd__decap_3
XFILLER_41_505 VGND VGND VPWR VPWR sky130_fd_sc_hd__decap_3
XFILLER_13_207 VGND VGND VPWR VPWR sky130_fd_sc_hd__decap_3
XTAP_TAPCELL_ROW_0_188 VGND VPWR sky130_fd_sc_hd__tapvpwrvgnd_1
X_6977_ _7009_/CLK _6977_/D fanout765/X VGND VGND VPWR VPWR _6977_/Q sky130_fd_sc_hd__dfrtp_2
XTAP_TAPCELL_ROW_0_199 VGND VPWR sky130_fd_sc_hd__tapvpwrvgnd_1
XFILLER_0_1074 VGND VGND VPWR VPWR sky130_fd_sc_hd__decap_3
XFILLER_41_527 VGND VGND VPWR VPWR sky130_fd_sc_hd__decap_3
X_5928_ _5928_/A0 _5928_/A1 _5932_/S VGND VGND VPWR VPWR _6933_/D sky130_fd_sc_hd__mux2_1
XFILLER_0_1096 VGND VGND VPWR VPWR sky130_fd_sc_hd__decap_3
XFILLER_22_730 VGND VGND VPWR VPWR sky130_fd_sc_hd__decap_3
XFILLER_10_903 VGND VGND VPWR VPWR sky130_fd_sc_hd__decap_3
XFILLER_55_1076 VGND VGND VPWR VPWR sky130_fd_sc_hd__fill_1
XFILLER_70_27 VGND VGND VPWR VPWR sky130_fd_sc_hd__fill_1
X_5859_ _7073_/Q _5868_/A _5859_/C VGND VGND VPWR VPWR _5867_/S sky130_fd_sc_hd__and3b_2
XFILLER_70_38 VGND VGND VPWR VPWR sky130_fd_sc_hd__decap_3
XFILLER_10_925 VGND VGND VPWR VPWR sky130_fd_sc_hd__decap_3
XFILLER_21_284 VGND VGND VPWR VPWR sky130_fd_sc_hd__decap_3
XFILLER_33_1363 VGND VGND VPWR VPWR sky130_fd_sc_hd__decap_3
XFILLER_5_417 VGND VGND VPWR VPWR sky130_fd_sc_hd__decap_3
XFILLER_33_1396 VGND VGND VPWR VPWR sky130_fd_sc_hd__decap_3
XFILLER_68_1415 VGND VGND VPWR VPWR sky130_fd_sc_hd__decap_3
XFILLER_79_36 VGND VGND VPWR VPWR sky130_fd_sc_hd__decap_3
XFILLER_68_1459 VGND VGND VPWR VPWR sky130_fd_sc_hd__decap_3
XFILLER_79_69 VGND VGND VPWR VPWR sky130_fd_sc_hd__decap_3
XFILLER_1_601 VGND VGND VPWR VPWR sky130_fd_sc_hd__decap_3
Xhold970 _6156_/Q VGND VGND VPWR VPWR hold970/X sky130_fd_sc_hd__dlygate4sd3_1
XFILLER_0_100 VGND VGND VPWR VPWR sky130_fd_sc_hd__decap_3
Xhold981 _6682_/Q VGND VGND VPWR VPWR hold981/X sky130_fd_sc_hd__dlygate4sd3_1
XTAP_TAPCELL_ROW_73_2096 VGND VPWR sky130_fd_sc_hd__tapvpwrvgnd_1
Xhold992 _7060_/Q VGND VGND VPWR VPWR hold992/X sky130_fd_sc_hd__dlygate4sd3_1
XFILLER_0_122 VGND VGND VPWR VPWR sky130_fd_sc_hd__decap_3
XFILLER_1_645 VGND VGND VPWR VPWR sky130_fd_sc_hd__decap_3
XFILLER_66_1183 VGND VGND VPWR VPWR sky130_fd_sc_hd__decap_3
XFILLER_0_144 VGND VGND VPWR VPWR sky130_fd_sc_hd__decap_3
XFILLER_7_1228 VGND VGND VPWR VPWR sky130_fd_sc_hd__decap_3
XFILLER_76_413 VGND VGND VPWR VPWR sky130_fd_sc_hd__decap_3
XFILLER_7_1239 VGND VGND VPWR VPWR sky130_fd_sc_hd__decap_3
XFILLER_23_1009 VGND VGND VPWR VPWR sky130_fd_sc_hd__decap_3
XFILLER_77_969 VGND VGND VPWR VPWR sky130_fd_sc_hd__decap_3
XFILLER_40_1312 VGND VGND VPWR VPWR sky130_fd_sc_hd__decap_3
XFILLER_48_137 VGND VGND VPWR VPWR sky130_fd_sc_hd__decap_3
XFILLER_40_1323 VGND VGND VPWR VPWR sky130_fd_sc_hd__decap_3
XFILLER_29_362 VGND VGND VPWR VPWR sky130_fd_sc_hd__decap_3
XFILLER_40_1356 VGND VGND VPWR VPWR sky130_fd_sc_hd__decap_3
XFILLER_63_118 VGND VGND VPWR VPWR sky130_fd_sc_hd__fill_1
Xclkbuf_leaf_83_clk clkbuf_leaf_3_clk/A VGND VGND VPWR VPWR _7024_/CLK sky130_fd_sc_hd__clkbuf_8
XFILLER_56_192 VGND VGND VPWR VPWR sky130_fd_sc_hd__decap_3
XFILLER_17_557 VGND VGND VPWR VPWR sky130_fd_sc_hd__decap_3
XFILLER_75_1419 VGND VGND VPWR VPWR sky130_fd_sc_hd__decap_3
XFILLER_71_140 VGND VGND VPWR VPWR sky130_fd_sc_hd__decap_3
XFILLER_17_579 VGND VGND VPWR VPWR sky130_fd_sc_hd__fill_1
XFILLER_44_354 VGND VGND VPWR VPWR sky130_fd_sc_hd__decap_3
XFILLER_73_1121 VGND VGND VPWR VPWR sky130_fd_sc_hd__decap_3
XFILLER_73_1154 VGND VGND VPWR VPWR sky130_fd_sc_hd__decap_3
XFILLER_13_763 VGND VGND VPWR VPWR sky130_fd_sc_hd__decap_3
XFILLER_38_1285 VGND VGND VPWR VPWR sky130_fd_sc_hd__decap_3
XFILLER_8_200 VGND VGND VPWR VPWR sky130_fd_sc_hd__decap_3
XFILLER_34_1127 VGND VGND VPWR VPWR sky130_fd_sc_hd__decap_3
XFILLER_40_571 VGND VGND VPWR VPWR sky130_fd_sc_hd__decap_3
XFILLER_73_1198 VGND VGND VPWR VPWR sky130_fd_sc_hd__decap_3
XFILLER_34_1149 VGND VGND VPWR VPWR sky130_fd_sc_hd__decap_3
XFILLER_12_284 VGND VGND VPWR VPWR sky130_fd_sc_hd__decap_3
XFILLER_8_233 VGND VGND VPWR VPWR sky130_fd_sc_hd__decap_3
XTAP_TAPCELL_ROW_23_791 VGND VPWR sky130_fd_sc_hd__tapvpwrvgnd_1
XFILLER_12_1403 VGND VGND VPWR VPWR sky130_fd_sc_hd__decap_3
XFILLER_51_1452 VGND VGND VPWR VPWR sky130_fd_sc_hd__decap_3
XFILLER_51_1463 VGND VGND VPWR VPWR sky130_fd_sc_hd__decap_3
XFILLER_12_1447 VGND VGND VPWR VPWR sky130_fd_sc_hd__decap_3
XTAP_TAPCELL_ROW_10_452 VGND VPWR sky130_fd_sc_hd__tapvpwrvgnd_1
XTAP_TAPCELL_ROW_10_463 VGND VPWR sky130_fd_sc_hd__tapvpwrvgnd_1
XTAP_TAPCELL_ROW_39_1202 VGND VPWR sky130_fd_sc_hd__tapvpwrvgnd_1
XTAP_TAPCELL_ROW_39_1213 VGND VPWR sky130_fd_sc_hd__tapvpwrvgnd_1
XTAP_TAPCELL_ROW_39_1224 VGND VPWR sky130_fd_sc_hd__tapvpwrvgnd_1
XFILLER_5_33 VGND VGND VPWR VPWR sky130_fd_sc_hd__decap_3
XFILLER_4_461 VGND VGND VPWR VPWR sky130_fd_sc_hd__decap_3
XFILLER_5_66 VGND VGND VPWR VPWR sky130_fd_sc_hd__decap_3
XFILLER_10_1182 VGND VGND VPWR VPWR sky130_fd_sc_hd__decap_3
X_3210_ _7064_/Q _3209_/X _3225_/S VGND VGND VPWR VPWR uo_out[6] sky130_fd_sc_hd__mux2_1
XFILLER_49_1381 VGND VGND VPWR VPWR sky130_fd_sc_hd__decap_3
XFILLER_80_1114 VGND VGND VPWR VPWR sky130_fd_sc_hd__decap_3
X_4190_ _4532_/B _4783_/C wire25/X VGND VGND VPWR VPWR _4190_/X sky130_fd_sc_hd__or3_2
XFILLER_45_1245 VGND VGND VPWR VPWR sky130_fd_sc_hd__decap_3
XFILLER_80_1136 VGND VGND VPWR VPWR sky130_fd_sc_hd__decap_3
XFILLER_68_925 VGND VGND VPWR VPWR sky130_fd_sc_hd__decap_3
X_3141_ _3212_/A1 _6964_/Q _6972_/Q _3136_/A VGND VGND VPWR VPWR _3141_/X sky130_fd_sc_hd__a22o_2
XFILLER_80_1158 VGND VGND VPWR VPWR sky130_fd_sc_hd__decap_3
XFILLER_45_1278 VGND VGND VPWR VPWR sky130_fd_sc_hd__decap_3
XFILLER_45_1289 VGND VGND VPWR VPWR sky130_fd_sc_hd__decap_3
XFILLER_10_3 VGND VGND VPWR VPWR sky130_fd_sc_hd__decap_3
X_3072_ _3489_/A VGND VGND VPWR VPWR _3743_/B sky130_fd_sc_hd__inv_2
XFILLER_54_107 VGND VGND VPWR VPWR sky130_fd_sc_hd__decap_3
X_6900_ _6900_/CLK _6900_/D fanout832/X VGND VGND VPWR VPWR _6900_/Q sky130_fd_sc_hd__dfrtp_2
XFILLER_36_833 VGND VGND VPWR VPWR sky130_fd_sc_hd__fill_2
XFILLER_75_490 VGND VGND VPWR VPWR sky130_fd_sc_hd__decap_3
XFILLER_63_630 VGND VGND VPWR VPWR sky130_fd_sc_hd__fill_1
Xclkbuf_leaf_74_clk clkload4/A VGND VGND VPWR VPWR _6926_/CLK sky130_fd_sc_hd__clkbuf_8
XFILLER_35_343 VGND VGND VPWR VPWR sky130_fd_sc_hd__decap_3
XTAP_TAPCELL_ROW_69_1987 VGND VPWR sky130_fd_sc_hd__tapvpwrvgnd_1
X_6831_ _6959_/CLK _6831_/D load_slew760/X VGND VGND VPWR VPWR _6831_/Q sky130_fd_sc_hd__dfrtp_2
XFILLER_51_803 VGND VGND VPWR VPWR sky130_fd_sc_hd__fill_2
XTAP_TAPCELL_ROW_69_1998 VGND VPWR sky130_fd_sc_hd__tapvpwrvgnd_1
XFILLER_78_1076 VGND VGND VPWR VPWR sky130_fd_sc_hd__decap_3
XFILLER_23_505 VGND VGND VPWR VPWR sky130_fd_sc_hd__decap_3
XFILLER_1_1372 VGND VGND VPWR VPWR sky130_fd_sc_hd__decap_3
X_6762_ _6858_/CLK _6762_/D wire652/X VGND VGND VPWR VPWR _6762_/Q sky130_fd_sc_hd__dfrtp_2
XFILLER_50_335 VGND VGND VPWR VPWR sky130_fd_sc_hd__decap_3
XFILLER_56_1341 VGND VGND VPWR VPWR sky130_fd_sc_hd__decap_3
XFILLER_51_869 VGND VGND VPWR VPWR sky130_fd_sc_hd__decap_3
X_3974_ _6530_/Q _3991_/B _4123_/B2 VGND VGND VPWR VPWR _3974_/X sky130_fd_sc_hd__a21bo_2
XFILLER_17_1325 VGND VGND VPWR VPWR sky130_fd_sc_hd__decap_3
XFILLER_52_1205 VGND VGND VPWR VPWR sky130_fd_sc_hd__decap_3
XFILLER_56_1385 VGND VGND VPWR VPWR sky130_fd_sc_hd__decap_3
X_5713_ _5749_/A _5722_/A _7067_/Q _5758_/C VGND VGND VPWR VPWR wire88/A sky130_fd_sc_hd__or4_2
X_6693_ _6765_/CLK _6693_/D wire641/X VGND VGND VPWR VPWR _6693_/Q sky130_fd_sc_hd__dfrtp_2
XFILLER_17_1369 VGND VGND VPWR VPWR sky130_fd_sc_hd__decap_3
XTAP_TAPCELL_ROW_21_739 VGND VPWR sky130_fd_sc_hd__tapvpwrvgnd_1
XFILLER_52_1249 VGND VGND VPWR VPWR sky130_fd_sc_hd__decap_3
X_5644_ _5910_/A0 _5644_/A1 wire92/A VGND VGND VPWR VPWR _6701_/D sky130_fd_sc_hd__mux2_1
X_5575_ _5606_/A1 _3712_/B _5588_/A3 _5583_/A2 _5575_/B2 VGND VGND VPWR VPWR _6653_/D
+ sky130_fd_sc_hd__a32o_2
X_4526_ _6525_/Q _4526_/B VGND VGND VPWR VPWR _4526_/Y sky130_fd_sc_hd__nand2_2
X_4457_ _6853_/Q _4869_/A2 _4455_/X _4456_/X VGND VGND VPWR VPWR _4457_/X sky130_fd_sc_hd__a211o_2
XFILLER_28_1421 VGND VGND VPWR VPWR sky130_fd_sc_hd__decap_3
XFILLER_63_1301 VGND VGND VPWR VPWR sky130_fd_sc_hd__decap_3
XFILLER_28_1432 VGND VGND VPWR VPWR sky130_fd_sc_hd__decap_3
Xfanout713 fanout740/X VGND VGND VPWR VPWR fanout713/X sky130_fd_sc_hd__clkdlybuf4s25_1
XFILLER_59_903 VGND VGND VPWR VPWR sky130_fd_sc_hd__fill_1
X_3408_ _6235_/Q _6435_/Q VGND VGND VPWR VPWR _3408_/X sky130_fd_sc_hd__xor2_2
Xfanout724 fanout740/X VGND VGND VPWR VPWR fanout724/X sky130_fd_sc_hd__clkdlybuf4s25_1
XFILLER_63_1334 VGND VGND VPWR VPWR sky130_fd_sc_hd__decap_3
Xfanout735 wire738/A VGND VGND VPWR VPWR fanout735/X sky130_fd_sc_hd__clkdlybuf4s25_1
XFILLER_28_1465 VGND VGND VPWR VPWR sky130_fd_sc_hd__decap_3
X_4388_ _4388_/A _4747_/B VGND VGND VPWR VPWR _4388_/Y sky130_fd_sc_hd__nor2_2
XFILLER_63_1345 VGND VGND VPWR VPWR sky130_fd_sc_hd__decap_3
Xfanout746 fanout790/X VGND VGND VPWR VPWR fanout746/X sky130_fd_sc_hd__clkdlybuf4s25_1
X_6127_ _6986_/CLK _6127_/D load_slew648/X VGND VGND VPWR VPWR _6127_/Q sky130_fd_sc_hd__dfrtp_2
XFILLER_24_1329 VGND VGND VPWR VPWR sky130_fd_sc_hd__decap_3
XFILLER_63_1378 VGND VGND VPWR VPWR sky130_fd_sc_hd__decap_3
X_3339_ _5990_/A0 _3338_/X _3425_/S VGND VGND VPWR VPWR _6143_/D sky130_fd_sc_hd__mux2_1
Xfanout768 fanout768/A VGND VGND VPWR VPWR fanout768/X sky130_fd_sc_hd__clkdlybuf4s25_1
Xfanout779 fanout779/A VGND VGND VPWR VPWR fanout779/X sky130_fd_sc_hd__clkdlybuf4s25_1
XFILLER_74_917 VGND VGND VPWR VPWR sky130_fd_sc_hd__fill_2
Xload_slew191 _3353_/S VGND VGND VPWR VPWR _3385_/S sky130_fd_sc_hd__clkbuf_4
XFILLER_6_1250 VGND VGND VPWR VPWR sky130_fd_sc_hd__decap_3
X_6058_ _6058_/A0 _6058_/A1 _6058_/S VGND VGND VPWR VPWR _7062_/D sky130_fd_sc_hd__mux2_1
XFILLER_73_405 VGND VGND VPWR VPWR sky130_fd_sc_hd__decap_3
XFILLER_6_1261 VGND VGND VPWR VPWR sky130_fd_sc_hd__decap_3
XFILLER_27_800 VGND VGND VPWR VPWR sky130_fd_sc_hd__decap_3
XFILLER_65_27 VGND VGND VPWR VPWR sky130_fd_sc_hd__decap_3
XFILLER_2_1114 VGND VGND VPWR VPWR sky130_fd_sc_hd__decap_3
XFILLER_6_1294 VGND VGND VPWR VPWR sky130_fd_sc_hd__decap_3
X_5009_ _6391_/Q _5243_/B VGND VGND VPWR VPWR _5009_/X sky130_fd_sc_hd__or2_2
XFILLER_27_844 VGND VGND VPWR VPWR sky130_fd_sc_hd__decap_3
XFILLER_2_1147 VGND VGND VPWR VPWR sky130_fd_sc_hd__fill_1
Xclkbuf_leaf_65_clk clkbuf_leaf_67_clk/A VGND VGND VPWR VPWR _7052_/CLK sky130_fd_sc_hd__clkbuf_8
XFILLER_2_1158 VGND VGND VPWR VPWR sky130_fd_sc_hd__decap_3
XFILLER_57_1105 VGND VGND VPWR VPWR sky130_fd_sc_hd__fill_2
XFILLER_27_877 VGND VGND VPWR VPWR sky130_fd_sc_hd__decap_3
XFILLER_26_365 VGND VGND VPWR VPWR sky130_fd_sc_hd__decap_3
XFILLER_42_825 VGND VGND VPWR VPWR sky130_fd_sc_hd__decap_3
XFILLER_57_1127 VGND VGND VPWR VPWR sky130_fd_sc_hd__decap_3
XFILLER_14_527 VGND VGND VPWR VPWR sky130_fd_sc_hd__decap_3
XFILLER_54_696 VGND VGND VPWR VPWR sky130_fd_sc_hd__decap_3
XFILLER_74_1441 VGND VGND VPWR VPWR sky130_fd_sc_hd__decap_3
XFILLER_42_869 VGND VGND VPWR VPWR sky130_fd_sc_hd__decap_3
XFILLER_35_1425 VGND VGND VPWR VPWR sky130_fd_sc_hd__decap_3
XFILLER_70_1338 VGND VGND VPWR VPWR sky130_fd_sc_hd__decap_3
XTAP_TAPCELL_ROW_79_2250 VGND VPWR sky130_fd_sc_hd__tapvpwrvgnd_1
XTAP_TAPCELL_ROW_79_2261 VGND VPWR sky130_fd_sc_hd__tapvpwrvgnd_1
XFILLER_10_777 VGND VGND VPWR VPWR sky130_fd_sc_hd__fill_2
XFILLER_5_225 VGND VGND VPWR VPWR sky130_fd_sc_hd__decap_3
XTAP_TAPCELL_ROW_75_2147 VGND VPWR sky130_fd_sc_hd__tapvpwrvgnd_1
XTAP_TAPCELL_ROW_75_2158 VGND VPWR sky130_fd_sc_hd__tapvpwrvgnd_1
XFILLER_68_1223 VGND VGND VPWR VPWR sky130_fd_sc_hd__decap_3
XFILLER_68_1256 VGND VGND VPWR VPWR sky130_fd_sc_hd__decap_3
XFILLER_30_85 VGND VGND VPWR VPWR sky130_fd_sc_hd__fill_2
XFILLER_68_1267 VGND VGND VPWR VPWR sky130_fd_sc_hd__decap_3
XFILLER_29_1229 VGND VGND VPWR VPWR sky130_fd_sc_hd__decap_3
XFILLER_2_943 VGND VGND VPWR VPWR sky130_fd_sc_hd__decap_3
XFILLER_1_420 VGND VGND VPWR VPWR sky130_fd_sc_hd__fill_1
XFILLER_2_976 VGND VGND VPWR VPWR sky130_fd_sc_hd__decap_3
XFILLER_2_987 VGND VGND VPWR VPWR sky130_fd_sc_hd__decap_3
XFILLER_77_711 VGND VGND VPWR VPWR sky130_fd_sc_hd__fill_1
XFILLER_49_402 VGND VGND VPWR VPWR sky130_fd_sc_hd__fill_1
XFILLER_1_475 VGND VGND VPWR VPWR sky130_fd_sc_hd__decap_3
XFILLER_42_1418 VGND VGND VPWR VPWR sky130_fd_sc_hd__decap_3
XFILLER_7_1047 VGND VGND VPWR VPWR sky130_fd_sc_hd__decap_3
XFILLER_42_1429 VGND VGND VPWR VPWR sky130_fd_sc_hd__decap_3
XFILLER_65_906 VGND VGND VPWR VPWR sky130_fd_sc_hd__fill_2
XFILLER_65_917 VGND VGND VPWR VPWR sky130_fd_sc_hd__decap_3
XFILLER_49_479 VGND VGND VPWR VPWR sky130_fd_sc_hd__fill_1
XFILLER_18_800 VGND VGND VPWR VPWR sky130_fd_sc_hd__decap_3
XFILLER_40_1131 VGND VGND VPWR VPWR sky130_fd_sc_hd__decap_3
XFILLER_76_287 VGND VGND VPWR VPWR sky130_fd_sc_hd__decap_3
XFILLER_18_833 VGND VGND VPWR VPWR sky130_fd_sc_hd__decap_3
XFILLER_17_310 VGND VGND VPWR VPWR sky130_fd_sc_hd__decap_3
Xclkbuf_leaf_56_clk clkbuf_leaf_56_clk/A VGND VGND VPWR VPWR _6819_/CLK sky130_fd_sc_hd__clkbuf_8
XFILLER_73_950 VGND VGND VPWR VPWR sky130_fd_sc_hd__fill_2
XFILLER_18_855 VGND VGND VPWR VPWR sky130_fd_sc_hd__decap_3
XFILLER_79_1363 VGND VGND VPWR VPWR sky130_fd_sc_hd__decap_3
XFILLER_73_961 VGND VGND VPWR VPWR sky130_fd_sc_hd__decap_3
XFILLER_45_663 VGND VGND VPWR VPWR sky130_fd_sc_hd__decap_3
XFILLER_75_1216 VGND VGND VPWR VPWR sky130_fd_sc_hd__decap_3
XFILLER_79_1396 VGND VGND VPWR VPWR sky130_fd_sc_hd__decap_3
XFILLER_44_195 VGND VGND VPWR VPWR sky130_fd_sc_hd__fill_1
XTAP_TAPCELL_ROW_64_1862 VGND VPWR sky130_fd_sc_hd__tapvpwrvgnd_1
XFILLER_60_677 VGND VGND VPWR VPWR sky130_fd_sc_hd__fill_2
XTAP_TAPCELL_ROW_64_1873 VGND VPWR sky130_fd_sc_hd__tapvpwrvgnd_1
XFILLER_60_688 VGND VGND VPWR VPWR sky130_fd_sc_hd__decap_3
XFILLER_38_1093 VGND VGND VPWR VPWR sky130_fd_sc_hd__decap_3
XFILLER_9_520 VGND VGND VPWR VPWR sky130_fd_sc_hd__decap_3
XTAP_TAPCELL_ROW_15_588 VGND VPWR sky130_fd_sc_hd__tapvpwrvgnd_1
XTAP_TAPCELL_ROW_15_599 VGND VPWR sky130_fd_sc_hd__tapvpwrvgnd_1
XFILLER_41_891 VGND VGND VPWR VPWR sky130_fd_sc_hd__decap_3
XTAP_TAPCELL_ROW_60_1748 VGND VPWR sky130_fd_sc_hd__tapvpwrvgnd_1
XFILLER_9_542 VGND VGND VPWR VPWR sky130_fd_sc_hd__decap_3
XTAP_TAPCELL_ROW_60_1759 VGND VPWR sky130_fd_sc_hd__tapvpwrvgnd_1
Xtt_um_aes128_optimized_849 VGND VGND VPWR VPWR tt_um_aes128_optimized_849/HI uio_oe[1]
+ sky130_fd_sc_hd__conb_1
X_3690_ _3689_/A _3881_/B _3880_/A VGND VGND VPWR VPWR _3757_/B sky130_fd_sc_hd__a21o_2
XFILLER_12_1211 VGND VGND VPWR VPWR sky130_fd_sc_hd__decap_3
XFILLER_9_575 VGND VGND VPWR VPWR sky130_fd_sc_hd__fill_2
XFILLER_51_1260 VGND VGND VPWR VPWR sky130_fd_sc_hd__decap_3
XFILLER_9_586 VGND VGND VPWR VPWR sky130_fd_sc_hd__decap_3
XFILLER_16_1391 VGND VGND VPWR VPWR sky130_fd_sc_hd__decap_3
XFILLER_12_1244 VGND VGND VPWR VPWR sky130_fd_sc_hd__decap_3
X_5360_ _5360_/A1 _5456_/A2 _4114_/X VGND VGND VPWR VPWR _6472_/D sky130_fd_sc_hd__a21o_2
XFILLER_58_3 VGND VGND VPWR VPWR sky130_fd_sc_hd__decap_3
XFILLER_12_1288 VGND VGND VPWR VPWR sky130_fd_sc_hd__decap_3
XFILLER_47_1307 VGND VGND VPWR VPWR sky130_fd_sc_hd__decap_3
XFILLER_5_781 VGND VGND VPWR VPWR sky130_fd_sc_hd__decap_3
X_4311_ _6267_/Q wire49/X _4308_/X _4310_/X VGND VGND VPWR VPWR _6267_/D sky130_fd_sc_hd__o22a_2
X_5291_ _5356_/S _5291_/B VGND VGND VPWR VPWR _5291_/Y sky130_fd_sc_hd__nand2_2
XFILLER_4_280 VGND VGND VPWR VPWR sky130_fd_sc_hd__fill_2
XTAP_TAPCELL_ROW_58_1699 VGND VPWR sky130_fd_sc_hd__tapvpwrvgnd_1
X_7030_ _7088_/CLK _7030_/D load_slew775/X VGND VGND VPWR VPWR _7030_/Q sky130_fd_sc_hd__dfrtp_2
X_4242_ _4283_/A wire31/X VGND VGND VPWR VPWR _4242_/Y sky130_fd_sc_hd__nand2_2
XFILLER_68_722 VGND VGND VPWR VPWR sky130_fd_sc_hd__decap_3
X_4173_ _4338_/A _4413_/B VGND VGND VPWR VPWR _4173_/Y sky130_fd_sc_hd__nand2_2
Xclkbuf_4_0__f_clk clkbuf_3_0_0_clk/X VGND VGND VPWR VPWR clkbuf_leaf_2_clk/A sky130_fd_sc_hd__clkbuf_16
XFILLER_3_1401 VGND VGND VPWR VPWR sky130_fd_sc_hd__decap_3
X_3124_ _3217_/A _3117_/X _3120_/X _3123_/X VGND VGND VPWR VPWR _3124_/X sky130_fd_sc_hd__a31o_2
XFILLER_23_1340 VGND VGND VPWR VPWR sky130_fd_sc_hd__decap_3
XFILLER_23_1351 VGND VGND VPWR VPWR sky130_fd_sc_hd__decap_3
XFILLER_67_287 VGND VGND VPWR VPWR sky130_fd_sc_hd__fill_1
XFILLER_3_1434 VGND VGND VPWR VPWR sky130_fd_sc_hd__decap_3
X_3055_ _6351_/Q VGND VGND VPWR VPWR _3055_/Y sky130_fd_sc_hd__inv_2
XFILLER_23_1384 VGND VGND VPWR VPWR sky130_fd_sc_hd__decap_3
Xclkbuf_leaf_47_clk clkbuf_leaf_47_clk/A VGND VGND VPWR VPWR _7035_/CLK sky130_fd_sc_hd__clkbuf_8
XFILLER_58_1403 VGND VGND VPWR VPWR sky130_fd_sc_hd__decap_3
XFILLER_70_419 VGND VGND VPWR VPWR sky130_fd_sc_hd__fill_1
XFILLER_51_611 VGND VGND VPWR VPWR sky130_fd_sc_hd__decap_3
XFILLER_58_1447 VGND VGND VPWR VPWR sky130_fd_sc_hd__decap_3
XFILLER_24_836 VGND VGND VPWR VPWR sky130_fd_sc_hd__decap_3
XFILLER_1_1180 VGND VGND VPWR VPWR sky130_fd_sc_hd__decap_3
X_6814_ _6819_/CLK _6814_/D load_slew767/X VGND VGND VPWR VPWR _6814_/Q sky130_fd_sc_hd__dfrtp_2
XFILLER_35_195 VGND VGND VPWR VPWR sky130_fd_sc_hd__fill_1
XFILLER_23_346 VGND VGND VPWR VPWR sky130_fd_sc_hd__decap_3
XFILLER_24_869 VGND VGND VPWR VPWR sky130_fd_sc_hd__decap_3
XFILLER_50_132 VGND VGND VPWR VPWR sky130_fd_sc_hd__decap_3
X_6745_ _7063_/CLK _6745_/D fanout739/X VGND VGND VPWR VPWR _6745_/Q sky130_fd_sc_hd__dfrtp_2
X_3957_ _4420_/C _3957_/B wire25/X VGND VGND VPWR VPWR _3957_/X sky130_fd_sc_hd__or3_2
XFILLER_56_1182 VGND VGND VPWR VPWR sky130_fd_sc_hd__fill_1
XFILLER_52_1035 VGND VGND VPWR VPWR sky130_fd_sc_hd__fill_1
XFILLER_17_1166 VGND VGND VPWR VPWR sky130_fd_sc_hd__decap_3
X_6676_ _7052_/CLK _6676_/D fanout797/X VGND VGND VPWR VPWR _6676_/Q sky130_fd_sc_hd__dfrtp_2
XFILLER_17_1177 VGND VGND VPWR VPWR sky130_fd_sc_hd__decap_3
X_3888_ _3888_/A _3888_/B _3888_/C VGND VGND VPWR VPWR _3889_/B sky130_fd_sc_hd__and3_2
XFILLER_30_1300 VGND VGND VPWR VPWR sky130_fd_sc_hd__decap_3
X_5627_ _5627_/A0 _5932_/A0 _5627_/S VGND VGND VPWR VPWR _6689_/D sky130_fd_sc_hd__mux2_1
XFILLER_30_1344 VGND VGND VPWR VPWR sky130_fd_sc_hd__decap_3
XFILLER_3_718 VGND VGND VPWR VPWR sky130_fd_sc_hd__decap_3
X_5558_ _6359_/Q _5566_/A2 hold936/X _5566_/B2 VGND VGND VPWR VPWR _6641_/D sky130_fd_sc_hd__a22o_2
XFILLER_3_729 VGND VGND VPWR VPWR sky130_fd_sc_hd__decap_3
XFILLER_30_1388 VGND VGND VPWR VPWR sky130_fd_sc_hd__decap_3
XFILLER_65_1407 VGND VGND VPWR VPWR sky130_fd_sc_hd__decap_3
X_4509_ _6290_/Q _4863_/A2 _4506_/X _4508_/X VGND VGND VPWR VPWR _6290_/D sky130_fd_sc_hd__o22a_2
X_5489_ _7081_/Q _5519_/A2 _3078_/A VGND VGND VPWR VPWR _5489_/Y sky130_fd_sc_hd__o21ai_2
XFILLER_2_239 VGND VGND VPWR VPWR sky130_fd_sc_hd__decap_3
XTAP_TAPCELL_ROW_70_2011 VGND VPWR sky130_fd_sc_hd__tapvpwrvgnd_1
XTAP_TAPCELL_ROW_70_2022 VGND VPWR sky130_fd_sc_hd__tapvpwrvgnd_1
XTAP_TAPCELL_ROW_70_2033 VGND VPWR sky130_fd_sc_hd__tapvpwrvgnd_1
XFILLER_28_1240 VGND VGND VPWR VPWR sky130_fd_sc_hd__decap_3
XFILLER_8_1312 VGND VGND VPWR VPWR sky130_fd_sc_hd__decap_3
XFILLER_8_1323 VGND VGND VPWR VPWR sky130_fd_sc_hd__decap_3
XFILLER_76_15 VGND VGND VPWR VPWR sky130_fd_sc_hd__decap_3
Xfanout532 _5340_/S VGND VGND VPWR VPWR _5356_/S sky130_fd_sc_hd__clkdlybuf4s25_1
XFILLER_28_1273 VGND VGND VPWR VPWR sky130_fd_sc_hd__decap_3
Xfanout543 _7083_/Q VGND VGND VPWR VPWR _5352_/S sky130_fd_sc_hd__clkdlybuf4s25_1
Xfanout554 _3212_/A1 VGND VGND VPWR VPWR _6081_/A sky130_fd_sc_hd__clkdlybuf4s25_1
XFILLER_8_1356 VGND VGND VPWR VPWR sky130_fd_sc_hd__decap_3
Xfanout565 _7072_/Q VGND VGND VPWR VPWR _5906_/B sky130_fd_sc_hd__clkdlybuf4s25_1
XFILLER_76_59 VGND VGND VPWR VPWR sky130_fd_sc_hd__decap_3
Xfanout576 _4886_/A1 VGND VGND VPWR VPWR _4428_/A sky130_fd_sc_hd__clkdlybuf4s25_1
Xfanout587 _3566_/A VGND VGND VPWR VPWR _3601_/A sky130_fd_sc_hd__clkdlybuf4s25_1
XFILLER_41_1440 VGND VGND VPWR VPWR sky130_fd_sc_hd__decap_3
XFILLER_58_276 VGND VGND VPWR VPWR sky130_fd_sc_hd__fill_1
XFILLER_73_213 VGND VGND VPWR VPWR sky130_fd_sc_hd__decap_3
XFILLER_46_438 VGND VGND VPWR VPWR sky130_fd_sc_hd__fill_1
XFILLER_58_298 VGND VGND VPWR VPWR sky130_fd_sc_hd__fill_1
Xclkbuf_leaf_38_clk clkload6/A VGND VGND VPWR VPWR _7088_/CLK sky130_fd_sc_hd__clkbuf_8
XFILLER_55_950 VGND VGND VPWR VPWR sky130_fd_sc_hd__fill_2
XFILLER_27_652 VGND VGND VPWR VPWR sky130_fd_sc_hd__decap_3
XFILLER_55_961 VGND VGND VPWR VPWR sky130_fd_sc_hd__fill_1
XFILLER_73_268 VGND VGND VPWR VPWR sky130_fd_sc_hd__decap_3
XFILLER_15_847 VGND VGND VPWR VPWR sky130_fd_sc_hd__decap_3
XTAP_TAPCELL_ROW_25_842 VGND VPWR sky130_fd_sc_hd__tapvpwrvgnd_1
XFILLER_26_195 VGND VGND VPWR VPWR sky130_fd_sc_hd__fill_1
XFILLER_25_63 VGND VGND VPWR VPWR sky130_fd_sc_hd__fill_2
XFILLER_41_132 VGND VGND VPWR VPWR sky130_fd_sc_hd__decap_3
XTAP_TAPCELL_ROW_25_853 VGND VPWR sky130_fd_sc_hd__tapvpwrvgnd_1
XFILLER_35_1200 VGND VGND VPWR VPWR sky130_fd_sc_hd__decap_3
XFILLER_14_368 VGND VGND VPWR VPWR sky130_fd_sc_hd__decap_3
XTAP_TAPCELL_ROW_12_503 VGND VPWR sky130_fd_sc_hd__tapvpwrvgnd_1
XFILLER_74_1282 VGND VGND VPWR VPWR sky130_fd_sc_hd__decap_3
XFILLER_35_1233 VGND VGND VPWR VPWR sky130_fd_sc_hd__decap_3
XTAP_TAPCELL_ROW_12_514 VGND VPWR sky130_fd_sc_hd__tapvpwrvgnd_1
XFILLER_41_187 VGND VGND VPWR VPWR sky130_fd_sc_hd__decap_3
XFILLER_70_1135 VGND VGND VPWR VPWR sky130_fd_sc_hd__decap_3
XTAP_TAPCELL_ROW_12_525 VGND VPWR sky130_fd_sc_hd__tapvpwrvgnd_1
XFILLER_35_1266 VGND VGND VPWR VPWR sky130_fd_sc_hd__decap_3
XTAP_TAPCELL_ROW_77_2209 VGND VPWR sky130_fd_sc_hd__tapvpwrvgnd_1
XFILLER_10_552 VGND VGND VPWR VPWR sky130_fd_sc_hd__decap_3
XFILLER_6_501 VGND VGND VPWR VPWR sky130_fd_sc_hd__decap_3
XFILLER_31_1119 VGND VGND VPWR VPWR sky130_fd_sc_hd__fill_1
XFILLER_70_1179 VGND VGND VPWR VPWR sky130_fd_sc_hd__decap_3
XFILLER_41_51 VGND VGND VPWR VPWR sky130_fd_sc_hd__decap_3
XFILLER_10_585 VGND VGND VPWR VPWR sky130_fd_sc_hd__decap_3
XFILLER_41_84 VGND VGND VPWR VPWR sky130_fd_sc_hd__decap_3
XFILLER_29_1004 VGND VGND VPWR VPWR sky130_fd_sc_hd__decap_3
XFILLER_68_1053 VGND VGND VPWR VPWR sky130_fd_sc_hd__decap_3
XFILLER_44_9 VGND VGND VPWR VPWR sky130_fd_sc_hd__decap_3
XFILLER_2_740 VGND VGND VPWR VPWR sky130_fd_sc_hd__decap_3
XFILLER_69_508 VGND VGND VPWR VPWR sky130_fd_sc_hd__decap_3
XFILLER_29_1059 VGND VGND VPWR VPWR sky130_fd_sc_hd__decap_3
XFILLER_1_261 VGND VGND VPWR VPWR sky130_fd_sc_hd__decap_3
XFILLER_2_12 VGND VGND VPWR VPWR sky130_fd_sc_hd__decap_3
XFILLER_46_1362 VGND VGND VPWR VPWR sky130_fd_sc_hd__decap_3
XFILLER_46_1373 VGND VGND VPWR VPWR sky130_fd_sc_hd__decap_3
XTAP_TAPCELL_ROW_53_1574 VGND VPWR sky130_fd_sc_hd__tapvpwrvgnd_1
XFILLER_77_541 VGND VGND VPWR VPWR sky130_fd_sc_hd__decap_3
XTAP_TAPCELL_ROW_53_1585 VGND VPWR sky130_fd_sc_hd__tapvpwrvgnd_1
XFILLER_2_56 VGND VGND VPWR VPWR sky130_fd_sc_hd__decap_3
XFILLER_38_917 VGND VGND VPWR VPWR sky130_fd_sc_hd__fill_1
XFILLER_49_265 VGND VGND VPWR VPWR sky130_fd_sc_hd__decap_3
XFILLER_37_449 VGND VGND VPWR VPWR sky130_fd_sc_hd__decap_3
Xclkbuf_leaf_29_clk clkload3/A VGND VGND VPWR VPWR _6905_/CLK sky130_fd_sc_hd__clkbuf_8
XFILLER_64_246 VGND VGND VPWR VPWR sky130_fd_sc_hd__decap_3
XTAP_TAPCELL_ROW_66_1913 VGND VPWR sky130_fd_sc_hd__tapvpwrvgnd_1
XFILLER_79_1160 VGND VGND VPWR VPWR sky130_fd_sc_hd__decap_3
XTAP_TAPCELL_ROW_66_1924 VGND VPWR sky130_fd_sc_hd__tapvpwrvgnd_1
XFILLER_33_611 VGND VGND VPWR VPWR sky130_fd_sc_hd__decap_3
XFILLER_75_1035 VGND VGND VPWR VPWR sky130_fd_sc_hd__decap_3
X_4860_ _4881_/A _4860_/B _4860_/C VGND VGND VPWR VPWR _4860_/X sky130_fd_sc_hd__and3_2
XFILLER_61_953 VGND VGND VPWR VPWR sky130_fd_sc_hd__fill_1
XFILLER_60_441 VGND VGND VPWR VPWR sky130_fd_sc_hd__decap_3
XFILLER_36_1019 VGND VGND VPWR VPWR sky130_fd_sc_hd__fill_1
X_3811_ _4291_/B _4279_/B VGND VGND VPWR VPWR _3812_/B sky130_fd_sc_hd__xnor2_2
XFILLER_33_688 VGND VGND VPWR VPWR sky130_fd_sc_hd__fill_2
XFILLER_53_1322 VGND VGND VPWR VPWR sky130_fd_sc_hd__decap_3
X_4791_ _6328_/Q _4849_/S _4788_/X _4790_/X VGND VGND VPWR VPWR _6328_/D sky130_fd_sc_hd__o22a_2
XFILLER_18_1453 VGND VGND VPWR VPWR sky130_fd_sc_hd__decap_3
XANTENNA_17 _3915_/X VGND VGND VPWR VPWR sky130_fd_sc_hd__diode_2
XANTENNA_28 _5887_/S VGND VGND VPWR VPWR sky130_fd_sc_hd__diode_2
XFILLER_14_1306 VGND VGND VPWR VPWR sky130_fd_sc_hd__decap_3
XANTENNA_39 fanout47/X VGND VGND VPWR VPWR sky130_fd_sc_hd__diode_2
X_6530_ _6999_/CLK _6530_/D load_slew786/X VGND VGND VPWR VPWR _6530_/Q sky130_fd_sc_hd__dfrtp_2
XFILLER_14_1317 VGND VGND VPWR VPWR sky130_fd_sc_hd__decap_3
XFILLER_53_1366 VGND VGND VPWR VPWR sky130_fd_sc_hd__decap_3
X_3742_ _6496_/Q _3483_/A _3719_/X _3741_/Y VGND VGND VPWR VPWR _3742_/X sky130_fd_sc_hd__o211a_2
XFILLER_53_1399 VGND VGND VPWR VPWR sky130_fd_sc_hd__fill_1
X_6461_ _7054_/CLK _6461_/D load_slew757/X VGND VGND VPWR VPWR _6461_/Q sky130_fd_sc_hd__dfrtp_2
X_3673_ _3673_/A _3673_/B VGND VGND VPWR VPWR _3674_/B sky130_fd_sc_hd__xnor2_2
X_5412_ _5412_/A1 _5476_/A2 _4520_/X VGND VGND VPWR VPWR _6524_/D sky130_fd_sc_hd__a21o_2
X_6392_ _6858_/CLK _6392_/D fanout646/X VGND VGND VPWR VPWR _6392_/Q sky130_fd_sc_hd__dfrtp_2
X_5343_ _6464_/Q _5342_/X _5355_/S VGND VGND VPWR VPWR _6464_/D sky130_fd_sc_hd__mux2_1
X_5274_ _6771_/Q _5304_/S _5305_/S _5273_/Y VGND VGND VPWR VPWR _5274_/X sky130_fd_sc_hd__o211a_2
X_7013_ clkload8/A _7013_/D load_slew643/X VGND VGND VPWR VPWR _7013_/Q sky130_fd_sc_hd__dfrtp_2
XFILLER_25_1413 VGND VGND VPWR VPWR sky130_fd_sc_hd__decap_3
XFILLER_64_1462 VGND VGND VPWR VPWR sky130_fd_sc_hd__decap_3
X_4225_ _6483_/Q _3483_/A _4831_/C1 _4224_/X VGND VGND VPWR VPWR _4225_/X sky130_fd_sc_hd__o211a_2
XFILLER_60_1315 VGND VGND VPWR VPWR sky130_fd_sc_hd__fill_1
XFILLER_25_1446 VGND VGND VPWR VPWR sky130_fd_sc_hd__decap_3
XFILLER_29_906 VGND VGND VPWR VPWR sky130_fd_sc_hd__decap_3
XFILLER_60_1326 VGND VGND VPWR VPWR sky130_fd_sc_hd__decap_3
XFILLER_25_1457 VGND VGND VPWR VPWR sky130_fd_sc_hd__decap_3
X_4156_ _6276_/Q wire507/X _3234_/X _4583_/B2 VGND VGND VPWR VPWR _4156_/X sky130_fd_sc_hd__a22o_2
XFILLER_60_1359 VGND VGND VPWR VPWR sky130_fd_sc_hd__decap_3
XFILLER_46_29 VGND VGND VPWR VPWR sky130_fd_sc_hd__decap_3
X_3107_ _6075_/S _7075_/Q VGND VGND VPWR VPWR _3107_/X sky130_fd_sc_hd__and2_2
XFILLER_3_1231 VGND VGND VPWR VPWR sky130_fd_sc_hd__fill_1
XFILLER_23_1170 VGND VGND VPWR VPWR sky130_fd_sc_hd__decap_3
X_4087_ _6244_/Q wire77/X _4085_/X _4086_/X VGND VGND VPWR VPWR _6244_/D sky130_fd_sc_hd__o22a_2
XFILLER_3_1242 VGND VGND VPWR VPWR sky130_fd_sc_hd__decap_3
XFILLER_71_717 VGND VGND VPWR VPWR sky130_fd_sc_hd__decap_3
XFILLER_58_1200 VGND VGND VPWR VPWR sky130_fd_sc_hd__decap_3
XFILLER_3_1275 VGND VGND VPWR VPWR sky130_fd_sc_hd__decap_3
XFILLER_55_279 VGND VGND VPWR VPWR sky130_fd_sc_hd__fill_1
XFILLER_37_994 VGND VGND VPWR VPWR sky130_fd_sc_hd__decap_3
XFILLER_64_780 VGND VGND VPWR VPWR sky130_fd_sc_hd__decap_3
XFILLER_23_110 VGND VGND VPWR VPWR sky130_fd_sc_hd__fill_2
XFILLER_58_1255 VGND VGND VPWR VPWR sky130_fd_sc_hd__decap_3
XTAP_TAPCELL_ROW_19_691 VGND VPWR sky130_fd_sc_hd__tapvpwrvgnd_1
XFILLER_19_1217 VGND VGND VPWR VPWR sky130_fd_sc_hd__decap_3
XFILLER_24_666 VGND VGND VPWR VPWR sky130_fd_sc_hd__decap_3
XFILLER_19_1239 VGND VGND VPWR VPWR sky130_fd_sc_hd__decap_3
XFILLER_58_1288 VGND VGND VPWR VPWR sky130_fd_sc_hd__decap_3
XFILLER_51_463 VGND VGND VPWR VPWR sky130_fd_sc_hd__decap_3
XFILLER_23_165 VGND VGND VPWR VPWR sky130_fd_sc_hd__decap_3
XFILLER_71_1422 VGND VGND VPWR VPWR sky130_fd_sc_hd__decap_3
X_4989_ _6388_/Q _5234_/B _5052_/B1 VGND VGND VPWR VPWR _4989_/Y sky130_fd_sc_hd__a21oi_2
XFILLER_71_1455 VGND VGND VPWR VPWR sky130_fd_sc_hd__fill_1
X_6728_ _7048_/CLK _6728_/D wire655/X VGND VGND VPWR VPWR _6728_/Q sky130_fd_sc_hd__dfrtp_2
XFILLER_32_1406 VGND VGND VPWR VPWR sky130_fd_sc_hd__decap_3
XFILLER_71_1466 VGND VGND VPWR VPWR sky130_fd_sc_hd__decap_3
XFILLER_20_861 VGND VGND VPWR VPWR sky130_fd_sc_hd__decap_3
X_6659_ _7035_/CLK _6659_/D load_slew831/X VGND VGND VPWR VPWR _6659_/Q sky130_fd_sc_hd__dfrtp_2
XFILLER_11_21 VGND VGND VPWR VPWR sky130_fd_sc_hd__fill_1
XFILLER_69_1340 VGND VGND VPWR VPWR sky130_fd_sc_hd__decap_3
XFILLER_69_1351 VGND VGND VPWR VPWR sky130_fd_sc_hd__decap_3
XFILLER_3_526 VGND VGND VPWR VPWR sky130_fd_sc_hd__decap_3
XFILLER_11_76 VGND VGND VPWR VPWR sky130_fd_sc_hd__decap_3
XFILLER_69_1384 VGND VGND VPWR VPWR sky130_fd_sc_hd__decap_3
XFILLER_3_559 VGND VGND VPWR VPWR sky130_fd_sc_hd__fill_1
XFILLER_65_1248 VGND VGND VPWR VPWR sky130_fd_sc_hd__decap_3
XFILLER_8_1120 VGND VGND VPWR VPWR sky130_fd_sc_hd__decap_3
XTAP_TAPCELL_ROW_6_353 VGND VPWR sky130_fd_sc_hd__tapvpwrvgnd_1
Xfanout340 _4771_/A1 VGND VGND VPWR VPWR _5517_/A3 sky130_fd_sc_hd__clkdlybuf4s25_1
XFILLER_8_1164 VGND VGND VPWR VPWR sky130_fd_sc_hd__decap_3
XTAP_TAPCELL_ROW_6_364 VGND VPWR sky130_fd_sc_hd__tapvpwrvgnd_1
Xfanout362 _3712_/B VGND VGND VPWR VPWR _3533_/B1 sky130_fd_sc_hd__clkdlybuf4s25_1
Xfanout373 _4832_/B2 VGND VGND VPWR VPWR _4789_/B2 sky130_fd_sc_hd__clkdlybuf4s25_1
Xfanout384 _4757_/B2 VGND VGND VPWR VPWR _4086_/A2 sky130_fd_sc_hd__clkdlybuf4s25_1
Xfanout395 _3487_/X VGND VGND VPWR VPWR fanout395/X sky130_fd_sc_hd__clkdlybuf4s25_1
XFILLER_8_1197 VGND VGND VPWR VPWR sky130_fd_sc_hd__decap_3
XFILLER_74_533 VGND VGND VPWR VPWR sky130_fd_sc_hd__decap_3
XFILLER_46_224 VGND VGND VPWR VPWR sky130_fd_sc_hd__decap_3
XFILLER_47_769 VGND VGND VPWR VPWR sky130_fd_sc_hd__decap_3
XFILLER_41_1281 VGND VGND VPWR VPWR sky130_fd_sc_hd__decap_3
XFILLER_76_1300 VGND VGND VPWR VPWR sky130_fd_sc_hd__decap_3
XFILLER_41_1292 VGND VGND VPWR VPWR sky130_fd_sc_hd__decap_3
XFILLER_34_419 VGND VGND VPWR VPWR sky130_fd_sc_hd__fill_1
XFILLER_36_51 VGND VGND VPWR VPWR sky130_fd_sc_hd__decap_3
XFILLER_62_739 VGND VGND VPWR VPWR sky130_fd_sc_hd__decap_3
XTAP_TAPCELL_ROW_17_639 VGND VPWR sky130_fd_sc_hd__tapvpwrvgnd_1
XFILLER_76_1344 VGND VGND VPWR VPWR sky130_fd_sc_hd__decap_3
XFILLER_43_942 VGND VGND VPWR VPWR sky130_fd_sc_hd__decap_3
XFILLER_36_95 VGND VGND VPWR VPWR sky130_fd_sc_hd__decap_3
XFILLER_43_953 VGND VGND VPWR VPWR sky130_fd_sc_hd__decap_3
XFILLER_42_430 VGND VGND VPWR VPWR sky130_fd_sc_hd__decap_3
XFILLER_72_1208 VGND VGND VPWR VPWR sky130_fd_sc_hd__decap_3
XFILLER_37_1328 VGND VGND VPWR VPWR sky130_fd_sc_hd__decap_3
XFILLER_76_1388 VGND VGND VPWR VPWR sky130_fd_sc_hd__decap_3
XFILLER_30_603 VGND VGND VPWR VPWR sky130_fd_sc_hd__decap_3
XFILLER_42_474 VGND VGND VPWR VPWR sky130_fd_sc_hd__fill_2
XFILLER_35_1041 VGND VGND VPWR VPWR sky130_fd_sc_hd__decap_3
XTAP_TAPCELL_ROW_42_1286 VGND VPWR sky130_fd_sc_hd__tapvpwrvgnd_1
XTAP_TAPCELL_ROW_42_1297 VGND VPWR sky130_fd_sc_hd__tapvpwrvgnd_1
XFILLER_13_1372 VGND VGND VPWR VPWR sky130_fd_sc_hd__decap_3
Xwire796 wire796/A VGND VGND VPWR VPWR wire796/X sky130_fd_sc_hd__clkbuf_4
XFILLER_48_1424 VGND VGND VPWR VPWR sky130_fd_sc_hd__decap_3
XFILLER_48_1435 VGND VGND VPWR VPWR sky130_fd_sc_hd__decap_3
XTAP_TAPCELL_ROW_55_1625 VGND VPWR sky130_fd_sc_hd__tapvpwrvgnd_1
XFILLER_42_6 VGND VGND VPWR VPWR sky130_fd_sc_hd__decap_3
XTAP_TAPCELL_ROW_55_1636 VGND VPWR sky130_fd_sc_hd__tapvpwrvgnd_1
Xload_slew702 fanout701/X VGND VGND VPWR VPWR fanout699/A sky130_fd_sc_hd__clkbuf_4
XFILLER_48_1468 VGND VGND VPWR VPWR sky130_fd_sc_hd__fill_1
Xload_slew757 fanout756/X VGND VGND VPWR VPWR load_slew757/X sky130_fd_sc_hd__clkbuf_4
XFILLER_78_872 VGND VGND VPWR VPWR sky130_fd_sc_hd__decap_3
X_4010_ _4010_/A _4010_/B VGND VGND VPWR VPWR _4010_/X sky130_fd_sc_hd__or2_2
XFILLER_42_1078 VGND VGND VPWR VPWR sky130_fd_sc_hd__decap_3
XFILLER_20_1332 VGND VGND VPWR VPWR sky130_fd_sc_hd__decap_3
XFILLER_80_503 VGND VGND VPWR VPWR sky130_fd_sc_hd__fill_1
XFILLER_77_1119 VGND VGND VPWR VPWR sky130_fd_sc_hd__fill_1
XFILLER_0_1404 VGND VGND VPWR VPWR sky130_fd_sc_hd__decap_3
XFILLER_25_408 VGND VGND VPWR VPWR sky130_fd_sc_hd__decap_3
XFILLER_37_268 VGND VGND VPWR VPWR sky130_fd_sc_hd__decap_3
XFILLER_37_279 VGND VGND VPWR VPWR sky130_fd_sc_hd__fill_1
XFILLER_80_514 VGND VGND VPWR VPWR sky130_fd_sc_hd__decap_3
XFILLER_18_460 VGND VGND VPWR VPWR sky130_fd_sc_hd__decap_3
X_5961_ hold975/X _6965_/Q _5998_/S VGND VGND VPWR VPWR _5961_/X sky130_fd_sc_hd__mux2_1
XFILLER_20_1365 VGND VGND VPWR VPWR sky130_fd_sc_hd__decap_3
XFILLER_80_536 VGND VGND VPWR VPWR sky130_fd_sc_hd__decap_3
XFILLER_20_1376 VGND VGND VPWR VPWR sky130_fd_sc_hd__decap_3
XFILLER_52_227 VGND VGND VPWR VPWR sky130_fd_sc_hd__decap_3
XFILLER_80_558 VGND VGND VPWR VPWR sky130_fd_sc_hd__fill_2
X_4912_ _6377_/Q _5201_/B _5083_/A VGND VGND VPWR VPWR _4912_/Y sky130_fd_sc_hd__a21oi_2
XFILLER_33_430 VGND VGND VPWR VPWR sky130_fd_sc_hd__decap_3
X_5892_ _5901_/A0 _5892_/A1 _5896_/S VGND VGND VPWR VPWR _6901_/D sky130_fd_sc_hd__mux2_1
XFILLER_33_452 VGND VGND VPWR VPWR sky130_fd_sc_hd__decap_3
XFILLER_55_1428 VGND VGND VPWR VPWR sky130_fd_sc_hd__decap_3
XFILLER_21_603 VGND VGND VPWR VPWR sky130_fd_sc_hd__decap_3
X_4843_ _4428_/A _4608_/B _4266_/Y _4842_/X _6584_/Q VGND VGND VPWR VPWR _4843_/X
+ sky130_fd_sc_hd__a32o_2
XFILLER_60_271 VGND VGND VPWR VPWR sky130_fd_sc_hd__decap_3
XFILLER_18_1250 VGND VGND VPWR VPWR sky130_fd_sc_hd__decap_3
XFILLER_53_1130 VGND VGND VPWR VPWR sky130_fd_sc_hd__decap_3
XFILLER_18_1261 VGND VGND VPWR VPWR sky130_fd_sc_hd__decap_3
XFILLER_20_124 VGND VGND VPWR VPWR sky130_fd_sc_hd__fill_1
X_4774_ _6912_/Q _4774_/A2 _4891_/B1 _4773_/X VGND VGND VPWR VPWR _4774_/X sky130_fd_sc_hd__a211o_2
XFILLER_18_1294 VGND VGND VPWR VPWR sky130_fd_sc_hd__decap_3
XFILLER_53_1174 VGND VGND VPWR VPWR sky130_fd_sc_hd__fill_2
XFILLER_14_1136 VGND VGND VPWR VPWR sky130_fd_sc_hd__decap_3
X_6513_ _6958_/CLK _6513_/D load_slew760/X VGND VGND VPWR VPWR _6513_/Q sky130_fd_sc_hd__dfrtp_2
X_3725_ _3960_/A _6312_/Q VGND VGND VPWR VPWR _3725_/X sky130_fd_sc_hd__and2b_2
Xclkbuf_leaf_9_clk clkload1/A VGND VGND VPWR VPWR _6888_/CLK sky130_fd_sc_hd__clkbuf_8
X_6444_ _6910_/CLK _6444_/D load_slew784/X VGND VGND VPWR VPWR _6444_/Q sky130_fd_sc_hd__dfrtp_2
X_3656_ _3681_/A _3681_/B VGND VGND VPWR VPWR _3748_/A sky130_fd_sc_hd__nand2_2
X_6375_ _7065_/CLK _6375_/D load_slew736/X VGND VGND VPWR VPWR _6375_/Q sky130_fd_sc_hd__dfrtp_2
X_3587_ _3689_/A _3588_/B _3588_/C VGND VGND VPWR VPWR _3673_/A sky130_fd_sc_hd__and3_2
X_5326_ _6794_/Q _5015_/B _5326_/S VGND VGND VPWR VPWR _5326_/X sky130_fd_sc_hd__mux2_1
XFILLER_0_529 VGND VGND VPWR VPWR sky130_fd_sc_hd__decap_3
XFILLER_9_1440 VGND VGND VPWR VPWR sky130_fd_sc_hd__decap_3
X_5257_ _6427_/Q _5257_/A2 _5256_/X VGND VGND VPWR VPWR _6427_/D sky130_fd_sc_hd__a21o_2
XFILLER_29_1390 VGND VGND VPWR VPWR sky130_fd_sc_hd__decap_3
XFILLER_64_1270 VGND VGND VPWR VPWR sky130_fd_sc_hd__decap_3
XFILLER_69_861 VGND VGND VPWR VPWR sky130_fd_sc_hd__decap_3
XFILLER_5_1304 VGND VGND VPWR VPWR sky130_fd_sc_hd__decap_3
X_4208_ _6257_/Q _4622_/S _4205_/X _4207_/X VGND VGND VPWR VPWR _6257_/D sky130_fd_sc_hd__o22a_2
XFILLER_25_1254 VGND VGND VPWR VPWR sky130_fd_sc_hd__decap_3
X_5188_ _6741_/Q _5342_/S VGND VGND VPWR VPWR _5188_/Y sky130_fd_sc_hd__nor2_2
XFILLER_5_1337 VGND VGND VPWR VPWR sky130_fd_sc_hd__decap_3
XFILLER_5_1348 VGND VGND VPWR VPWR sky130_fd_sc_hd__decap_3
XFILLER_25_1287 VGND VGND VPWR VPWR sky130_fd_sc_hd__fill_1
XFILLER_21_1129 VGND VGND VPWR VPWR sky130_fd_sc_hd__decap_3
XFILLER_56_533 VGND VGND VPWR VPWR sky130_fd_sc_hd__decap_3
XFILLER_25_1298 VGND VGND VPWR VPWR sky130_fd_sc_hd__decap_3
X_4139_ _6475_/Q _5588_/A3 _4169_/S VGND VGND VPWR VPWR _4139_/X sky130_fd_sc_hd__mux2_1
XFILLER_16_408 VGND VGND VPWR VPWR sky130_fd_sc_hd__decap_3
XTAP_TAPCELL_ROW_27_904 VGND VPWR sky130_fd_sc_hd__tapvpwrvgnd_1
XFILLER_71_503 VGND VGND VPWR VPWR sky130_fd_sc_hd__fill_1
XTAP_TAPCELL_ROW_27_915 VGND VPWR sky130_fd_sc_hd__tapvpwrvgnd_1
XFILLER_73_27 VGND VGND VPWR VPWR sky130_fd_sc_hd__decap_3
XFILLER_71_514 VGND VGND VPWR VPWR sky130_fd_sc_hd__decap_3
XFILLER_37_780 VGND VGND VPWR VPWR sky130_fd_sc_hd__decap_3
XFILLER_44_739 VGND VGND VPWR VPWR sky130_fd_sc_hd__decap_3
XFILLER_3_1083 VGND VGND VPWR VPWR sky130_fd_sc_hd__decap_3
XFILLER_25_953 VGND VGND VPWR VPWR sky130_fd_sc_hd__decap_3
XFILLER_24_441 VGND VGND VPWR VPWR sky130_fd_sc_hd__decap_3
XFILLER_52_750 VGND VGND VPWR VPWR sky130_fd_sc_hd__decap_3
XFILLER_19_1025 VGND VGND VPWR VPWR sky130_fd_sc_hd__decap_3
XFILLER_25_986 VGND VGND VPWR VPWR sky130_fd_sc_hd__decap_3
XFILLER_58_1096 VGND VGND VPWR VPWR sky130_fd_sc_hd__fill_1
XFILLER_11_113 VGND VGND VPWR VPWR sky130_fd_sc_hd__decap_3
XFILLER_24_496 VGND VGND VPWR VPWR sky130_fd_sc_hd__decap_3
XFILLER_36_1350 VGND VGND VPWR VPWR sky130_fd_sc_hd__decap_3
XFILLER_40_978 VGND VGND VPWR VPWR sky130_fd_sc_hd__fill_2
XFILLER_40_989 VGND VGND VPWR VPWR sky130_fd_sc_hd__decap_3
XFILLER_71_1263 VGND VGND VPWR VPWR sky130_fd_sc_hd__decap_3
XFILLER_36_1394 VGND VGND VPWR VPWR sky130_fd_sc_hd__decap_3
XFILLER_32_1247 VGND VGND VPWR VPWR sky130_fd_sc_hd__decap_3
XFILLER_22_53 VGND VGND VPWR VPWR sky130_fd_sc_hd__decap_3
XFILLER_4_846 VGND VGND VPWR VPWR sky130_fd_sc_hd__decap_3
XFILLER_79_603 VGND VGND VPWR VPWR sky130_fd_sc_hd__decap_3
XFILLER_69_1192 VGND VGND VPWR VPWR sky130_fd_sc_hd__decap_3
XFILLER_65_1034 VGND VGND VPWR VPWR sky130_fd_sc_hd__decap_3
XFILLER_3_389 VGND VGND VPWR VPWR sky130_fd_sc_hd__decap_3
XFILLER_65_1056 VGND VGND VPWR VPWR sky130_fd_sc_hd__decap_3
XFILLER_26_1029 VGND VGND VPWR VPWR sky130_fd_sc_hd__decap_3
XFILLER_43_1310 VGND VGND VPWR VPWR sky130_fd_sc_hd__decap_3
XTAP_TAPCELL_ROW_50_1500 VGND VPWR sky130_fd_sc_hd__tapvpwrvgnd_1
XTAP_TAPCELL_ROW_50_1511 VGND VPWR sky130_fd_sc_hd__tapvpwrvgnd_1
XFILLER_43_1343 VGND VGND VPWR VPWR sky130_fd_sc_hd__fill_1
XFILLER_43_1354 VGND VGND VPWR VPWR sky130_fd_sc_hd__decap_3
Xfanout170 _4768_/A VGND VGND VPWR VPWR _3717_/A sky130_fd_sc_hd__clkdlybuf4s25_1
Xfanout192 _3459_/S VGND VGND VPWR VPWR fanout192/X sky130_fd_sc_hd__clkdlybuf4s25_1
XFILLER_43_1387 VGND VGND VPWR VPWR sky130_fd_sc_hd__decap_3
XFILLER_59_393 VGND VGND VPWR VPWR sky130_fd_sc_hd__decap_3
XFILLER_75_853 VGND VGND VPWR VPWR sky130_fd_sc_hd__decap_3
XFILLER_47_544 VGND VGND VPWR VPWR sky130_fd_sc_hd__decap_3
XFILLER_78_1406 VGND VGND VPWR VPWR sky130_fd_sc_hd__decap_3
XFILLER_74_341 VGND VGND VPWR VPWR sky130_fd_sc_hd__decap_3
XFILLER_19_268 VGND VGND VPWR VPWR sky130_fd_sc_hd__decap_3
XFILLER_74_396 VGND VGND VPWR VPWR sky130_fd_sc_hd__decap_3
XFILLER_34_238 VGND VGND VPWR VPWR sky130_fd_sc_hd__decap_3
XFILLER_76_1141 VGND VGND VPWR VPWR sky130_fd_sc_hd__decap_3
XTAP_TAPCELL_ROW_48_1440 VGND VPWR sky130_fd_sc_hd__tapvpwrvgnd_1
XFILLER_15_430 VGND VGND VPWR VPWR sky130_fd_sc_hd__decap_3
XFILLER_16_964 VGND VGND VPWR VPWR sky130_fd_sc_hd__decap_3
XTAP_TAPCELL_ROW_48_1451 VGND VPWR sky130_fd_sc_hd__tapvpwrvgnd_1
XFILLER_62_569 VGND VGND VPWR VPWR sky130_fd_sc_hd__decap_3
XFILLER_76_1152 VGND VGND VPWR VPWR sky130_fd_sc_hd__decap_3
XFILLER_15_463 VGND VGND VPWR VPWR sky130_fd_sc_hd__decap_3
XFILLER_76_1185 VGND VGND VPWR VPWR sky130_fd_sc_hd__decap_3
XFILLER_43_794 VGND VGND VPWR VPWR sky130_fd_sc_hd__fill_2
XTAP_TAPCELL_ROW_44_1337 VGND VPWR sky130_fd_sc_hd__tapvpwrvgnd_1
XFILLER_42_282 VGND VGND VPWR VPWR sky130_fd_sc_hd__fill_2
XTAP_TAPCELL_ROW_44_1348 VGND VPWR sky130_fd_sc_hd__tapvpwrvgnd_1
XFILLER_15_1401 VGND VGND VPWR VPWR sky130_fd_sc_hd__decap_3
XFILLER_42_293 VGND VGND VPWR VPWR sky130_fd_sc_hd__decap_3
XFILLER_54_1450 VGND VGND VPWR VPWR sky130_fd_sc_hd__decap_3
XFILLER_50_1303 VGND VGND VPWR VPWR sky130_fd_sc_hd__decap_3
XFILLER_30_466 VGND VGND VPWR VPWR sky130_fd_sc_hd__fill_1
XFILLER_15_1434 VGND VGND VPWR VPWR sky130_fd_sc_hd__decap_3
XFILLER_50_1347 VGND VGND VPWR VPWR sky130_fd_sc_hd__decap_3
X_3510_ _6300_/Q _6308_/Q _6316_/Q _6236_/Q _4394_/B _4394_/A VGND VGND VPWR VPWR
+ _3510_/X sky130_fd_sc_hd__mux4_2
XFILLER_7_673 VGND VGND VPWR VPWR sky130_fd_sc_hd__fill_1
X_4490_ _6520_/Q _4541_/A _4787_/C1 VGND VGND VPWR VPWR _4490_/X sky130_fd_sc_hd__a21bo_2
X_3441_ _6041_/A0 _3440_/X _3457_/S VGND VGND VPWR VPWR _6194_/D sky130_fd_sc_hd__mux2_1
XFILLER_40_3 VGND VGND VPWR VPWR sky130_fd_sc_hd__decap_3
X_6160_ _7011_/CLK _6160_/D fanout811/X VGND VGND VPWR VPWR _6160_/Q sky130_fd_sc_hd__dfrtp_2
X_3372_ _6305_/Q _6417_/Q VGND VGND VPWR VPWR _3372_/X sky130_fd_sc_hd__xor2_2
XFILLER_48_1254 VGND VGND VPWR VPWR sky130_fd_sc_hd__decap_3
Xload_slew510 _4882_/A2 VGND VGND VPWR VPWR _4854_/A2 sky130_fd_sc_hd__buf_2
XFILLER_48_1276 VGND VGND VPWR VPWR sky130_fd_sc_hd__decap_3
X_5111_ _6469_/Q _5111_/B VGND VGND VPWR VPWR _5112_/B sky130_fd_sc_hd__xnor2_2
XFILLER_69_124 VGND VGND VPWR VPWR sky130_fd_sc_hd__decap_3
X_6091_ _7009_/CLK _6091_/D load_slew767/X VGND VGND VPWR VPWR _6091_/Q sky130_fd_sc_hd__dfrtp_2
XFILLER_61_1410 VGND VGND VPWR VPWR sky130_fd_sc_hd__decap_3
Xhold1307 _6857_/Q VGND VGND VPWR VPWR _5840_/A1 sky130_fd_sc_hd__dlygate4sd3_1
X_5042_ _6460_/Q _6678_/Q VGND VGND VPWR VPWR _5043_/B sky130_fd_sc_hd__xor2_2
Xhold1318 _6761_/Q VGND VGND VPWR VPWR _5712_/A1 sky130_fd_sc_hd__dlygate4sd3_1
XFILLER_61_1443 VGND VGND VPWR VPWR sky130_fd_sc_hd__decap_3
XFILLER_38_500 VGND VGND VPWR VPWR sky130_fd_sc_hd__decap_3
Xhold1329 _6645_/Q VGND VGND VPWR VPWR _5562_/B1 sky130_fd_sc_hd__dlygate4sd3_1
XFILLER_66_820 VGND VGND VPWR VPWR sky130_fd_sc_hd__decap_3
Xload_slew598 _4394_/B VGND VGND VPWR VPWR _4369_/B sky130_fd_sc_hd__buf_2
XFILLER_22_1427 VGND VGND VPWR VPWR sky130_fd_sc_hd__fill_1
XFILLER_22_1438 VGND VGND VPWR VPWR sky130_fd_sc_hd__decap_3
XFILLER_66_886 VGND VGND VPWR VPWR sky130_fd_sc_hd__decap_3
XFILLER_0_1201 VGND VGND VPWR VPWR sky130_fd_sc_hd__decap_3
XFILLER_20_1140 VGND VGND VPWR VPWR sky130_fd_sc_hd__decap_3
X_6993_ _6993_/CLK _6993_/D load_slew748/X VGND VGND VPWR VPWR _6993_/Q sky130_fd_sc_hd__dfrtp_2
XFILLER_0_1223 VGND VGND VPWR VPWR sky130_fd_sc_hd__decap_3
XFILLER_65_396 VGND VGND VPWR VPWR sky130_fd_sc_hd__fill_1
XFILLER_0_1245 VGND VGND VPWR VPWR sky130_fd_sc_hd__decap_3
XFILLER_20_1184 VGND VGND VPWR VPWR sky130_fd_sc_hd__decap_3
X_5944_ hold965/X _5944_/A1 _5975_/S VGND VGND VPWR VPWR _6948_/D sky130_fd_sc_hd__mux2_1
XFILLER_0_1267 VGND VGND VPWR VPWR sky130_fd_sc_hd__decap_3
XFILLER_34_750 VGND VGND VPWR VPWR sky130_fd_sc_hd__decap_3
XFILLER_53_569 VGND VGND VPWR VPWR sky130_fd_sc_hd__decap_3
XFILLER_59_1372 VGND VGND VPWR VPWR sky130_fd_sc_hd__decap_3
XFILLER_0_1289 VGND VGND VPWR VPWR sky130_fd_sc_hd__decap_3
XFILLER_40_219 VGND VGND VPWR VPWR sky130_fd_sc_hd__fill_1
XFILLER_55_1236 VGND VGND VPWR VPWR sky130_fd_sc_hd__decap_3
XFILLER_80_399 VGND VGND VPWR VPWR sky130_fd_sc_hd__decap_3
XFILLER_21_411 VGND VGND VPWR VPWR sky130_fd_sc_hd__decap_3
X_5875_ _5875_/A1 _5868_/Y _5915_/C _5795_/X VGND VGND VPWR VPWR _6886_/D sky130_fd_sc_hd__a22o_2
XFILLER_55_1269 VGND VGND VPWR VPWR sky130_fd_sc_hd__decap_3
X_4826_ _6919_/Q _4862_/A2 _4862_/B1 _4825_/X VGND VGND VPWR VPWR _4826_/X sky130_fd_sc_hd__a211o_2
XFILLER_21_455 VGND VGND VPWR VPWR sky130_fd_sc_hd__fill_1
X_4757_ _6252_/Q wire515/X _3426_/X _4757_/B2 VGND VGND VPWR VPWR _4757_/X sky130_fd_sc_hd__a22o_2
X_3708_ _3787_/A _3762_/B VGND VGND VPWR VPWR _3709_/B sky130_fd_sc_hd__xnor2_2
X_4688_ _4717_/A _4865_/B VGND VGND VPWR VPWR _4688_/Y sky130_fd_sc_hd__nor2_2
X_6427_ _6765_/CLK _6427_/D wire641/X VGND VGND VPWR VPWR _6427_/Q sky130_fd_sc_hd__dfrtp_2
X_3639_ _3652_/B _3639_/B VGND VGND VPWR VPWR _3706_/A sky130_fd_sc_hd__nor2_2
XFILLER_49_1029 VGND VGND VPWR VPWR sky130_fd_sc_hd__decap_3
XTAP_TAPCELL_ROW_8_404 VGND VPWR sky130_fd_sc_hd__tapvpwrvgnd_1
XTAP_TAPCELL_ROW_8_415 VGND VPWR sky130_fd_sc_hd__tapvpwrvgnd_1
XFILLER_66_1332 VGND VGND VPWR VPWR sky130_fd_sc_hd__decap_3
X_6358_ _7048_/CLK _6358_/D load_slew658/X VGND VGND VPWR VPWR _6358_/Q sky130_fd_sc_hd__dfrtp_2
XFILLER_1_827 VGND VGND VPWR VPWR sky130_fd_sc_hd__decap_3
XFILLER_68_27 VGND VGND VPWR VPWR sky130_fd_sc_hd__fill_1
XFILLER_0_315 VGND VGND VPWR VPWR sky130_fd_sc_hd__decap_3
XFILLER_27_1316 VGND VGND VPWR VPWR sky130_fd_sc_hd__decap_3
XFILLER_66_1365 VGND VGND VPWR VPWR sky130_fd_sc_hd__decap_3
XFILLER_68_38 VGND VGND VPWR VPWR sky130_fd_sc_hd__decap_3
XFILLER_66_1376 VGND VGND VPWR VPWR sky130_fd_sc_hd__decap_3
XFILLER_0_337 VGND VGND VPWR VPWR sky130_fd_sc_hd__decap_3
X_5309_ _6447_/Q _5308_/X _5341_/S VGND VGND VPWR VPWR _6447_/D sky130_fd_sc_hd__mux2_1
XFILLER_62_1229 VGND VGND VPWR VPWR sky130_fd_sc_hd__decap_3
X_6289_ _6923_/CLK _6289_/D fanout802/X VGND VGND VPWR VPWR _6289_/Q sky130_fd_sc_hd__dfrtp_2
XFILLER_76_606 VGND VGND VPWR VPWR sky130_fd_sc_hd__decap_3
XFILLER_5_1101 VGND VGND VPWR VPWR sky130_fd_sc_hd__decap_3
XFILLER_75_116 VGND VGND VPWR VPWR sky130_fd_sc_hd__decap_3
XFILLER_9_1281 VGND VGND VPWR VPWR sky130_fd_sc_hd__decap_3
XFILLER_57_820 VGND VGND VPWR VPWR sky130_fd_sc_hd__decap_3
XFILLER_9_1292 VGND VGND VPWR VPWR sky130_fd_sc_hd__decap_3
XFILLER_29_522 VGND VGND VPWR VPWR sky130_fd_sc_hd__fill_1
XFILLER_5_1145 VGND VGND VPWR VPWR sky130_fd_sc_hd__decap_3
XFILLER_25_1084 VGND VGND VPWR VPWR sky130_fd_sc_hd__fill_1
XFILLER_29_544 VGND VGND VPWR VPWR sky130_fd_sc_hd__decap_3
XFILLER_56_330 VGND VGND VPWR VPWR sky130_fd_sc_hd__decap_3
XFILLER_57_864 VGND VGND VPWR VPWR sky130_fd_sc_hd__decap_3
XFILLER_1_1009 VGND VGND VPWR VPWR sky130_fd_sc_hd__decap_3
XFILLER_5_1189 VGND VGND VPWR VPWR sky130_fd_sc_hd__decap_3
XFILLER_57_897 VGND VGND VPWR VPWR sky130_fd_sc_hd__fill_1
XFILLER_16_216 VGND VGND VPWR VPWR sky130_fd_sc_hd__decap_3
XFILLER_44_536 VGND VGND VPWR VPWR sky130_fd_sc_hd__decap_3
XFILLER_38_1412 VGND VGND VPWR VPWR sky130_fd_sc_hd__decap_3
XFILLER_73_1325 VGND VGND VPWR VPWR sky130_fd_sc_hd__decap_3
XFILLER_71_388 VGND VGND VPWR VPWR sky130_fd_sc_hd__decap_3
XFILLER_71_399 VGND VGND VPWR VPWR sky130_fd_sc_hd__fill_1
XFILLER_25_794 VGND VGND VPWR VPWR sky130_fd_sc_hd__decap_3
XFILLER_38_1456 VGND VGND VPWR VPWR sky130_fd_sc_hd__decap_3
XFILLER_24_282 VGND VGND VPWR VPWR sky130_fd_sc_hd__decap_3
XFILLER_34_1309 VGND VGND VPWR VPWR sky130_fd_sc_hd__decap_3
XFILLER_73_1369 VGND VGND VPWR VPWR sky130_fd_sc_hd__decap_3
XFILLER_13_956 VGND VGND VPWR VPWR sky130_fd_sc_hd__decap_3
XFILLER_12_433 VGND VGND VPWR VPWR sky130_fd_sc_hd__decap_3
XFILLER_24_293 VGND VGND VPWR VPWR sky130_fd_sc_hd__decap_3
XFILLER_40_742 VGND VGND VPWR VPWR sky130_fd_sc_hd__decap_3
XFILLER_8_404 VGND VGND VPWR VPWR sky130_fd_sc_hd__decap_3
XFILLER_12_477 VGND VGND VPWR VPWR sky130_fd_sc_hd__decap_3
XFILLER_32_1022 VGND VGND VPWR VPWR sky130_fd_sc_hd__fill_1
XFILLER_8_448 VGND VGND VPWR VPWR sky130_fd_sc_hd__decap_3
XFILLER_4_610 VGND VGND VPWR VPWR sky130_fd_sc_hd__decap_3
XFILLER_10_1320 VGND VGND VPWR VPWR sky130_fd_sc_hd__decap_3
XFILLER_10_1353 VGND VGND VPWR VPWR sky130_fd_sc_hd__decap_3
XFILLER_3_131 VGND VGND VPWR VPWR sky130_fd_sc_hd__decap_3
XFILLER_4_676 VGND VGND VPWR VPWR sky130_fd_sc_hd__decap_3
XFILLER_10_1397 VGND VGND VPWR VPWR sky130_fd_sc_hd__decap_3
XFILLER_4_698 VGND VGND VPWR VPWR sky130_fd_sc_hd__fill_2
XTAP_TAPCELL_ROW_37_1152 VGND VPWR sky130_fd_sc_hd__tapvpwrvgnd_1
XFILLER_45_1416 VGND VGND VPWR VPWR sky130_fd_sc_hd__decap_3
XFILLER_80_1307 VGND VGND VPWR VPWR sky130_fd_sc_hd__decap_3
XFILLER_3_186 VGND VGND VPWR VPWR sky130_fd_sc_hd__decap_3
XTAP_TAPCELL_ROW_37_1163 VGND VPWR sky130_fd_sc_hd__tapvpwrvgnd_1
XFILLER_80_1329 VGND VGND VPWR VPWR sky130_fd_sc_hd__decap_3
XFILLER_79_455 VGND VGND VPWR VPWR sky130_fd_sc_hd__decap_3
XTAP_TAPCELL_ROW_37_1174 VGND VPWR sky130_fd_sc_hd__tapvpwrvgnd_1
XFILLER_45_1449 VGND VGND VPWR VPWR sky130_fd_sc_hd__decap_3
XFILLER_39_308 VGND VGND VPWR VPWR sky130_fd_sc_hd__decap_3
XFILLER_67_617 VGND VGND VPWR VPWR sky130_fd_sc_hd__fill_2
XTAP_TAPCELL_ROW_33_1049 VGND VPWR sky130_fd_sc_hd__tapvpwrvgnd_1
XFILLER_43_1140 VGND VGND VPWR VPWR sky130_fd_sc_hd__decap_3
XFILLER_0_893 VGND VGND VPWR VPWR sky130_fd_sc_hd__decap_3
XFILLER_58_82 VGND VGND VPWR VPWR sky130_fd_sc_hd__fill_2
XFILLER_78_1203 VGND VGND VPWR VPWR sky130_fd_sc_hd__fill_1
XFILLER_48_875 VGND VGND VPWR VPWR sky130_fd_sc_hd__decap_3
XFILLER_78_1214 VGND VGND VPWR VPWR sky130_fd_sc_hd__decap_3
XFILLER_35_514 VGND VGND VPWR VPWR sky130_fd_sc_hd__decap_3
XFILLER_78_1247 VGND VGND VPWR VPWR sky130_fd_sc_hd__decap_3
XFILLER_21_1460 VGND VGND VPWR VPWR sky130_fd_sc_hd__decap_3
XFILLER_62_322 VGND VGND VPWR VPWR sky130_fd_sc_hd__fill_1
XFILLER_35_547 VGND VGND VPWR VPWR sky130_fd_sc_hd__decap_3
XFILLER_63_856 VGND VGND VPWR VPWR sky130_fd_sc_hd__decap_3
XFILLER_16_750 VGND VGND VPWR VPWR sky130_fd_sc_hd__decap_3
X_3990_ _4088_/A1 _3717_/Y _4586_/B _3958_/Y _6533_/Q VGND VGND VPWR VPWR _3990_/X
+ sky130_fd_sc_hd__a32o_2
XFILLER_16_772 VGND VGND VPWR VPWR sky130_fd_sc_hd__decap_3
XFILLER_50_539 VGND VGND VPWR VPWR sky130_fd_sc_hd__decap_3
XFILLER_62_399 VGND VGND VPWR VPWR sky130_fd_sc_hd__fill_1
XFILLER_31_720 VGND VGND VPWR VPWR sky130_fd_sc_hd__decap_3
XFILLER_52_1409 VGND VGND VPWR VPWR sky130_fd_sc_hd__decap_3
XFILLER_30_230 VGND VGND VPWR VPWR sky130_fd_sc_hd__fill_2
X_5660_ _5825_/A0 _5660_/A1 _5666_/S VGND VGND VPWR VPWR _6715_/D sky130_fd_sc_hd__mux2_1
XFILLER_15_1231 VGND VGND VPWR VPWR sky130_fd_sc_hd__fill_1
XFILLER_31_797 VGND VGND VPWR VPWR sky130_fd_sc_hd__decap_3
X_4611_ _6544_/Q _4610_/A _4838_/A1 VGND VGND VPWR VPWR _4611_/X sky130_fd_sc_hd__a21bo_2
XFILLER_15_1242 VGND VGND VPWR VPWR sky130_fd_sc_hd__decap_3
XFILLER_54_1291 VGND VGND VPWR VPWR sky130_fd_sc_hd__decap_3
XFILLER_30_285 VGND VGND VPWR VPWR sky130_fd_sc_hd__fill_1
X_5591_ _5606_/A1 _5591_/A2 _3915_/X _5592_/B1 _5591_/B2 VGND VGND VPWR VPWR _6664_/D
+ sky130_fd_sc_hd__a32o_2
XFILLER_15_1275 VGND VGND VPWR VPWR sky130_fd_sc_hd__decap_3
X_4542_ _6527_/Q _4541_/A _4896_/A1 VGND VGND VPWR VPWR _4542_/X sky130_fd_sc_hd__a21bo_2
XFILLER_7_470 VGND VGND VPWR VPWR sky130_fd_sc_hd__decap_3
XFILLER_50_1199 VGND VGND VPWR VPWR sky130_fd_sc_hd__decap_3
X_4473_ _5609_/A3 _6518_/Q _4480_/S VGND VGND VPWR VPWR _4473_/X sky130_fd_sc_hd__mux2_1
Xmax_cap145 _4162_/A VGND VGND VPWR VPWR _4337_/A sky130_fd_sc_hd__buf_2
X_6212_ _7060_/CLK _6212_/D load_slew775/X VGND VGND VPWR VPWR _6212_/Q sky130_fd_sc_hd__dfrtp_2
Xmax_cap167 _5489_/Y VGND VGND VPWR VPWR _5534_/B1 sky130_fd_sc_hd__buf_2
X_3424_ _6323_/Q _6443_/Q VGND VGND VPWR VPWR _3424_/X sky130_fd_sc_hd__xor2_2
XFILLER_48_1040 VGND VGND VPWR VPWR sky130_fd_sc_hd__decap_3
XFILLER_48_1073 VGND VGND VPWR VPWR sky130_fd_sc_hd__decap_3
X_6143_ _7077_/CLK _6143_/D load_slew692/X VGND VGND VPWR VPWR _6143_/Q sky130_fd_sc_hd__dfrtp_2
X_3355_ _5998_/A0 _3354_/X _3355_/S VGND VGND VPWR VPWR _6151_/D sky130_fd_sc_hd__mux2_1
Xload_slew351 _4740_/B VGND VGND VPWR VPWR _4732_/A sky130_fd_sc_hd__buf_4
X_6074_ _7094_/D _6073_/B _7111_/A _5769_/A _7096_/Q VGND VGND VPWR VPWR _6074_/Y
+ sky130_fd_sc_hd__a311oi_2
XFILLER_6_1421 VGND VGND VPWR VPWR sky130_fd_sc_hd__decap_3
Xhold1104 _5964_/X VGND VGND VPWR VPWR _6968_/D sky130_fd_sc_hd__dlygate4sd3_1
Xhold1115 _6202_/Q VGND VGND VPWR VPWR _6049_/A0 sky130_fd_sc_hd__dlygate4sd3_1
XFILLER_6_1432 VGND VGND VPWR VPWR sky130_fd_sc_hd__decap_3
XFILLER_39_820 VGND VGND VPWR VPWR sky130_fd_sc_hd__decap_3
X_3286_ _6222_/Q _6374_/Q VGND VGND VPWR VPWR _3286_/X sky130_fd_sc_hd__xor2_2
XFILLER_26_1371 VGND VGND VPWR VPWR sky130_fd_sc_hd__fill_1
Xhold1126 _6618_/Q VGND VGND VPWR VPWR _5535_/B1 sky130_fd_sc_hd__dlygate4sd3_1
XFILLER_61_1251 VGND VGND VPWR VPWR sky130_fd_sc_hd__decap_3
Xhold1137 _6805_/Q VGND VGND VPWR VPWR _5762_/A1 sky130_fd_sc_hd__dlygate4sd3_1
XFILLER_26_1382 VGND VGND VPWR VPWR sky130_fd_sc_hd__decap_3
XFILLER_22_1224 VGND VGND VPWR VPWR sky130_fd_sc_hd__decap_3
X_5025_ _5023_/X _5024_/Y _5254_/A2 VGND VGND VPWR VPWR _5027_/S sky130_fd_sc_hd__a21oi_2
XFILLER_6_1465 VGND VGND VPWR VPWR sky130_fd_sc_hd__decap_3
Xhold1148 _6021_/X VGND VGND VPWR VPWR _7025_/D sky130_fd_sc_hd__dlygate4sd3_1
Xhold1159 _6870_/Q VGND VGND VPWR VPWR _5855_/A0 sky130_fd_sc_hd__dlygate4sd3_1
XFILLER_61_1284 VGND VGND VPWR VPWR sky130_fd_sc_hd__decap_3
XFILLER_61_1295 VGND VGND VPWR VPWR sky130_fd_sc_hd__decap_3
XFILLER_72_108 VGND VGND VPWR VPWR sky130_fd_sc_hd__decap_3
XFILLER_2_1329 VGND VGND VPWR VPWR sky130_fd_sc_hd__decap_3
XFILLER_22_1257 VGND VGND VPWR VPWR sky130_fd_sc_hd__decap_3
XFILLER_26_503 VGND VGND VPWR VPWR sky130_fd_sc_hd__decap_3
XFILLER_38_363 VGND VGND VPWR VPWR sky130_fd_sc_hd__fill_1
XFILLER_22_1279 VGND VGND VPWR VPWR sky130_fd_sc_hd__decap_3
XFILLER_54_18 VGND VGND VPWR VPWR sky130_fd_sc_hd__fill_1
XFILLER_26_536 VGND VGND VPWR VPWR sky130_fd_sc_hd__decap_3
XFILLER_54_867 VGND VGND VPWR VPWR sky130_fd_sc_hd__fill_1
XFILLER_80_130 VGND VGND VPWR VPWR sky130_fd_sc_hd__decap_3
XFILLER_14_709 VGND VGND VPWR VPWR sky130_fd_sc_hd__decap_3
XFILLER_26_569 VGND VGND VPWR VPWR sky130_fd_sc_hd__decap_3
XFILLER_80_141 VGND VGND VPWR VPWR sky130_fd_sc_hd__decap_3
XTAP_TAPCELL_ROW_0_167 VGND VPWR sky130_fd_sc_hd__tapvpwrvgnd_1
XTAP_TAPCELL_ROW_0_178 VGND VPWR sky130_fd_sc_hd__tapvpwrvgnd_1
X_6976_ _7072_/CLK _6976_/D fanout688/X VGND VGND VPWR VPWR _6976_/Q sky130_fd_sc_hd__dfrtp_2
XTAP_TAPCELL_ROW_0_189 VGND VPWR sky130_fd_sc_hd__tapvpwrvgnd_1
XFILLER_41_517 VGND VGND VPWR VPWR sky130_fd_sc_hd__fill_2
XFILLER_13_219 VGND VGND VPWR VPWR sky130_fd_sc_hd__decap_3
XFILLER_53_388 VGND VGND VPWR VPWR sky130_fd_sc_hd__decap_3
XFILLER_59_1180 VGND VGND VPWR VPWR sky130_fd_sc_hd__decap_3
XFILLER_0_1086 VGND VGND VPWR VPWR sky130_fd_sc_hd__decap_3
X_5927_ _5791_/C _5927_/A1 _5932_/S VGND VGND VPWR VPWR _6932_/D sky130_fd_sc_hd__mux2_1
XFILLER_22_720 VGND VGND VPWR VPWR sky130_fd_sc_hd__fill_2
X_5858_ _5858_/A0 _5858_/A1 wire97/X VGND VGND VPWR VPWR _6873_/D sky130_fd_sc_hd__mux2_1
X_4809_ _6579_/Q _4829_/A _4831_/A1 VGND VGND VPWR VPWR _4809_/X sky130_fd_sc_hd__a21bo_2
XFILLER_33_1331 VGND VGND VPWR VPWR sky130_fd_sc_hd__decap_3
XFILLER_72_1391 VGND VGND VPWR VPWR sky130_fd_sc_hd__decap_3
XPHY_EDGE_ROW_17_Right_17 VGND VGND VPWR VPWR sky130_fd_sc_hd__decap_3
XFILLER_6_908 VGND VGND VPWR VPWR sky130_fd_sc_hd__decap_3
X_5789_ _5801_/A_N _5868_/B _5789_/C VGND VGND VPWR VPWR _5789_/X sky130_fd_sc_hd__and3b_2
XFILLER_33_1375 VGND VGND VPWR VPWR sky130_fd_sc_hd__decap_3
XFILLER_79_15 VGND VGND VPWR VPWR sky130_fd_sc_hd__decap_3
XFILLER_68_1427 VGND VGND VPWR VPWR sky130_fd_sc_hd__fill_1
XFILLER_68_1438 VGND VGND VPWR VPWR sky130_fd_sc_hd__decap_3
XFILLER_79_48 VGND VGND VPWR VPWR sky130_fd_sc_hd__decap_3
XFILLER_1_613 VGND VGND VPWR VPWR sky130_fd_sc_hd__decap_3
Xhold960 _6152_/Q VGND VGND VPWR VPWR hold960/X sky130_fd_sc_hd__dlygate4sd3_1
Xhold971 _6098_/Q VGND VGND VPWR VPWR hold971/X sky130_fd_sc_hd__dlygate4sd3_1
XTAP_TAPCELL_ROW_73_2086 VGND VPWR sky130_fd_sc_hd__tapvpwrvgnd_1
Xhold982 _6158_/Q VGND VGND VPWR VPWR hold982/X sky130_fd_sc_hd__dlygate4sd3_1
XFILLER_66_1162 VGND VGND VPWR VPWR sky130_fd_sc_hd__decap_3
XTAP_TAPCELL_ROW_73_2097 VGND VPWR sky130_fd_sc_hd__tapvpwrvgnd_1
Xhold993 _7046_/Q VGND VGND VPWR VPWR hold993/X sky130_fd_sc_hd__dlygate4sd3_1
XFILLER_1_657 VGND VGND VPWR VPWR sky130_fd_sc_hd__decap_3
XFILLER_7_1207 VGND VGND VPWR VPWR sky130_fd_sc_hd__decap_3
XFILLER_0_134 VGND VGND VPWR VPWR sky130_fd_sc_hd__decap_3
XFILLER_27_1135 VGND VGND VPWR VPWR sky130_fd_sc_hd__decap_3
XFILLER_77_915 VGND VGND VPWR VPWR sky130_fd_sc_hd__decap_3
XFILLER_66_1195 VGND VGND VPWR VPWR sky130_fd_sc_hd__decap_3
XFILLER_0_156 VGND VGND VPWR VPWR sky130_fd_sc_hd__decap_3
XFILLER_1_679 VGND VGND VPWR VPWR sky130_fd_sc_hd__decap_3
XFILLER_49_617 VGND VGND VPWR VPWR sky130_fd_sc_hd__decap_3
XFILLER_62_1037 VGND VGND VPWR VPWR sky130_fd_sc_hd__decap_3
XFILLER_49_639 VGND VGND VPWR VPWR sky130_fd_sc_hd__decap_3
XFILLER_0_178 VGND VGND VPWR VPWR sky130_fd_sc_hd__decap_3
XPHY_EDGE_ROW_26_Right_26 VGND VGND VPWR VPWR sky130_fd_sc_hd__decap_3
XFILLER_76_458 VGND VGND VPWR VPWR sky130_fd_sc_hd__decap_3
XFILLER_40_1335 VGND VGND VPWR VPWR sky130_fd_sc_hd__decap_3
XFILLER_17_503 VGND VGND VPWR VPWR sky130_fd_sc_hd__fill_1
XFILLER_29_374 VGND VGND VPWR VPWR sky130_fd_sc_hd__decap_3
XFILLER_40_1368 VGND VGND VPWR VPWR sky130_fd_sc_hd__decap_3
XFILLER_44_300 VGND VGND VPWR VPWR sky130_fd_sc_hd__decap_3
XFILLER_17_525 VGND VGND VPWR VPWR sky130_fd_sc_hd__decap_3
XFILLER_40_1379 VGND VGND VPWR VPWR sky130_fd_sc_hd__decap_3
XFILLER_45_834 VGND VGND VPWR VPWR sky130_fd_sc_hd__decap_3
XFILLER_29_396 VGND VGND VPWR VPWR sky130_fd_sc_hd__decap_3
XFILLER_45_867 VGND VGND VPWR VPWR sky130_fd_sc_hd__decap_3
XFILLER_44_51 VGND VGND VPWR VPWR sky130_fd_sc_hd__decap_3
XFILLER_13_720 VGND VGND VPWR VPWR sky130_fd_sc_hd__decap_3
XFILLER_38_1242 VGND VGND VPWR VPWR sky130_fd_sc_hd__decap_3
XFILLER_73_1133 VGND VGND VPWR VPWR sky130_fd_sc_hd__decap_3
XFILLER_38_1264 VGND VGND VPWR VPWR sky130_fd_sc_hd__decap_3
XFILLER_73_1166 VGND VGND VPWR VPWR sky130_fd_sc_hd__decap_3
XFILLER_9_713 VGND VGND VPWR VPWR sky130_fd_sc_hd__decap_3
XFILLER_73_1177 VGND VGND VPWR VPWR sky130_fd_sc_hd__decap_3
XFILLER_13_775 VGND VGND VPWR VPWR sky130_fd_sc_hd__fill_1
XPHY_EDGE_ROW_35_Right_35 VGND VGND VPWR VPWR sky130_fd_sc_hd__decap_3
XFILLER_38_1297 VGND VGND VPWR VPWR sky130_fd_sc_hd__decap_3
XFILLER_34_1139 VGND VGND VPWR VPWR sky130_fd_sc_hd__decap_3
XFILLER_51_1431 VGND VGND VPWR VPWR sky130_fd_sc_hd__decap_3
XFILLER_74_9 VGND VGND VPWR VPWR sky130_fd_sc_hd__decap_3
XTAP_TAPCELL_ROW_23_792 VGND VPWR sky130_fd_sc_hd__tapvpwrvgnd_1
XFILLER_12_1415 VGND VGND VPWR VPWR sky130_fd_sc_hd__decap_3
XFILLER_60_61 VGND VGND VPWR VPWR sky130_fd_sc_hd__fill_2
XTAP_TAPCELL_ROW_10_453 VGND VPWR sky130_fd_sc_hd__tapvpwrvgnd_1
XFILLER_12_1459 VGND VGND VPWR VPWR sky130_fd_sc_hd__decap_3
XTAP_TAPCELL_ROW_10_464 VGND VPWR sky130_fd_sc_hd__tapvpwrvgnd_1
XFILLER_60_94 VGND VGND VPWR VPWR sky130_fd_sc_hd__fill_2
XTAP_TAPCELL_ROW_39_1203 VGND VPWR sky130_fd_sc_hd__tapvpwrvgnd_1
XFILLER_5_12 VGND VGND VPWR VPWR sky130_fd_sc_hd__decap_3
XTAP_TAPCELL_ROW_39_1214 VGND VPWR sky130_fd_sc_hd__tapvpwrvgnd_1
XTAP_TAPCELL_ROW_39_1225 VGND VPWR sky130_fd_sc_hd__tapvpwrvgnd_1
XFILLER_5_45 VGND VGND VPWR VPWR sky130_fd_sc_hd__decap_3
XFILLER_10_1161 VGND VGND VPWR VPWR sky130_fd_sc_hd__decap_3
XFILLER_4_473 VGND VGND VPWR VPWR sky130_fd_sc_hd__decap_3
XFILLER_49_1360 VGND VGND VPWR VPWR sky130_fd_sc_hd__decap_3
XFILLER_10_1194 VGND VGND VPWR VPWR sky130_fd_sc_hd__decap_3
XFILLER_5_89 VGND VGND VPWR VPWR sky130_fd_sc_hd__decap_3
XPHY_EDGE_ROW_44_Right_44 VGND VGND VPWR VPWR sky130_fd_sc_hd__decap_3
XFILLER_49_1393 VGND VGND VPWR VPWR sky130_fd_sc_hd__decap_3
XFILLER_68_904 VGND VGND VPWR VPWR sky130_fd_sc_hd__decap_3
XFILLER_45_1257 VGND VGND VPWR VPWR sky130_fd_sc_hd__decap_3
X_3140_ _6980_/Q _6988_/Q _3149_/S VGND VGND VPWR VPWR _3140_/X sky130_fd_sc_hd__mux2_1
XFILLER_68_959 VGND VGND VPWR VPWR sky130_fd_sc_hd__decap_3
X_3071_ _6367_/Q VGND VGND VPWR VPWR _3071_/Y sky130_fd_sc_hd__inv_2
XFILLER_76_981 VGND VGND VPWR VPWR sky130_fd_sc_hd__fill_2
XFILLER_1_1340 VGND VGND VPWR VPWR sky130_fd_sc_hd__decap_3
XFILLER_1_1351 VGND VGND VPWR VPWR sky130_fd_sc_hd__decap_3
X_6830_ _7022_/CLK _6830_/D fanout761/X VGND VGND VPWR VPWR _6830_/Q sky130_fd_sc_hd__dfrtp_2
XFILLER_35_355 VGND VGND VPWR VPWR sky130_fd_sc_hd__decap_3
XFILLER_39_1017 VGND VGND VPWR VPWR sky130_fd_sc_hd__decap_3
XFILLER_62_130 VGND VGND VPWR VPWR sky130_fd_sc_hd__fill_1
XTAP_TAPCELL_ROW_69_1988 VGND VPWR sky130_fd_sc_hd__tapvpwrvgnd_1
XTAP_TAPCELL_ROW_69_1999 VGND VPWR sky130_fd_sc_hd__tapvpwrvgnd_1
XFILLER_62_152 VGND VGND VPWR VPWR sky130_fd_sc_hd__decap_3
XFILLER_78_1088 VGND VGND VPWR VPWR sky130_fd_sc_hd__decap_3
XFILLER_35_377 VGND VGND VPWR VPWR sky130_fd_sc_hd__decap_3
XFILLER_51_826 VGND VGND VPWR VPWR sky130_fd_sc_hd__decap_3
XFILLER_78_1099 VGND VGND VPWR VPWR sky130_fd_sc_hd__decap_3
XFILLER_1_1384 VGND VGND VPWR VPWR sky130_fd_sc_hd__decap_3
XFILLER_56_1320 VGND VGND VPWR VPWR sky130_fd_sc_hd__decap_3
X_6761_ _6990_/CLK _6761_/D load_slew748/X VGND VGND VPWR VPWR _6761_/Q sky130_fd_sc_hd__dfrtp_2
XFILLER_35_399 VGND VGND VPWR VPWR sky130_fd_sc_hd__decap_3
XPHY_EDGE_ROW_53_Right_53 VGND VGND VPWR VPWR sky130_fd_sc_hd__decap_3
X_3973_ _4071_/B _3991_/B VGND VGND VPWR VPWR _3973_/Y sky130_fd_sc_hd__nor2_2
XFILLER_17_1304 VGND VGND VPWR VPWR sky130_fd_sc_hd__decap_3
XFILLER_56_1353 VGND VGND VPWR VPWR sky130_fd_sc_hd__decap_3
X_5712_ _5801_/C _5712_/A1 wire89/X VGND VGND VPWR VPWR _6761_/D sky130_fd_sc_hd__mux2_1
XFILLER_17_1337 VGND VGND VPWR VPWR sky130_fd_sc_hd__decap_3
X_6692_ _6988_/CLK _6692_/D fanout816/X VGND VGND VPWR VPWR _6692_/Q sky130_fd_sc_hd__dfrtp_2
XFILLER_31_550 VGND VGND VPWR VPWR sky130_fd_sc_hd__decap_3
XFILLER_17_1348 VGND VGND VPWR VPWR sky130_fd_sc_hd__decap_3
XFILLER_31_561 VGND VGND VPWR VPWR sky130_fd_sc_hd__fill_2
XFILLER_56_1397 VGND VGND VPWR VPWR sky130_fd_sc_hd__decap_3
X_5643_ _5909_/A0 _5643_/A1 wire92/X VGND VGND VPWR VPWR _6700_/D sky130_fd_sc_hd__mux2_1
X_5574_ _5567_/A _5574_/A2 _4562_/B _5568_/Y _5574_/B2 VGND VGND VPWR VPWR _6652_/D
+ sky130_fd_sc_hd__a32o_2
XFILLER_15_1094 VGND VGND VPWR VPWR sky130_fd_sc_hd__decap_3
X_4525_ _6525_/Q _4487_/X _4524_/X _4842_/A _4880_/C1 VGND VGND VPWR VPWR _4528_/B
+ sky130_fd_sc_hd__a221o_2
X_4456_ _6331_/Q _4868_/A2 _3312_/X _4868_/B2 VGND VGND VPWR VPWR _4456_/X sky130_fd_sc_hd__a22o_2
XFILLER_28_1400 VGND VGND VPWR VPWR sky130_fd_sc_hd__decap_3
XPHY_EDGE_ROW_62_Right_62 VGND VGND VPWR VPWR sky130_fd_sc_hd__decap_3
XFILLER_67_1460 VGND VGND VPWR VPWR sky130_fd_sc_hd__decap_3
X_3407_ _6024_/A0 _3406_/X _3421_/S VGND VGND VPWR VPWR _6177_/D sky130_fd_sc_hd__mux2_1
Xfanout703 fanout704/X VGND VGND VPWR VPWR fanout703/X sky130_fd_sc_hd__clkdlybuf4s25_1
XFILLER_63_1313 VGND VGND VPWR VPWR sky130_fd_sc_hd__decap_3
XFILLER_28_1444 VGND VGND VPWR VPWR sky130_fd_sc_hd__decap_3
Xfanout714 fanout717/X VGND VGND VPWR VPWR wire715/A sky130_fd_sc_hd__clkdlybuf4s25_1
X_4387_ _4886_/A1 _4386_/X _4360_/X _6507_/Q VGND VGND VPWR VPWR _4387_/X sky130_fd_sc_hd__a2bb2o_2
Xfanout725 fanout730/X VGND VGND VPWR VPWR fanout725/X sky130_fd_sc_hd__clkdlybuf4s25_1
Xfanout747 fanout752/X VGND VGND VPWR VPWR fanout747/X sky130_fd_sc_hd__clkdlybuf4s25_1
X_6126_ _7009_/CLK _6126_/D fanout765/X VGND VGND VPWR VPWR _6126_/Q sky130_fd_sc_hd__dfrtp_2
XFILLER_63_1357 VGND VGND VPWR VPWR sky130_fd_sc_hd__decap_3
Xfanout758 fanout790/X VGND VGND VPWR VPWR fanout758/X sky130_fd_sc_hd__clkdlybuf4s25_1
XFILLER_59_948 VGND VGND VPWR VPWR sky130_fd_sc_hd__decap_3
X_3338_ _6224_/Q _6400_/Q VGND VGND VPWR VPWR _3338_/X sky130_fd_sc_hd__xor2_2
Xload_slew181 _3473_/S VGND VGND VPWR VPWR _3425_/S sky130_fd_sc_hd__clkbuf_4
X_6057_ _6057_/A0 _7061_/Q _6061_/S VGND VGND VPWR VPWR _6057_/X sky130_fd_sc_hd__mux2_1
X_3269_ _5955_/A0 _3268_/X _3269_/S VGND VGND VPWR VPWR _6108_/D sky130_fd_sc_hd__mux2_1
XFILLER_61_1081 VGND VGND VPWR VPWR sky130_fd_sc_hd__decap_3
XFILLER_6_1273 VGND VGND VPWR VPWR sky130_fd_sc_hd__decap_3
X_5008_ _6423_/Q _5008_/B VGND VGND VPWR VPWR _5243_/B sky130_fd_sc_hd__xnor2_2
XFILLER_2_1126 VGND VGND VPWR VPWR sky130_fd_sc_hd__decap_3
XFILLER_54_620 VGND VGND VPWR VPWR sky130_fd_sc_hd__decap_3
XFILLER_66_480 VGND VGND VPWR VPWR sky130_fd_sc_hd__decap_3
XFILLER_26_355 VGND VGND VPWR VPWR sky130_fd_sc_hd__decap_3
XPHY_EDGE_ROW_71_Right_71 VGND VGND VPWR VPWR sky130_fd_sc_hd__decap_3
XFILLER_27_889 VGND VGND VPWR VPWR sky130_fd_sc_hd__decap_3
XFILLER_26_399 VGND VGND VPWR VPWR sky130_fd_sc_hd__decap_3
XFILLER_53_185 VGND VGND VPWR VPWR sky130_fd_sc_hd__fill_1
X_6959_ _6959_/CLK _6959_/D load_slew799/X VGND VGND VPWR VPWR _6959_/Q sky130_fd_sc_hd__dfrtp_2
XFILLER_74_1453 VGND VGND VPWR VPWR sky130_fd_sc_hd__decap_3
XFILLER_35_1404 VGND VGND VPWR VPWR sky130_fd_sc_hd__decap_3
XFILLER_70_1306 VGND VGND VPWR VPWR sky130_fd_sc_hd__decap_3
XFILLER_14_32 VGND VGND VPWR VPWR sky130_fd_sc_hd__decap_3
XFILLER_70_1317 VGND VGND VPWR VPWR sky130_fd_sc_hd__decap_3
XFILLER_35_1437 VGND VGND VPWR VPWR sky130_fd_sc_hd__decap_3
XFILLER_22_561 VGND VGND VPWR VPWR sky130_fd_sc_hd__decap_3
XFILLER_50_881 VGND VGND VPWR VPWR sky130_fd_sc_hd__decap_3
XFILLER_10_723 VGND VGND VPWR VPWR sky130_fd_sc_hd__decap_3
XFILLER_10_745 VGND VGND VPWR VPWR sky130_fd_sc_hd__fill_2
XTAP_TAPCELL_ROW_79_2251 VGND VPWR sky130_fd_sc_hd__tapvpwrvgnd_1
XTAP_TAPCELL_ROW_79_2262 VGND VPWR sky130_fd_sc_hd__tapvpwrvgnd_1
XFILLER_68_1202 VGND VGND VPWR VPWR sky130_fd_sc_hd__fill_2
XTAP_TAPCELL_ROW_75_2148 VGND VPWR sky130_fd_sc_hd__tapvpwrvgnd_1
XTAP_TAPCELL_ROW_75_2159 VGND VPWR sky130_fd_sc_hd__tapvpwrvgnd_1
XPHY_EDGE_ROW_80_Right_80 VGND VGND VPWR VPWR sky130_fd_sc_hd__decap_3
XFILLER_68_1235 VGND VGND VPWR VPWR sky130_fd_sc_hd__decap_3
XFILLER_2_911 VGND VGND VPWR VPWR sky130_fd_sc_hd__decap_3
XFILLER_68_1279 VGND VGND VPWR VPWR sky130_fd_sc_hd__decap_3
XFILLER_2_955 VGND VGND VPWR VPWR sky130_fd_sc_hd__decap_3
XFILLER_1_443 VGND VGND VPWR VPWR sky130_fd_sc_hd__decap_3
XFILLER_2_999 VGND VGND VPWR VPWR sky130_fd_sc_hd__decap_3
XFILLER_76_200 VGND VGND VPWR VPWR sky130_fd_sc_hd__fill_1
XFILLER_39_51 VGND VGND VPWR VPWR sky130_fd_sc_hd__decap_3
XFILLER_1_487 VGND VGND VPWR VPWR sky130_fd_sc_hd__decap_3
XFILLER_49_425 VGND VGND VPWR VPWR sky130_fd_sc_hd__decap_3
XFILLER_77_778 VGND VGND VPWR VPWR sky130_fd_sc_hd__decap_3
XFILLER_65_929 VGND VGND VPWR VPWR sky130_fd_sc_hd__fill_2
XFILLER_58_981 VGND VGND VPWR VPWR sky130_fd_sc_hd__fill_1
XFILLER_79_1331 VGND VGND VPWR VPWR sky130_fd_sc_hd__decap_3
XTAP_TAPCELL_ROW_4_292 VGND VPWR sky130_fd_sc_hd__tapvpwrvgnd_1
XFILLER_64_439 VGND VGND VPWR VPWR sky130_fd_sc_hd__decap_3
XFILLER_17_322 VGND VGND VPWR VPWR sky130_fd_sc_hd__decap_3
XFILLER_40_1176 VGND VGND VPWR VPWR sky130_fd_sc_hd__decap_3
Xhold1490 _6565_/Q VGND VGND VPWR VPWR _5453_/A1 sky130_fd_sc_hd__dlygate4sd3_1
XFILLER_29_193 VGND VGND VPWR VPWR sky130_fd_sc_hd__decap_3
XFILLER_79_1375 VGND VGND VPWR VPWR sky130_fd_sc_hd__decap_3
XFILLER_72_450 VGND VGND VPWR VPWR sky130_fd_sc_hd__fill_2
XFILLER_75_1228 VGND VGND VPWR VPWR sky130_fd_sc_hd__decap_3
XFILLER_72_461 VGND VGND VPWR VPWR sky130_fd_sc_hd__fill_1
XFILLER_75_1239 VGND VGND VPWR VPWR sky130_fd_sc_hd__decap_3
XFILLER_32_314 VGND VGND VPWR VPWR sky130_fd_sc_hd__decap_3
XFILLER_33_837 VGND VGND VPWR VPWR sky130_fd_sc_hd__decap_3
XFILLER_60_645 VGND VGND VPWR VPWR sky130_fd_sc_hd__decap_3
XTAP_TAPCELL_ROW_64_1852 VGND VPWR sky130_fd_sc_hd__tapvpwrvgnd_1
XTAP_TAPCELL_ROW_64_1863 VGND VPWR sky130_fd_sc_hd__tapvpwrvgnd_1
XTAP_TAPCELL_ROW_64_1874 VGND VPWR sky130_fd_sc_hd__tapvpwrvgnd_1
XTAP_TAPCELL_ROW_15_578 VGND VPWR sky130_fd_sc_hd__tapvpwrvgnd_1
XFILLER_13_561 VGND VGND VPWR VPWR sky130_fd_sc_hd__decap_3
XFILLER_41_870 VGND VGND VPWR VPWR sky130_fd_sc_hd__decap_3
XFILLER_71_60 VGND VGND VPWR VPWR sky130_fd_sc_hd__fill_2
XTAP_TAPCELL_ROW_15_589 VGND VPWR sky130_fd_sc_hd__tapvpwrvgnd_1
XTAP_TAPCELL_ROW_60_1749 VGND VPWR sky130_fd_sc_hd__tapvpwrvgnd_1
XFILLER_40_391 VGND VGND VPWR VPWR sky130_fd_sc_hd__decap_3
XFILLER_72_6 VGND VGND VPWR VPWR sky130_fd_sc_hd__decap_3
XFILLER_12_1201 VGND VGND VPWR VPWR sky130_fd_sc_hd__decap_3
XFILLER_12_1223 VGND VGND VPWR VPWR sky130_fd_sc_hd__decap_3
XFILLER_51_1272 VGND VGND VPWR VPWR sky130_fd_sc_hd__decap_3
XFILLER_12_1256 VGND VGND VPWR VPWR sky130_fd_sc_hd__decap_3
XFILLER_12_1267 VGND VGND VPWR VPWR sky130_fd_sc_hd__decap_3
X_4310_ _6829_/Q _4869_/A2 _4869_/B1 _4309_/X VGND VGND VPWR VPWR _4310_/X sky130_fd_sc_hd__a211o_2
X_5290_ _6438_/Q _5290_/A2 _5289_/X VGND VGND VPWR VPWR _6438_/D sky130_fd_sc_hd__a21o_2
XFILLER_47_1319 VGND VGND VPWR VPWR sky130_fd_sc_hd__decap_3
X_4241_ _4241_/A _4241_/B VGND VGND VPWR VPWR wire31/A sky130_fd_sc_hd__xnor2_2
XFILLER_45_1032 VGND VGND VPWR VPWR sky130_fd_sc_hd__decap_3
X_4172_ _4172_/A _4172_/B VGND VGND VPWR VPWR _4413_/B sky130_fd_sc_hd__xnor2_2
XFILLER_68_734 VGND VGND VPWR VPWR sky130_fd_sc_hd__decap_3
XFILLER_45_1076 VGND VGND VPWR VPWR sky130_fd_sc_hd__decap_3
X_3123_ _3202_/A _3123_/B _3123_/C VGND VGND VPWR VPWR _3123_/X sky130_fd_sc_hd__and3_2
XFILLER_56_918 VGND VGND VPWR VPWR sky130_fd_sc_hd__decap_3
XFILLER_55_406 VGND VGND VPWR VPWR sky130_fd_sc_hd__decap_3
XFILLER_3_1413 VGND VGND VPWR VPWR sky130_fd_sc_hd__decap_3
XFILLER_27_108 VGND VGND VPWR VPWR sky130_fd_sc_hd__decap_3
XFILLER_23_1363 VGND VGND VPWR VPWR sky130_fd_sc_hd__decap_3
X_3054_ _6350_/Q VGND VGND VPWR VPWR _3054_/Y sky130_fd_sc_hd__inv_2
XFILLER_67_299 VGND VGND VPWR VPWR sky130_fd_sc_hd__decap_3
XFILLER_3_1446 VGND VGND VPWR VPWR sky130_fd_sc_hd__decap_3
XFILLER_3_1457 VGND VGND VPWR VPWR sky130_fd_sc_hd__decap_3
XFILLER_23_1396 VGND VGND VPWR VPWR sky130_fd_sc_hd__decap_3
XFILLER_36_653 VGND VGND VPWR VPWR sky130_fd_sc_hd__decap_3
XFILLER_58_1415 VGND VGND VPWR VPWR sky130_fd_sc_hd__decap_3
XFILLER_51_623 VGND VGND VPWR VPWR sky130_fd_sc_hd__decap_3
XFILLER_58_1459 VGND VGND VPWR VPWR sky130_fd_sc_hd__decap_3
X_6813_ _7034_/CLK _6813_/D fanout675/X VGND VGND VPWR VPWR _6813_/Q sky130_fd_sc_hd__dfrtp_2
XFILLER_1_1192 VGND VGND VPWR VPWR sky130_fd_sc_hd__decap_3
X_6744_ _7095_/CLK _6744_/D fanout697/X VGND VGND VPWR VPWR _6744_/Q sky130_fd_sc_hd__dfrtp_2
X_3956_ _6223_/Q _4105_/A2 _3954_/X _3955_/X VGND VGND VPWR VPWR _6223_/D sky130_fd_sc_hd__o22a_2
X_6675_ _6923_/CLK _6675_/D fanout802/X VGND VGND VPWR VPWR _6675_/Q sky130_fd_sc_hd__dfrtp_2
XFILLER_13_1009 VGND VGND VPWR VPWR sky130_fd_sc_hd__fill_1
X_3887_ _3888_/A _3888_/B _3888_/C VGND VGND VPWR VPWR _3889_/A sky130_fd_sc_hd__a21oi_2
X_5626_ _5626_/A0 _5931_/A0 _5626_/S VGND VGND VPWR VPWR _6688_/D sky130_fd_sc_hd__mux2_1
XFILLER_30_1312 VGND VGND VPWR VPWR sky130_fd_sc_hd__decap_3
XFILLER_30_1323 VGND VGND VPWR VPWR sky130_fd_sc_hd__decap_3
X_5557_ _6358_/Q _5565_/A2 _5557_/B1 _5502_/D VGND VGND VPWR VPWR _6640_/D sky130_fd_sc_hd__a22o_2
XFILLER_30_1356 VGND VGND VPWR VPWR sky130_fd_sc_hd__decap_3
X_4508_ _6860_/Q _4862_/A2 _4862_/B1 _4507_/X VGND VGND VPWR VPWR _4508_/X sky130_fd_sc_hd__a211o_2
XFILLER_2_218 VGND VGND VPWR VPWR sky130_fd_sc_hd__decap_3
X_5488_ _7081_/Q _5519_/A2 _3078_/A VGND VGND VPWR VPWR _5488_/X sky130_fd_sc_hd__o21a_2
XFILLER_65_1419 VGND VGND VPWR VPWR sky130_fd_sc_hd__decap_3
XFILLER_4_9 VGND VGND VPWR VPWR sky130_fd_sc_hd__decap_3
XTAP_TAPCELL_ROW_70_2012 VGND VPWR sky130_fd_sc_hd__tapvpwrvgnd_1
XTAP_TAPCELL_ROW_70_2023 VGND VPWR sky130_fd_sc_hd__tapvpwrvgnd_1
X_4439_ _6513_/Q _4438_/A _4793_/A VGND VGND VPWR VPWR _4439_/X sky130_fd_sc_hd__a21bo_2
Xfanout500 _4773_/A2 VGND VGND VPWR VPWR _4416_/A2 sky130_fd_sc_hd__clkdlybuf4s25_1
Xfanout511 wire515/X VGND VGND VPWR VPWR _4408_/A2 sky130_fd_sc_hd__clkdlybuf4s25_1
Xfanout522 _5322_/S VGND VGND VPWR VPWR _5326_/S sky130_fd_sc_hd__clkdlybuf4s25_1
XFILLER_28_1252 VGND VGND VPWR VPWR sky130_fd_sc_hd__decap_3
XFILLER_63_1132 VGND VGND VPWR VPWR sky130_fd_sc_hd__decap_3
XFILLER_59_723 VGND VGND VPWR VPWR sky130_fd_sc_hd__decap_3
Xfanout533 fanout535/X VGND VGND VPWR VPWR _5340_/S sky130_fd_sc_hd__clkdlybuf4s25_1
XFILLER_8_1335 VGND VGND VPWR VPWR sky130_fd_sc_hd__decap_3
XFILLER_58_200 VGND VGND VPWR VPWR sky130_fd_sc_hd__fill_1
XFILLER_76_27 VGND VGND VPWR VPWR sky130_fd_sc_hd__fill_1
Xfanout544 _5261_/A VGND VGND VPWR VPWR _5330_/S sky130_fd_sc_hd__clkdlybuf4s25_1
XFILLER_76_38 VGND VGND VPWR VPWR sky130_fd_sc_hd__decap_3
XFILLER_28_1285 VGND VGND VPWR VPWR sky130_fd_sc_hd__decap_3
Xfanout555 _7076_/Q VGND VGND VPWR VPWR _3212_/A1 sky130_fd_sc_hd__clkdlybuf4s25_1
XFILLER_8_1368 VGND VGND VPWR VPWR sky130_fd_sc_hd__decap_3
XFILLER_24_1127 VGND VGND VPWR VPWR sky130_fd_sc_hd__decap_3
Xfanout566 _7072_/Q VGND VGND VPWR VPWR _5924_/A sky130_fd_sc_hd__clkdlybuf4s25_1
X_6109_ clkload8/A _6109_/D load_slew637/X VGND VGND VPWR VPWR _6109_/Q sky130_fd_sc_hd__dfrtp_2
Xfanout577 _4886_/A1 VGND VGND VPWR VPWR _4008_/A sky130_fd_sc_hd__clkdlybuf4s25_1
XFILLER_59_767 VGND VGND VPWR VPWR sky130_fd_sc_hd__decap_3
XFILLER_74_704 VGND VGND VPWR VPWR sky130_fd_sc_hd__fill_2
XFILLER_8_1379 VGND VGND VPWR VPWR sky130_fd_sc_hd__decap_3
XFILLER_24_1149 VGND VGND VPWR VPWR sky130_fd_sc_hd__decap_3
Xfanout588 _4394_/A VGND VGND VPWR VPWR _3566_/A sky130_fd_sc_hd__clkdlybuf4s25_1
X_7089_ _7089_/CLK _7089_/D wire734/X VGND VGND VPWR VPWR _7089_/Q sky130_fd_sc_hd__dfrtp_2
Xfanout599 input9/X VGND VGND VPWR VPWR _5923_/A1 sky130_fd_sc_hd__clkdlybuf4s25_1
XFILLER_74_726 VGND VGND VPWR VPWR sky130_fd_sc_hd__decap_3
XFILLER_41_1452 VGND VGND VPWR VPWR sky130_fd_sc_hd__decap_3
XFILLER_41_1463 VGND VGND VPWR VPWR sky130_fd_sc_hd__decap_3
XFILLER_73_225 VGND VGND VPWR VPWR sky130_fd_sc_hd__fill_2
XFILLER_6_1081 VGND VGND VPWR VPWR sky130_fd_sc_hd__decap_3
XFILLER_73_258 VGND VGND VPWR VPWR sky130_fd_sc_hd__decap_3
XFILLER_15_815 VGND VGND VPWR VPWR sky130_fd_sc_hd__fill_1
XFILLER_15_837 VGND VGND VPWR VPWR sky130_fd_sc_hd__decap_3
XFILLER_42_645 VGND VGND VPWR VPWR sky130_fd_sc_hd__decap_3
XTAP_TAPCELL_ROW_25_843 VGND VPWR sky130_fd_sc_hd__tapvpwrvgnd_1
XTAP_TAPCELL_ROW_25_854 VGND VPWR sky130_fd_sc_hd__tapvpwrvgnd_1
XFILLER_74_1250 VGND VGND VPWR VPWR sky130_fd_sc_hd__decap_3
XFILLER_74_1261 VGND VGND VPWR VPWR sky130_fd_sc_hd__decap_3
XFILLER_39_1381 VGND VGND VPWR VPWR sky130_fd_sc_hd__decap_3
XTAP_TAPCELL_ROW_12_504 VGND VPWR sky130_fd_sc_hd__tapvpwrvgnd_1
XTAP_TAPCELL_ROW_12_515 VGND VPWR sky130_fd_sc_hd__tapvpwrvgnd_1
XFILLER_74_1294 VGND VGND VPWR VPWR sky130_fd_sc_hd__decap_3
XFILLER_35_1245 VGND VGND VPWR VPWR sky130_fd_sc_hd__decap_3
XFILLER_41_199 VGND VGND VPWR VPWR sky130_fd_sc_hd__decap_3
XFILLER_70_1147 VGND VGND VPWR VPWR sky130_fd_sc_hd__fill_1
XFILLER_10_531 VGND VGND VPWR VPWR sky130_fd_sc_hd__fill_1
XFILLER_70_1158 VGND VGND VPWR VPWR sky130_fd_sc_hd__decap_3
XFILLER_35_1278 VGND VGND VPWR VPWR sky130_fd_sc_hd__decap_3
XFILLER_35_1289 VGND VGND VPWR VPWR sky130_fd_sc_hd__decap_3
XFILLER_10_564 VGND VGND VPWR VPWR sky130_fd_sc_hd__decap_3
XFILLER_6_513 VGND VGND VPWR VPWR sky130_fd_sc_hd__decap_3
XFILLER_41_96 VGND VGND VPWR VPWR sky130_fd_sc_hd__decap_3
XFILLER_68_1065 VGND VGND VPWR VPWR sky130_fd_sc_hd__decap_3
XFILLER_2_752 VGND VGND VPWR VPWR sky130_fd_sc_hd__decap_3
XFILLER_1_240 VGND VGND VPWR VPWR sky130_fd_sc_hd__decap_3
XFILLER_2_763 VGND VGND VPWR VPWR sky130_fd_sc_hd__decap_3
XFILLER_37_9 VGND VGND VPWR VPWR sky130_fd_sc_hd__decap_3
XFILLER_46_1341 VGND VGND VPWR VPWR sky130_fd_sc_hd__decap_3
XFILLER_2_785 VGND VGND VPWR VPWR sky130_fd_sc_hd__decap_3
XFILLER_1_273 VGND VGND VPWR VPWR sky130_fd_sc_hd__decap_3
XFILLER_1_284 VGND VGND VPWR VPWR sky130_fd_sc_hd__decap_3
XFILLER_2_24 VGND VGND VPWR VPWR sky130_fd_sc_hd__decap_3
XFILLER_2_35 VGND VGND VPWR VPWR sky130_fd_sc_hd__decap_3
XFILLER_46_1385 VGND VGND VPWR VPWR sky130_fd_sc_hd__decap_3
XTAP_TAPCELL_ROW_53_1575 VGND VPWR sky130_fd_sc_hd__tapvpwrvgnd_1
XTAP_TAPCELL_ROW_53_1586 VGND VPWR sky130_fd_sc_hd__tapvpwrvgnd_1
XFILLER_77_553 VGND VGND VPWR VPWR sky130_fd_sc_hd__decap_3
XFILLER_42_1249 VGND VGND VPWR VPWR sky130_fd_sc_hd__decap_3
XFILLER_2_68 VGND VGND VPWR VPWR sky130_fd_sc_hd__decap_3
XFILLER_37_406 VGND VGND VPWR VPWR sky130_fd_sc_hd__decap_3
XFILLER_64_203 VGND VGND VPWR VPWR sky130_fd_sc_hd__decap_3
XFILLER_77_597 VGND VGND VPWR VPWR sky130_fd_sc_hd__fill_2
XFILLER_37_439 VGND VGND VPWR VPWR sky130_fd_sc_hd__decap_3
XFILLER_49_299 VGND VGND VPWR VPWR sky130_fd_sc_hd__fill_2
XFILLER_66_71 VGND VGND VPWR VPWR sky130_fd_sc_hd__decap_3
XFILLER_80_707 VGND VGND VPWR VPWR sky130_fd_sc_hd__decap_3
XFILLER_18_653 VGND VGND VPWR VPWR sky130_fd_sc_hd__decap_3
XTAP_TAPCELL_ROW_66_1914 VGND VPWR sky130_fd_sc_hd__tapvpwrvgnd_1
XFILLER_79_1172 VGND VGND VPWR VPWR sky130_fd_sc_hd__decap_3
XFILLER_80_729 VGND VGND VPWR VPWR sky130_fd_sc_hd__decap_3
XTAP_TAPCELL_ROW_66_1925 VGND VPWR sky130_fd_sc_hd__tapvpwrvgnd_1
XFILLER_18_686 VGND VGND VPWR VPWR sky130_fd_sc_hd__decap_3
XFILLER_79_1183 VGND VGND VPWR VPWR sky130_fd_sc_hd__decap_3
XFILLER_45_472 VGND VGND VPWR VPWR sky130_fd_sc_hd__decap_3
XFILLER_33_623 VGND VGND VPWR VPWR sky130_fd_sc_hd__decap_3
XFILLER_33_667 VGND VGND VPWR VPWR sky130_fd_sc_hd__decap_3
X_3810_ _6241_/Q _3903_/A2 _3808_/X _3809_/X VGND VGND VPWR VPWR _4279_/B sky130_fd_sc_hd__o22a_2
XFILLER_18_1421 VGND VGND VPWR VPWR sky130_fd_sc_hd__decap_3
XFILLER_53_1301 VGND VGND VPWR VPWR sky130_fd_sc_hd__decap_3
XFILLER_18_1432 VGND VGND VPWR VPWR sky130_fd_sc_hd__decap_3
XFILLER_20_306 VGND VGND VPWR VPWR sky130_fd_sc_hd__fill_2
X_4790_ _6914_/Q _4790_/A2 _4869_/B1 _4789_/X VGND VGND VPWR VPWR _4790_/X sky130_fd_sc_hd__a211o_2
XFILLER_53_1334 VGND VGND VPWR VPWR sky130_fd_sc_hd__decap_3
XANTENNA_18 _3960_/Y VGND VGND VPWR VPWR sky130_fd_sc_hd__diode_2
XFILLER_20_328 VGND VGND VPWR VPWR sky130_fd_sc_hd__decap_3
XFILLER_32_188 VGND VGND VPWR VPWR sky130_fd_sc_hd__decap_3
XFILLER_53_1345 VGND VGND VPWR VPWR sky130_fd_sc_hd__decap_3
XFILLER_18_1465 VGND VGND VPWR VPWR sky130_fd_sc_hd__decap_3
XANTENNA_29 _5887_/S VGND VGND VPWR VPWR sky130_fd_sc_hd__diode_2
X_3741_ _3933_/A _4059_/B _4796_/A VGND VGND VPWR VPWR _3741_/Y sky130_fd_sc_hd__a21oi_2
XFILLER_9_340 VGND VGND VPWR VPWR sky130_fd_sc_hd__decap_3
XFILLER_14_1329 VGND VGND VPWR VPWR sky130_fd_sc_hd__decap_3
XFILLER_53_1378 VGND VGND VPWR VPWR sky130_fd_sc_hd__decap_3
X_6460_ _7054_/CLK _6460_/D load_slew754/X VGND VGND VPWR VPWR _6460_/Q sky130_fd_sc_hd__dfrtp_2
XFILLER_70_3 VGND VGND VPWR VPWR sky130_fd_sc_hd__decap_3
X_3672_ _3665_/A _3665_/B _3879_/A VGND VGND VPWR VPWR _3674_/A sky130_fd_sc_hd__a21oi_2
X_5411_ _5411_/A1 _5470_/A2 _4513_/X VGND VGND VPWR VPWR _6523_/D sky130_fd_sc_hd__a21o_2
X_6391_ _6990_/CLK _6391_/D fanout749/X VGND VGND VPWR VPWR _6391_/Q sky130_fd_sc_hd__dfrtp_2
XFILLER_12_1064 VGND VGND VPWR VPWR sky130_fd_sc_hd__fill_1
X_5342_ _6802_/Q _5072_/B _5342_/S VGND VGND VPWR VPWR _5342_/X sky130_fd_sc_hd__mux2_1
X_5273_ _5304_/S _5273_/B VGND VGND VPWR VPWR _5273_/Y sky130_fd_sc_hd__nand2_2
X_7012_ _7012_/CLK _7012_/D fanout812/X VGND VGND VPWR VPWR _7012_/Q sky130_fd_sc_hd__dfrtp_2
XFILLER_64_1441 VGND VGND VPWR VPWR sky130_fd_sc_hd__decap_3
X_4224_ _4338_/A _4808_/B _4218_/X _4831_/A1 VGND VGND VPWR VPWR _4224_/X sky130_fd_sc_hd__o2bb2a_2
XFILLER_25_1425 VGND VGND VPWR VPWR sky130_fd_sc_hd__decap_3
X_4155_ _6476_/Q _4319_/A2 _4582_/A _4154_/X VGND VGND VPWR VPWR _4155_/X sky130_fd_sc_hd__o211a_2
XFILLER_60_1338 VGND VGND VPWR VPWR sky130_fd_sc_hd__decap_3
XFILLER_28_406 VGND VGND VPWR VPWR sky130_fd_sc_hd__decap_3
XFILLER_3_1210 VGND VGND VPWR VPWR sky130_fd_sc_hd__decap_3
X_3106_ _3114_/B _3106_/B VGND VGND VPWR VPWR _3106_/Y sky130_fd_sc_hd__nand2_2
XFILLER_68_597 VGND VGND VPWR VPWR sky130_fd_sc_hd__fill_1
XFILLER_7_1390 VGND VGND VPWR VPWR sky130_fd_sc_hd__decap_3
XFILLER_55_225 VGND VGND VPWR VPWR sky130_fd_sc_hd__decap_3
X_4086_ _3474_/X _4086_/A2 _4584_/A2 _6934_/Q _4092_/C1 VGND VGND VPWR VPWR _4086_/X
+ sky130_fd_sc_hd__a221o_2
XFILLER_3_1254 VGND VGND VPWR VPWR sky130_fd_sc_hd__decap_3
XFILLER_37_973 VGND VGND VPWR VPWR sky130_fd_sc_hd__decap_3
XFILLER_71_729 VGND VGND VPWR VPWR sky130_fd_sc_hd__decap_3
XFILLER_3_1287 VGND VGND VPWR VPWR sky130_fd_sc_hd__fill_1
XFILLER_3_1298 VGND VGND VPWR VPWR sky130_fd_sc_hd__decap_3
XFILLER_58_1234 VGND VGND VPWR VPWR sky130_fd_sc_hd__decap_3
XFILLER_36_483 VGND VGND VPWR VPWR sky130_fd_sc_hd__fill_1
XFILLER_64_792 VGND VGND VPWR VPWR sky130_fd_sc_hd__decap_3
XFILLER_51_420 VGND VGND VPWR VPWR sky130_fd_sc_hd__decap_3
XTAP_TAPCELL_ROW_19_692 VGND VPWR sky130_fd_sc_hd__tapvpwrvgnd_1
XFILLER_58_1267 VGND VGND VPWR VPWR sky130_fd_sc_hd__decap_3
XFILLER_19_1229 VGND VGND VPWR VPWR sky130_fd_sc_hd__decap_3
XFILLER_52_965 VGND VGND VPWR VPWR sky130_fd_sc_hd__fill_2
XFILLER_54_1109 VGND VGND VPWR VPWR sky130_fd_sc_hd__fill_2
XFILLER_52_976 VGND VGND VPWR VPWR sky130_fd_sc_hd__decap_3
XFILLER_71_1401 VGND VGND VPWR VPWR sky130_fd_sc_hd__decap_3
XFILLER_52_998 VGND VGND VPWR VPWR sky130_fd_sc_hd__decap_3
XFILLER_51_475 VGND VGND VPWR VPWR sky130_fd_sc_hd__decap_3
XFILLER_11_317 VGND VGND VPWR VPWR sky130_fd_sc_hd__decap_3
X_4988_ _6388_/Q _5234_/B VGND VGND VPWR VPWR _4988_/X sky130_fd_sc_hd__or2_2
XFILLER_71_1434 VGND VGND VPWR VPWR sky130_fd_sc_hd__decap_3
X_6727_ _6991_/CLK _6727_/D wire796/X VGND VGND VPWR VPWR _6727_/Q sky130_fd_sc_hd__dfrtp_2
X_3939_ _4008_/B _4002_/A2 _4344_/B _3089_/B _6503_/Q VGND VGND VPWR VPWR _3939_/X
+ sky130_fd_sc_hd__a32o_2
XFILLER_32_1418 VGND VGND VPWR VPWR sky130_fd_sc_hd__decap_3
XFILLER_32_1429 VGND VGND VPWR VPWR sky130_fd_sc_hd__decap_3
X_6658_ _7072_/CLK _6658_/D load_slew684/X VGND VGND VPWR VPWR _6658_/Q sky130_fd_sc_hd__dfrtp_2
XFILLER_20_895 VGND VGND VPWR VPWR sky130_fd_sc_hd__fill_2
X_5609_ _5581_/A _5610_/A1 _5609_/A3 _5610_/B1 _5609_/B2 VGND VGND VPWR VPWR _6680_/D
+ sky130_fd_sc_hd__a32o_2
X_6589_ _6863_/CLK _6589_/D fanout756/X VGND VGND VPWR VPWR _6589_/Q sky130_fd_sc_hd__dfrtp_2
XFILLER_11_55 VGND VGND VPWR VPWR sky130_fd_sc_hd__fill_1
XFILLER_69_1363 VGND VGND VPWR VPWR sky130_fd_sc_hd__decap_3
XFILLER_11_88 VGND VGND VPWR VPWR sky130_fd_sc_hd__decap_3
XFILLER_65_1216 VGND VGND VPWR VPWR sky130_fd_sc_hd__decap_3
XFILLER_2_6 VGND VGND VPWR VPWR sky130_fd_sc_hd__decap_3
XFILLER_69_1396 VGND VGND VPWR VPWR sky130_fd_sc_hd__decap_3
XFILLER_8_1132 VGND VGND VPWR VPWR sky130_fd_sc_hd__decap_3
XFILLER_28_1071 VGND VGND VPWR VPWR sky130_fd_sc_hd__decap_3
XTAP_TAPCELL_ROW_6_354 VGND VPWR sky130_fd_sc_hd__tapvpwrvgnd_1
Xfanout352 _3722_/X VGND VGND VPWR VPWR _3903_/A2 sky130_fd_sc_hd__clkdlybuf4s25_1
XTAP_TAPCELL_ROW_6_365 VGND VPWR sky130_fd_sc_hd__tapvpwrvgnd_1
Xfanout363 _5579_/B2 VGND VGND VPWR VPWR _3712_/B sky130_fd_sc_hd__clkdlybuf4s25_1
XFILLER_8_1176 VGND VGND VPWR VPWR sky130_fd_sc_hd__decap_3
Xfanout374 fanout395/X VGND VGND VPWR VPWR _4713_/B2 sky130_fd_sc_hd__clkdlybuf4s25_1
XFILLER_59_564 VGND VGND VPWR VPWR sky130_fd_sc_hd__decap_3
XFILLER_19_428 VGND VGND VPWR VPWR sky130_fd_sc_hd__fill_2
XFILLER_41_1260 VGND VGND VPWR VPWR sky130_fd_sc_hd__decap_3
XFILLER_62_718 VGND VGND VPWR VPWR sky130_fd_sc_hd__decap_3
XFILLER_76_1312 VGND VGND VPWR VPWR sky130_fd_sc_hd__decap_3
XFILLER_74_589 VGND VGND VPWR VPWR sky130_fd_sc_hd__decap_3
XFILLER_15_601 VGND VGND VPWR VPWR sky130_fd_sc_hd__decap_3
XFILLER_76_1323 VGND VGND VPWR VPWR sky130_fd_sc_hd__decap_3
XFILLER_61_239 VGND VGND VPWR VPWR sky130_fd_sc_hd__decap_3
XFILLER_27_494 VGND VGND VPWR VPWR sky130_fd_sc_hd__decap_3
XFILLER_54_280 VGND VGND VPWR VPWR sky130_fd_sc_hd__decap_3
XFILLER_76_1356 VGND VGND VPWR VPWR sky130_fd_sc_hd__decap_3
XFILLER_37_1307 VGND VGND VPWR VPWR sky130_fd_sc_hd__decap_3
XFILLER_15_656 VGND VGND VPWR VPWR sky130_fd_sc_hd__decap_3
XFILLER_43_965 VGND VGND VPWR VPWR sky130_fd_sc_hd__decap_3
XFILLER_14_144 VGND VGND VPWR VPWR sky130_fd_sc_hd__decap_3
XFILLER_43_987 VGND VGND VPWR VPWR sky130_fd_sc_hd__decap_3
XFILLER_14_177 VGND VGND VPWR VPWR sky130_fd_sc_hd__decap_3
XTAP_TAPCELL_ROW_46_1390 VGND VPWR sky130_fd_sc_hd__tapvpwrvgnd_1
XFILLER_74_1091 VGND VGND VPWR VPWR sky130_fd_sc_hd__fill_1
XFILLER_30_648 VGND VGND VPWR VPWR sky130_fd_sc_hd__decap_3
XFILLER_35_1053 VGND VGND VPWR VPWR sky130_fd_sc_hd__fill_1
XFILLER_7_800 VGND VGND VPWR VPWR sky130_fd_sc_hd__decap_3
XFILLER_10_350 VGND VGND VPWR VPWR sky130_fd_sc_hd__fill_1
XFILLER_11_895 VGND VGND VPWR VPWR sky130_fd_sc_hd__fill_1
XTAP_TAPCELL_ROW_42_1287 VGND VPWR sky130_fd_sc_hd__tapvpwrvgnd_1
XFILLER_13_1340 VGND VGND VPWR VPWR sky130_fd_sc_hd__decap_3
XFILLER_7_844 VGND VGND VPWR VPWR sky130_fd_sc_hd__decap_3
XTAP_TAPCELL_ROW_42_1298 VGND VPWR sky130_fd_sc_hd__tapvpwrvgnd_1
Xwire764 wire764/A VGND VGND VPWR VPWR wire764/X sky130_fd_sc_hd__clkbuf_4
XFILLER_13_1351 VGND VGND VPWR VPWR sky130_fd_sc_hd__decap_3
XFILLER_6_343 VGND VGND VPWR VPWR sky130_fd_sc_hd__decap_3
XFILLER_13_1384 VGND VGND VPWR VPWR sky130_fd_sc_hd__decap_3
XTAP_TAPCELL_ROW_59_1740 VGND VPWR sky130_fd_sc_hd__tapvpwrvgnd_1
XFILLER_48_1403 VGND VGND VPWR VPWR sky130_fd_sc_hd__decap_3
XTAP_TAPCELL_ROW_55_1626 VGND VPWR sky130_fd_sc_hd__tapvpwrvgnd_1
XFILLER_48_1447 VGND VGND VPWR VPWR sky130_fd_sc_hd__decap_3
XTAP_TAPCELL_ROW_55_1637 VGND VPWR sky130_fd_sc_hd__tapvpwrvgnd_1
XFILLER_35_6 VGND VGND VPWR VPWR sky130_fd_sc_hd__decap_3
Xload_slew736 fanout735/X VGND VGND VPWR VPWR load_slew736/X sky130_fd_sc_hd__buf_4
XFILLER_2_571 VGND VGND VPWR VPWR sky130_fd_sc_hd__decap_3
XFILLER_78_840 VGND VGND VPWR VPWR sky130_fd_sc_hd__decap_3
Xload_slew769 fanout768/X VGND VGND VPWR VPWR load_slew769/X sky130_fd_sc_hd__clkbuf_4
XFILLER_77_81 VGND VGND VPWR VPWR sky130_fd_sc_hd__decap_3
XFILLER_37_203 VGND VGND VPWR VPWR sky130_fd_sc_hd__decap_3
XFILLER_42_1046 VGND VGND VPWR VPWR sky130_fd_sc_hd__fill_2
XFILLER_20_1300 VGND VGND VPWR VPWR sky130_fd_sc_hd__decap_3
XFILLER_37_225 VGND VGND VPWR VPWR sky130_fd_sc_hd__decap_3
XFILLER_65_556 VGND VGND VPWR VPWR sky130_fd_sc_hd__decap_3
XFILLER_19_951 VGND VGND VPWR VPWR sky130_fd_sc_hd__fill_1
XFILLER_19_962 VGND VGND VPWR VPWR sky130_fd_sc_hd__fill_1
XFILLER_0_1416 VGND VGND VPWR VPWR sky130_fd_sc_hd__decap_3
XFILLER_20_1344 VGND VGND VPWR VPWR sky130_fd_sc_hd__decap_3
XFILLER_65_578 VGND VGND VPWR VPWR sky130_fd_sc_hd__decap_3
XFILLER_53_729 VGND VGND VPWR VPWR sky130_fd_sc_hd__decap_3
X_5960_ _5960_/A0 _5960_/A1 _6015_/S VGND VGND VPWR VPWR _6964_/D sky130_fd_sc_hd__mux2_1
XFILLER_65_589 VGND VGND VPWR VPWR sky130_fd_sc_hd__decap_3
XFILLER_80_526 VGND VGND VPWR VPWR sky130_fd_sc_hd__decap_3
XFILLER_0_1438 VGND VGND VPWR VPWR sky130_fd_sc_hd__decap_3
XFILLER_18_472 VGND VGND VPWR VPWR sky130_fd_sc_hd__decap_3
XFILLER_20_1388 VGND VGND VPWR VPWR sky130_fd_sc_hd__decap_3
XFILLER_52_239 VGND VGND VPWR VPWR sky130_fd_sc_hd__decap_3
X_4911_ _6377_/Q _5201_/B VGND VGND VPWR VPWR _4911_/X sky130_fd_sc_hd__or2_2
X_5891_ _5900_/A0 _5891_/A1 _5896_/S VGND VGND VPWR VPWR _6900_/D sky130_fd_sc_hd__mux2_1
XFILLER_55_1407 VGND VGND VPWR VPWR sky130_fd_sc_hd__decap_3
XFILLER_34_987 VGND VGND VPWR VPWR sky130_fd_sc_hd__fill_2
XFILLER_61_773 VGND VGND VPWR VPWR sky130_fd_sc_hd__decap_3
XFILLER_21_615 VGND VGND VPWR VPWR sky130_fd_sc_hd__fill_1
X_4842_ _4842_/A _4842_/B _4842_/C VGND VGND VPWR VPWR _4842_/X sky130_fd_sc_hd__or3_2
XFILLER_20_103 VGND VGND VPWR VPWR sky130_fd_sc_hd__decap_3
XFILLER_60_283 VGND VGND VPWR VPWR sky130_fd_sc_hd__fill_1
XFILLER_21_659 VGND VGND VPWR VPWR sky130_fd_sc_hd__decap_3
X_4773_ _6254_/Q _4773_/A2 _3430_/X _4773_/B2 VGND VGND VPWR VPWR _4773_/X sky130_fd_sc_hd__a22o_2
XFILLER_18_1273 VGND VGND VPWR VPWR sky130_fd_sc_hd__decap_3
XFILLER_14_1115 VGND VGND VPWR VPWR sky130_fd_sc_hd__decap_3
X_6512_ _6882_/CLK _6512_/D fanout665/X VGND VGND VPWR VPWR _6512_/Q sky130_fd_sc_hd__dfrtp_2
X_3724_ _6320_/Q _4770_/B _3723_/X _3720_/X VGND VGND VPWR VPWR _4269_/A sky130_fd_sc_hd__o22a_2
XFILLER_9_181 VGND VGND VPWR VPWR sky130_fd_sc_hd__decap_3
XFILLER_31_1440 VGND VGND VPWR VPWR sky130_fd_sc_hd__decap_3
X_3655_ _3617_/A _3617_/B _3652_/X _3653_/Y VGND VGND VPWR VPWR _3681_/B sky130_fd_sc_hd__a211o_2
X_6443_ _7076_/CLK _6443_/D load_slew681/X VGND VGND VPWR VPWR _6443_/Q sky130_fd_sc_hd__dfrtp_2
X_6374_ _7095_/CLK _6374_/D fanout695/X VGND VGND VPWR VPWR _6374_/Q sky130_fd_sc_hd__dfrtp_2
X_3586_ _3588_/B _3588_/C VGND VGND VPWR VPWR _3645_/A sky130_fd_sc_hd__nand2_2
X_5325_ _6455_/Q _5324_/X _5341_/S VGND VGND VPWR VPWR _6455_/D sky130_fd_sc_hd__mux2_1
XFILLER_0_508 VGND VGND VPWR VPWR sky130_fd_sc_hd__decap_3
X_5256_ _6765_/Q _5332_/S _5333_/S _5255_/Y VGND VGND VPWR VPWR _5256_/X sky130_fd_sc_hd__o211a_2
XFILLER_9_1452 VGND VGND VPWR VPWR sky130_fd_sc_hd__decap_3
XFILLER_9_1463 VGND VGND VPWR VPWR sky130_fd_sc_hd__decap_3
XFILLER_25_1233 VGND VGND VPWR VPWR sky130_fd_sc_hd__decap_3
X_4207_ _6819_/Q _4883_/A2 _4766_/B1 _4206_/X VGND VGND VPWR VPWR _4207_/X sky130_fd_sc_hd__a211o_2
XFILLER_64_1282 VGND VGND VPWR VPWR sky130_fd_sc_hd__decap_3
X_5187_ _5186_/Y _5090_/X _5278_/A2 _6402_/Q VGND VGND VPWR VPWR _6402_/D sky130_fd_sc_hd__a2bb2o_2
XFILLER_5_1316 VGND VGND VPWR VPWR sky130_fd_sc_hd__decap_3
XFILLER_25_1266 VGND VGND VPWR VPWR sky130_fd_sc_hd__decap_3
XFILLER_56_512 VGND VGND VPWR VPWR sky130_fd_sc_hd__decap_3
X_4138_ _6250_/Q _4622_/S _4135_/X _4137_/X VGND VGND VPWR VPWR _6250_/D sky130_fd_sc_hd__o22a_2
XFILLER_56_567 VGND VGND VPWR VPWR sky130_fd_sc_hd__decap_3
XFILLER_3_1051 VGND VGND VPWR VPWR sky130_fd_sc_hd__decap_3
XTAP_TAPCELL_ROW_27_905 VGND VPWR sky130_fd_sc_hd__tapvpwrvgnd_1
X_4069_ _6241_/Q _4069_/A2 _4067_/X _4068_/X VGND VGND VPWR VPWR _6241_/D sky130_fd_sc_hd__o22a_2
XFILLER_73_39 VGND VGND VPWR VPWR sky130_fd_sc_hd__decap_3
XFILLER_71_526 VGND VGND VPWR VPWR sky130_fd_sc_hd__decap_3
XFILLER_43_228 VGND VGND VPWR VPWR sky130_fd_sc_hd__decap_3
XFILLER_3_1095 VGND VGND VPWR VPWR sky130_fd_sc_hd__decap_3
XFILLER_43_239 VGND VGND VPWR VPWR sky130_fd_sc_hd__decap_3
XFILLER_71_559 VGND VGND VPWR VPWR sky130_fd_sc_hd__fill_1
XFILLER_36_280 VGND VGND VPWR VPWR sky130_fd_sc_hd__decap_3
XFILLER_25_965 VGND VGND VPWR VPWR sky130_fd_sc_hd__decap_3
XFILLER_24_453 VGND VGND VPWR VPWR sky130_fd_sc_hd__decap_3
Xwire95 wire95/A VGND VGND VPWR VPWR wire95/X sky130_fd_sc_hd__buf_2
XFILLER_12_604 VGND VGND VPWR VPWR sky130_fd_sc_hd__decap_3
XFILLER_19_1037 VGND VGND VPWR VPWR sky130_fd_sc_hd__decap_3
XFILLER_11_103 VGND VGND VPWR VPWR sky130_fd_sc_hd__decap_3
XFILLER_40_946 VGND VGND VPWR VPWR sky130_fd_sc_hd__decap_3
XFILLER_12_648 VGND VGND VPWR VPWR sky130_fd_sc_hd__decap_3
XFILLER_71_1231 VGND VGND VPWR VPWR sky130_fd_sc_hd__fill_1
XFILLER_11_125 VGND VGND VPWR VPWR sky130_fd_sc_hd__decap_3
XFILLER_71_1242 VGND VGND VPWR VPWR sky130_fd_sc_hd__decap_3
XFILLER_8_608 VGND VGND VPWR VPWR sky130_fd_sc_hd__decap_3
XFILLER_36_1362 VGND VGND VPWR VPWR sky130_fd_sc_hd__decap_3
XFILLER_36_1373 VGND VGND VPWR VPWR sky130_fd_sc_hd__decap_3
XFILLER_71_1275 VGND VGND VPWR VPWR sky130_fd_sc_hd__decap_3
XFILLER_32_1226 VGND VGND VPWR VPWR sky130_fd_sc_hd__decap_3
XFILLER_20_681 VGND VGND VPWR VPWR sky130_fd_sc_hd__decap_3
XFILLER_32_1259 VGND VGND VPWR VPWR sky130_fd_sc_hd__fill_1
XFILLER_22_65 VGND VGND VPWR VPWR sky130_fd_sc_hd__decap_3
XFILLER_4_803 VGND VGND VPWR VPWR sky130_fd_sc_hd__decap_3
XFILLER_4_858 VGND VGND VPWR VPWR sky130_fd_sc_hd__decap_3
XFILLER_4_869 VGND VGND VPWR VPWR sky130_fd_sc_hd__decap_3
XFILLER_65_1002 VGND VGND VPWR VPWR sky130_fd_sc_hd__decap_3
XFILLER_69_1171 VGND VGND VPWR VPWR sky130_fd_sc_hd__decap_3
XFILLER_3_346 VGND VGND VPWR VPWR sky130_fd_sc_hd__decap_3
XFILLER_79_615 VGND VGND VPWR VPWR sky130_fd_sc_hd__fill_1
XFILLER_0_3 VGND VGND VPWR VPWR sky130_fd_sc_hd__decap_3
XFILLER_79_626 VGND VGND VPWR VPWR sky130_fd_sc_hd__decap_3
XFILLER_65_1046 VGND VGND VPWR VPWR sky130_fd_sc_hd__fill_2
XFILLER_78_136 VGND VGND VPWR VPWR sky130_fd_sc_hd__decap_3
XTAP_TAPCELL_ROW_50_1501 VGND VPWR sky130_fd_sc_hd__tapvpwrvgnd_1
XFILLER_43_1322 VGND VGND VPWR VPWR sky130_fd_sc_hd__decap_3
XTAP_TAPCELL_ROW_50_1512 VGND VPWR sky130_fd_sc_hd__tapvpwrvgnd_1
XFILLER_66_309 VGND VGND VPWR VPWR sky130_fd_sc_hd__decap_3
Xfanout171 _4768_/A VGND VGND VPWR VPWR _4694_/B sky130_fd_sc_hd__clkdlybuf4s25_1
XFILLER_19_203 VGND VGND VPWR VPWR sky130_fd_sc_hd__decap_3
XFILLER_43_1366 VGND VGND VPWR VPWR sky130_fd_sc_hd__decap_3
Xfanout182 _3481_/S VGND VGND VPWR VPWR wire183/A sky130_fd_sc_hd__clkdlybuf4s25_1
XFILLER_19_225 VGND VGND VPWR VPWR sky130_fd_sc_hd__decap_3
XFILLER_43_1399 VGND VGND VPWR VPWR sky130_fd_sc_hd__fill_1
XFILLER_47_556 VGND VGND VPWR VPWR sky130_fd_sc_hd__decap_3
XFILLER_78_1418 VGND VGND VPWR VPWR sky130_fd_sc_hd__decap_3
XFILLER_78_1429 VGND VGND VPWR VPWR sky130_fd_sc_hd__decap_3
XFILLER_47_95 VGND VGND VPWR VPWR sky130_fd_sc_hd__fill_1
XFILLER_35_729 VGND VGND VPWR VPWR sky130_fd_sc_hd__decap_3
XFILLER_62_504 VGND VGND VPWR VPWR sky130_fd_sc_hd__fill_2
XFILLER_47_589 VGND VGND VPWR VPWR sky130_fd_sc_hd__decap_3
XFILLER_76_1120 VGND VGND VPWR VPWR sky130_fd_sc_hd__decap_3
XTAP_TAPCELL_ROW_48_1441 VGND VPWR sky130_fd_sc_hd__tapvpwrvgnd_1
XFILLER_27_291 VGND VGND VPWR VPWR sky130_fd_sc_hd__decap_3
XTAP_TAPCELL_ROW_48_1452 VGND VPWR sky130_fd_sc_hd__tapvpwrvgnd_1
XFILLER_76_1164 VGND VGND VPWR VPWR sky130_fd_sc_hd__decap_3
XFILLER_16_976 VGND VGND VPWR VPWR sky130_fd_sc_hd__decap_3
XFILLER_43_773 VGND VGND VPWR VPWR sky130_fd_sc_hd__decap_3
XFILLER_72_1017 VGND VGND VPWR VPWR sky130_fd_sc_hd__decap_3
XFILLER_15_475 VGND VGND VPWR VPWR sky130_fd_sc_hd__decap_3
XFILLER_30_401 VGND VGND VPWR VPWR sky130_fd_sc_hd__decap_3
XFILLER_37_1137 VGND VGND VPWR VPWR sky130_fd_sc_hd__decap_3
XFILLER_76_1197 VGND VGND VPWR VPWR sky130_fd_sc_hd__decap_3
XFILLER_31_935 VGND VGND VPWR VPWR sky130_fd_sc_hd__decap_3
XTAP_TAPCELL_ROW_44_1338 VGND VPWR sky130_fd_sc_hd__tapvpwrvgnd_1
XFILLER_70_581 VGND VGND VPWR VPWR sky130_fd_sc_hd__decap_3
XTAP_TAPCELL_ROW_44_1349 VGND VPWR sky130_fd_sc_hd__tapvpwrvgnd_1
XFILLER_8_12 VGND VGND VPWR VPWR sky130_fd_sc_hd__decap_3
XFILLER_31_968 VGND VGND VPWR VPWR sky130_fd_sc_hd__fill_2
XFILLER_15_1413 VGND VGND VPWR VPWR sky130_fd_sc_hd__decap_3
XFILLER_54_1462 VGND VGND VPWR VPWR sky130_fd_sc_hd__decap_3
XFILLER_50_1315 VGND VGND VPWR VPWR sky130_fd_sc_hd__fill_1
XFILLER_15_1446 VGND VGND VPWR VPWR sky130_fd_sc_hd__decap_3
XFILLER_50_1326 VGND VGND VPWR VPWR sky130_fd_sc_hd__decap_3
XFILLER_30_489 VGND VGND VPWR VPWR sky130_fd_sc_hd__decap_3
XFILLER_15_1457 VGND VGND VPWR VPWR sky130_fd_sc_hd__decap_3
XFILLER_7_630 VGND VGND VPWR VPWR sky130_fd_sc_hd__decap_3
XFILLER_50_1359 VGND VGND VPWR VPWR sky130_fd_sc_hd__decap_3
XFILLER_7_652 VGND VGND VPWR VPWR sky130_fd_sc_hd__decap_3
Xwire594 _3601_/B VGND VGND VPWR VPWR _3496_/B sky130_fd_sc_hd__clkbuf_4
X_3440_ _6331_/Q _6451_/Q VGND VGND VPWR VPWR _3440_/X sky130_fd_sc_hd__xor2_2
XFILLER_48_1233 VGND VGND VPWR VPWR sky130_fd_sc_hd__decap_3
X_3371_ _6006_/A0 _3370_/X _3435_/S VGND VGND VPWR VPWR _6159_/D sky130_fd_sc_hd__mux2_1
X_5110_ _6615_/Q _6655_/Q VGND VGND VPWR VPWR _5111_/B sky130_fd_sc_hd__xnor2_2
XFILLER_3_880 VGND VGND VPWR VPWR sky130_fd_sc_hd__decap_3
XFILLER_33_3 VGND VGND VPWR VPWR sky130_fd_sc_hd__decap_3
XFILLER_48_1288 VGND VGND VPWR VPWR sky130_fd_sc_hd__decap_3
X_6090_ _6970_/CLK _6090_/D fanout670/X VGND VGND VPWR VPWR _6090_/Q sky130_fd_sc_hd__dfrtp_2
XFILLER_69_136 VGND VGND VPWR VPWR sky130_fd_sc_hd__decap_3
XFILLER_61_1422 VGND VGND VPWR VPWR sky130_fd_sc_hd__decap_3
X_5041_ _6363_/Q _5040_/X _5041_/S VGND VGND VPWR VPWR _6363_/D sky130_fd_sc_hd__mux2_1
Xhold1308 _6479_/Q VGND VGND VPWR VPWR _5367_/A1 sky130_fd_sc_hd__dlygate4sd3_1
XFILLER_69_169 VGND VGND VPWR VPWR sky130_fd_sc_hd__fill_1
Xhold1319 _6895_/Q VGND VGND VPWR VPWR _5885_/A1 sky130_fd_sc_hd__dlygate4sd3_1
XFILLER_22_1406 VGND VGND VPWR VPWR sky130_fd_sc_hd__decap_3
XFILLER_61_1455 VGND VGND VPWR VPWR sky130_fd_sc_hd__fill_1
XFILLER_61_1466 VGND VGND VPWR VPWR sky130_fd_sc_hd__decap_3
XFILLER_38_545 VGND VGND VPWR VPWR sky130_fd_sc_hd__decap_3
XFILLER_66_854 VGND VGND VPWR VPWR sky130_fd_sc_hd__decap_3
XFILLER_38_556 VGND VGND VPWR VPWR sky130_fd_sc_hd__decap_3
XFILLER_26_707 VGND VGND VPWR VPWR sky130_fd_sc_hd__decap_3
XFILLER_38_578 VGND VGND VPWR VPWR sky130_fd_sc_hd__fill_2
XFILLER_4_1371 VGND VGND VPWR VPWR sky130_fd_sc_hd__fill_1
XFILLER_65_375 VGND VGND VPWR VPWR sky130_fd_sc_hd__decap_3
XFILLER_66_898 VGND VGND VPWR VPWR sky130_fd_sc_hd__decap_3
X_6992_ _7048_/CLK _6992_/D fanout657/A VGND VGND VPWR VPWR _6992_/Q sky130_fd_sc_hd__dfrtp_2
XFILLER_4_1382 VGND VGND VPWR VPWR sky130_fd_sc_hd__decap_3
XFILLER_25_239 VGND VGND VPWR VPWR sky130_fd_sc_hd__decap_3
XFILLER_59_1340 VGND VGND VPWR VPWR sky130_fd_sc_hd__decap_3
X_5943_ _5943_/A0 _6947_/Q _6032_/S VGND VGND VPWR VPWR _5943_/X sky130_fd_sc_hd__mux2_1
XFILLER_59_1351 VGND VGND VPWR VPWR sky130_fd_sc_hd__decap_3
XFILLER_0_1257 VGND VGND VPWR VPWR sky130_fd_sc_hd__decap_3
XFILLER_0_1279 VGND VGND VPWR VPWR sky130_fd_sc_hd__decap_3
XFILLER_59_1384 VGND VGND VPWR VPWR sky130_fd_sc_hd__decap_3
XFILLER_22_913 VGND VGND VPWR VPWR sky130_fd_sc_hd__decap_3
X_5874_ _5874_/A1 _5868_/Y _5915_/C _5793_/X VGND VGND VPWR VPWR _6885_/D sky130_fd_sc_hd__a22o_2
XFILLER_55_1248 VGND VGND VPWR VPWR sky130_fd_sc_hd__decap_3
X_4825_ _6285_/Q _4861_/A2 _3444_/X _4861_/B2 VGND VGND VPWR VPWR _4825_/X sky130_fd_sc_hd__a22o_2
X_4756_ _4756_/A1 _4753_/X _4754_/Y _4755_/X _4558_/A VGND VGND VPWR VPWR _4756_/X
+ sky130_fd_sc_hd__o221a_2
XFILLER_30_990 VGND VGND VPWR VPWR sky130_fd_sc_hd__decap_3
X_3707_ _3829_/B _3707_/B VGND VGND VPWR VPWR _3762_/B sky130_fd_sc_hd__xnor2_2
X_4687_ _4420_/C _3717_/A _4300_/X _4665_/X _6555_/Q VGND VGND VPWR VPWR _4687_/X
+ sky130_fd_sc_hd__a32o_2
X_6426_ _7020_/CLK _6426_/D fanout804/X VGND VGND VPWR VPWR _6426_/Q sky130_fd_sc_hd__dfrtp_2
X_3638_ _3637_/B _3755_/A VGND VGND VPWR VPWR _3639_/B sky130_fd_sc_hd__and2b_2
XFILLER_31_1281 VGND VGND VPWR VPWR sky130_fd_sc_hd__decap_3
XFILLER_31_1292 VGND VGND VPWR VPWR sky130_fd_sc_hd__decap_3
XFILLER_66_1300 VGND VGND VPWR VPWR sky130_fd_sc_hd__decap_3
XTAP_TAPCELL_ROW_8_405 VGND VPWR sky130_fd_sc_hd__tapvpwrvgnd_1
XFILLER_1_806 VGND VGND VPWR VPWR sky130_fd_sc_hd__decap_3
XTAP_TAPCELL_ROW_8_416 VGND VPWR sky130_fd_sc_hd__tapvpwrvgnd_1
X_6357_ _6991_/CLK _6357_/D load_slew792/X VGND VGND VPWR VPWR _6357_/Q sky130_fd_sc_hd__dfrtp_2
X_3569_ _4665_/B _3565_/X _3567_/X _3568_/X VGND VGND VPWR VPWR _3569_/Y sky130_fd_sc_hd__o22ai_2
XFILLER_66_1344 VGND VGND VPWR VPWR sky130_fd_sc_hd__decap_3
XFILLER_0_305 VGND VGND VPWR VPWR sky130_fd_sc_hd__decap_3
XFILLER_1_839 VGND VGND VPWR VPWR sky130_fd_sc_hd__fill_1
XFILLER_0_327 VGND VGND VPWR VPWR sky130_fd_sc_hd__decap_3
XFILLER_27_1328 VGND VGND VPWR VPWR sky130_fd_sc_hd__decap_3
X_5308_ _6785_/Q _4952_/B _5356_/S VGND VGND VPWR VPWR _5308_/X sky130_fd_sc_hd__mux2_1
XFILLER_62_1208 VGND VGND VPWR VPWR sky130_fd_sc_hd__decap_3
X_6288_ _6858_/CLK _6288_/D wire652/X VGND VGND VPWR VPWR _6288_/Q sky130_fd_sc_hd__dfrtp_2
XFILLER_66_1388 VGND VGND VPWR VPWR sky130_fd_sc_hd__decap_3
XFILLER_0_349 VGND VGND VPWR VPWR sky130_fd_sc_hd__decap_3
XFILLER_9_1260 VGND VGND VPWR VPWR sky130_fd_sc_hd__decap_3
X_5239_ _6421_/Q _5263_/A2 _5238_/X VGND VGND VPWR VPWR _6421_/D sky130_fd_sc_hd__a21o_2
XFILLER_25_1030 VGND VGND VPWR VPWR sky130_fd_sc_hd__decap_3
XFILLER_29_501 VGND VGND VPWR VPWR sky130_fd_sc_hd__decap_3
XFILLER_5_1113 VGND VGND VPWR VPWR sky130_fd_sc_hd__decap_3
XFILLER_64_1090 VGND VGND VPWR VPWR sky130_fd_sc_hd__fill_2
XFILLER_5_1124 VGND VGND VPWR VPWR sky130_fd_sc_hd__decap_3
XFILLER_68_180 VGND VGND VPWR VPWR sky130_fd_sc_hd__fill_2
XFILLER_5_1157 VGND VGND VPWR VPWR sky130_fd_sc_hd__decap_3
XFILLER_29_556 VGND VGND VPWR VPWR sky130_fd_sc_hd__decap_3
XFILLER_56_342 VGND VGND VPWR VPWR sky130_fd_sc_hd__decap_3
XFILLER_57_876 VGND VGND VPWR VPWR sky130_fd_sc_hd__decap_3
XFILLER_17_729 VGND VGND VPWR VPWR sky130_fd_sc_hd__decap_3
XFILLER_17_54 VGND VGND VPWR VPWR sky130_fd_sc_hd__fill_2
XFILLER_77_1440 VGND VGND VPWR VPWR sky130_fd_sc_hd__decap_3
XFILLER_72_857 VGND VGND VPWR VPWR sky130_fd_sc_hd__decap_3
XFILLER_71_334 VGND VGND VPWR VPWR sky130_fd_sc_hd__fill_2
XFILLER_25_740 VGND VGND VPWR VPWR sky130_fd_sc_hd__fill_2
XFILLER_73_1304 VGND VGND VPWR VPWR sky130_fd_sc_hd__decap_3
XFILLER_71_367 VGND VGND VPWR VPWR sky130_fd_sc_hd__decap_3
XFILLER_38_1424 VGND VGND VPWR VPWR sky130_fd_sc_hd__decap_3
XFILLER_38_1435 VGND VGND VPWR VPWR sky130_fd_sc_hd__decap_3
XFILLER_73_1337 VGND VGND VPWR VPWR sky130_fd_sc_hd__decap_3
XFILLER_12_401 VGND VGND VPWR VPWR sky130_fd_sc_hd__decap_3
XFILLER_52_570 VGND VGND VPWR VPWR sky130_fd_sc_hd__fill_2
XFILLER_13_935 VGND VGND VPWR VPWR sky130_fd_sc_hd__decap_3
XFILLER_52_581 VGND VGND VPWR VPWR sky130_fd_sc_hd__decap_3
XFILLER_73_1348 VGND VGND VPWR VPWR sky130_fd_sc_hd__decap_3
XFILLER_38_1468 VGND VGND VPWR VPWR sky130_fd_sc_hd__fill_1
XFILLER_9_906 VGND VGND VPWR VPWR sky130_fd_sc_hd__decap_3
XFILLER_12_445 VGND VGND VPWR VPWR sky130_fd_sc_hd__decap_3
XFILLER_40_754 VGND VGND VPWR VPWR sky130_fd_sc_hd__fill_2
XFILLER_12_467 VGND VGND VPWR VPWR sky130_fd_sc_hd__decap_3
XFILLER_8_416 VGND VGND VPWR VPWR sky130_fd_sc_hd__decap_3
XPHY_EDGE_ROW_49_Left_130 VGND VGND VPWR VPWR sky130_fd_sc_hd__decap_3
XFILLER_36_1170 VGND VGND VPWR VPWR sky130_fd_sc_hd__decap_3
XFILLER_8_427 VGND VGND VPWR VPWR sky130_fd_sc_hd__decap_3
XFILLER_10_1332 VGND VGND VPWR VPWR sky130_fd_sc_hd__decap_3
XFILLER_4_622 VGND VGND VPWR VPWR sky130_fd_sc_hd__decap_3
XFILLER_10_1365 VGND VGND VPWR VPWR sky130_fd_sc_hd__decap_3
XFILLER_4_655 VGND VGND VPWR VPWR sky130_fd_sc_hd__decap_3
XFILLER_10_1376 VGND VGND VPWR VPWR sky130_fd_sc_hd__decap_3
XFILLER_4_688 VGND VGND VPWR VPWR sky130_fd_sc_hd__fill_1
XFILLER_3_165 VGND VGND VPWR VPWR sky130_fd_sc_hd__decap_3
XTAP_TAPCELL_ROW_37_1153 VGND VPWR sky130_fd_sc_hd__tapvpwrvgnd_1
XFILLER_3_198 VGND VGND VPWR VPWR sky130_fd_sc_hd__decap_3
XTAP_TAPCELL_ROW_37_1164 VGND VPWR sky130_fd_sc_hd__tapvpwrvgnd_1
XFILLER_45_1428 VGND VGND VPWR VPWR sky130_fd_sc_hd__decap_3
XTAP_TAPCELL_ROW_37_1175 VGND VPWR sky130_fd_sc_hd__tapvpwrvgnd_1
XFILLER_79_467 VGND VGND VPWR VPWR sky130_fd_sc_hd__decap_3
XFILLER_0_850 VGND VGND VPWR VPWR sky130_fd_sc_hd__decap_3
XFILLER_58_50 VGND VGND VPWR VPWR sky130_fd_sc_hd__decap_3
XFILLER_0_872 VGND VGND VPWR VPWR sky130_fd_sc_hd__decap_3
XFILLER_43_1174 VGND VGND VPWR VPWR sky130_fd_sc_hd__fill_2
XFILLER_48_865 VGND VGND VPWR VPWR sky130_fd_sc_hd__decap_3
XFILLER_78_1226 VGND VGND VPWR VPWR sky130_fd_sc_hd__decap_3
XFILLER_47_375 VGND VGND VPWR VPWR sky130_fd_sc_hd__fill_1
XFILLER_62_312 VGND VGND VPWR VPWR sky130_fd_sc_hd__fill_1
XFILLER_78_1259 VGND VGND VPWR VPWR sky130_fd_sc_hd__fill_1
XFILLER_74_71 VGND VGND VPWR VPWR sky130_fd_sc_hd__decap_3
XFILLER_35_559 VGND VGND VPWR VPWR sky130_fd_sc_hd__fill_1
XFILLER_22_209 VGND VGND VPWR VPWR sky130_fd_sc_hd__fill_2
XFILLER_15_261 VGND VGND VPWR VPWR sky130_fd_sc_hd__decap_3
XFILLER_16_784 VGND VGND VPWR VPWR sky130_fd_sc_hd__decap_3
XFILLER_31_732 VGND VGND VPWR VPWR sky130_fd_sc_hd__fill_2
XFILLER_15_1210 VGND VGND VPWR VPWR sky130_fd_sc_hd__decap_3
XFILLER_54_1270 VGND VGND VPWR VPWR sky130_fd_sc_hd__decap_3
XFILLER_19_1390 VGND VGND VPWR VPWR sky130_fd_sc_hd__decap_3
X_4610_ _4610_/A _4610_/B VGND VGND VPWR VPWR _4610_/Y sky130_fd_sc_hd__nor2_2
X_5590_ _3082_/X _5578_/Y _5584_/Y _5590_/B2 VGND VGND VPWR VPWR _6663_/D sky130_fd_sc_hd__a22o_2
XFILLER_15_1254 VGND VGND VPWR VPWR sky130_fd_sc_hd__decap_3
X_4541_ _4541_/A _4894_/B VGND VGND VPWR VPWR _4541_/Y sky130_fd_sc_hd__nor2_2
XFILLER_15_1287 VGND VGND VPWR VPWR sky130_fd_sc_hd__fill_1
XFILLER_11_1129 VGND VGND VPWR VPWR sky130_fd_sc_hd__decap_3
XFILLER_15_1298 VGND VGND VPWR VPWR sky130_fd_sc_hd__decap_3
X_4472_ _6285_/Q wire63/X _4469_/X _4471_/X VGND VGND VPWR VPWR _6285_/D sky130_fd_sc_hd__o22a_2
XFILLER_7_482 VGND VGND VPWR VPWR sky130_fd_sc_hd__decap_3
Xmax_cap146 _4328_/A VGND VGND VPWR VPWR _4249_/A sky130_fd_sc_hd__buf_2
X_6211_ _7063_/CLK _6211_/D fanout770/X VGND VGND VPWR VPWR _6211_/Q sky130_fd_sc_hd__dfrtp_2
X_3423_ hold948/X _3422_/X _3423_/S VGND VGND VPWR VPWR _6185_/D sky130_fd_sc_hd__mux2_1
Xmax_cap168 _4169_/S VGND VGND VPWR VPWR _4265_/B sky130_fd_sc_hd__buf_6
X_6142_ _6993_/CLK _6142_/D load_slew710/X VGND VGND VPWR VPWR _6142_/Q sky130_fd_sc_hd__dfrtp_2
X_3354_ _6296_/Q _6408_/Q VGND VGND VPWR VPWR _3354_/X sky130_fd_sc_hd__xor2_2
Xload_slew330 _5566_/B2 VGND VGND VPWR VPWR _5567_/B sky130_fd_sc_hd__buf_4
XFILLER_6_1400 VGND VGND VPWR VPWR sky130_fd_sc_hd__decap_3
Xload_slew341 _5517_/A3 VGND VGND VPWR VPWR _4777_/A sky130_fd_sc_hd__clkbuf_4
X_6073_ _7094_/D _6073_/B _7111_/A _6073_/D VGND VGND VPWR VPWR _6081_/C sky130_fd_sc_hd__and4_2
XFILLER_26_1350 VGND VGND VPWR VPWR sky130_fd_sc_hd__decap_3
Xhold1105 _6188_/Q VGND VGND VPWR VPWR _6035_/A0 sky130_fd_sc_hd__dlygate4sd3_1
X_3285_ hold955/X _3284_/X _3429_/S VGND VGND VPWR VPWR _6116_/D sky130_fd_sc_hd__mux2_1
Xhold1116 _6049_/X VGND VGND VPWR VPWR _7053_/D sky130_fd_sc_hd__dlygate4sd3_1
Xload_slew385 _4086_/A2 VGND VGND VPWR VPWR _4583_/B2 sky130_fd_sc_hd__clkbuf_4
XFILLER_6_1444 VGND VGND VPWR VPWR sky130_fd_sc_hd__decap_3
X_5024_ _6393_/Q _5249_/B _5031_/B1 VGND VGND VPWR VPWR _5024_/Y sky130_fd_sc_hd__a21oi_2
Xhold1127 _6955_/Q VGND VGND VPWR VPWR _5951_/A1 sky130_fd_sc_hd__dlygate4sd3_1
Xload_slew396 fanout395/X VGND VGND VPWR VPWR _4757_/B2 sky130_fd_sc_hd__buf_6
XFILLER_57_139 VGND VGND VPWR VPWR sky130_fd_sc_hd__decap_3
Xhold1138 _6715_/Q VGND VGND VPWR VPWR _5660_/A1 sky130_fd_sc_hd__dlygate4sd3_1
XFILLER_61_1263 VGND VGND VPWR VPWR sky130_fd_sc_hd__decap_3
XFILLER_26_1394 VGND VGND VPWR VPWR sky130_fd_sc_hd__decap_3
Xhold1149 _7040_/Q VGND VGND VPWR VPWR _6036_/A1 sky130_fd_sc_hd__dlygate4sd3_1
XFILLER_22_1236 VGND VGND VPWR VPWR sky130_fd_sc_hd__decap_3
XFILLER_54_813 VGND VGND VPWR VPWR sky130_fd_sc_hd__decap_3
XFILLER_53_301 VGND VGND VPWR VPWR sky130_fd_sc_hd__decap_3
XFILLER_65_161 VGND VGND VPWR VPWR sky130_fd_sc_hd__decap_3
XFILLER_0_1021 VGND VGND VPWR VPWR sky130_fd_sc_hd__decap_3
XFILLER_53_345 VGND VGND VPWR VPWR sky130_fd_sc_hd__decap_3
XTAP_TAPCELL_ROW_0_168 VGND VPWR sky130_fd_sc_hd__tapvpwrvgnd_1
XFILLER_0_1043 VGND VGND VPWR VPWR sky130_fd_sc_hd__decap_3
X_6975_ _7007_/CLK _6975_/D fanout820/X VGND VGND VPWR VPWR _6975_/Q sky130_fd_sc_hd__dfrtp_2
XTAP_TAPCELL_ROW_0_179 VGND VPWR sky130_fd_sc_hd__tapvpwrvgnd_1
XFILLER_55_1001 VGND VGND VPWR VPWR sky130_fd_sc_hd__decap_3
XFILLER_0_1065 VGND VGND VPWR VPWR sky130_fd_sc_hd__decap_3
X_5926_ _5789_/C _5926_/A1 _5932_/S VGND VGND VPWR VPWR _6931_/D sky130_fd_sc_hd__mux2_1
XFILLER_55_1012 VGND VGND VPWR VPWR sky130_fd_sc_hd__decap_3
XFILLER_59_1192 VGND VGND VPWR VPWR sky130_fd_sc_hd__fill_1
XFILLER_62_890 VGND VGND VPWR VPWR sky130_fd_sc_hd__decap_3
XFILLER_80_197 VGND VGND VPWR VPWR sky130_fd_sc_hd__decap_3
XFILLER_34_592 VGND VGND VPWR VPWR sky130_fd_sc_hd__fill_1
X_5857_ _5857_/A0 _5904_/A0 wire97/X VGND VGND VPWR VPWR _6872_/D sky130_fd_sc_hd__mux2_1
XFILLER_70_18 VGND VGND VPWR VPWR sky130_fd_sc_hd__decap_3
XFILLER_21_242 VGND VGND VPWR VPWR sky130_fd_sc_hd__decap_3
XFILLER_70_29 VGND VGND VPWR VPWR sky130_fd_sc_hd__decap_3
XFILLER_33_1310 VGND VGND VPWR VPWR sky130_fd_sc_hd__decap_3
X_4808_ _4829_/A _4808_/B VGND VGND VPWR VPWR _4808_/Y sky130_fd_sc_hd__nor2_2
XFILLER_22_798 VGND VGND VPWR VPWR sky130_fd_sc_hd__fill_2
X_5788_ _5788_/A1 _5783_/X _5784_/X _5841_/C VGND VGND VPWR VPWR _6818_/D sky130_fd_sc_hd__a22o_2
XFILLER_33_1343 VGND VGND VPWR VPWR sky130_fd_sc_hd__fill_1
XFILLER_33_1354 VGND VGND VPWR VPWR sky130_fd_sc_hd__decap_3
XFILLER_5_408 VGND VGND VPWR VPWR sky130_fd_sc_hd__decap_3
X_4739_ _6570_/Q _4723_/X _4741_/C1 VGND VGND VPWR VPWR _4739_/X sky130_fd_sc_hd__a21o_2
XFILLER_33_1387 VGND VGND VPWR VPWR sky130_fd_sc_hd__decap_3
XFILLER_68_1406 VGND VGND VPWR VPWR sky130_fd_sc_hd__decap_3
XFILLER_79_27 VGND VGND VPWR VPWR sky130_fd_sc_hd__decap_3
XTAP_TAPCELL_ROW_77_2190 VGND VPWR sky130_fd_sc_hd__tapvpwrvgnd_1
X_6409_ _7027_/CLK _6409_/D load_slew845/X VGND VGND VPWR VPWR _6409_/Q sky130_fd_sc_hd__dfrtp_2
Xhold950 _6683_/Q VGND VGND VPWR VPWR hold950/X sky130_fd_sc_hd__dlygate4sd3_1
Xhold961 _6157_/Q VGND VGND VPWR VPWR hold961/X sky130_fd_sc_hd__dlygate4sd3_1
Xhold972 _7031_/Q VGND VGND VPWR VPWR hold972/X sky130_fd_sc_hd__dlygate4sd3_1
XTAP_TAPCELL_ROW_73_2087 VGND VPWR sky130_fd_sc_hd__tapvpwrvgnd_1
XFILLER_0_113 VGND VGND VPWR VPWR sky130_fd_sc_hd__decap_3
Xhold983 _6005_/X VGND VGND VPWR VPWR _7009_/D sky130_fd_sc_hd__dlygate4sd3_1
XTAP_TAPCELL_ROW_73_2098 VGND VPWR sky130_fd_sc_hd__tapvpwrvgnd_1
Xhold994 _6190_/Q VGND VGND VPWR VPWR hold994/X sky130_fd_sc_hd__dlygate4sd3_1
XFILLER_66_1174 VGND VGND VPWR VPWR sky130_fd_sc_hd__decap_3
XFILLER_1_669 VGND VGND VPWR VPWR sky130_fd_sc_hd__decap_3
XFILLER_49_607 VGND VGND VPWR VPWR sky130_fd_sc_hd__fill_1
XFILLER_7_1219 VGND VGND VPWR VPWR sky130_fd_sc_hd__decap_3
XFILLER_76_404 VGND VGND VPWR VPWR sky130_fd_sc_hd__decap_3
XFILLER_48_106 VGND VGND VPWR VPWR sky130_fd_sc_hd__decap_3
XFILLER_44_1450 VGND VGND VPWR VPWR sky130_fd_sc_hd__decap_3
XFILLER_40_1303 VGND VGND VPWR VPWR sky130_fd_sc_hd__decap_3
XFILLER_29_320 VGND VGND VPWR VPWR sky130_fd_sc_hd__decap_3
XFILLER_29_353 VGND VGND VPWR VPWR sky130_fd_sc_hd__decap_3
XFILLER_40_1347 VGND VGND VPWR VPWR sky130_fd_sc_hd__decap_3
XFILLER_57_684 VGND VGND VPWR VPWR sky130_fd_sc_hd__decap_3
XFILLER_44_345 VGND VGND VPWR VPWR sky130_fd_sc_hd__decap_3
XFILLER_72_687 VGND VGND VPWR VPWR sky130_fd_sc_hd__decap_3
XFILLER_60_827 VGND VGND VPWR VPWR sky130_fd_sc_hd__decap_3
XFILLER_77_1281 VGND VGND VPWR VPWR sky130_fd_sc_hd__decap_3
XFILLER_71_175 VGND VGND VPWR VPWR sky130_fd_sc_hd__decap_3
XFILLER_25_570 VGND VGND VPWR VPWR sky130_fd_sc_hd__decap_3
XFILLER_77_1292 VGND VGND VPWR VPWR sky130_fd_sc_hd__decap_3
XFILLER_38_1254 VGND VGND VPWR VPWR sky130_fd_sc_hd__decap_3
XFILLER_73_1145 VGND VGND VPWR VPWR sky130_fd_sc_hd__decap_3
XFILLER_44_85 VGND VGND VPWR VPWR sky130_fd_sc_hd__decap_3
XFILLER_13_754 VGND VGND VPWR VPWR sky130_fd_sc_hd__fill_1
XFILLER_38_1276 VGND VGND VPWR VPWR sky130_fd_sc_hd__decap_3
XFILLER_9_725 VGND VGND VPWR VPWR sky130_fd_sc_hd__decap_3
XFILLER_73_1189 VGND VGND VPWR VPWR sky130_fd_sc_hd__decap_3
XFILLER_51_1410 VGND VGND VPWR VPWR sky130_fd_sc_hd__decap_3
XFILLER_12_275 VGND VGND VPWR VPWR sky130_fd_sc_hd__decap_3
XTAP_TAPCELL_ROW_23_793 VGND VPWR sky130_fd_sc_hd__tapvpwrvgnd_1
XFILLER_51_1443 VGND VGND VPWR VPWR sky130_fd_sc_hd__decap_3
XFILLER_12_1427 VGND VGND VPWR VPWR sky130_fd_sc_hd__fill_1
XFILLER_12_1438 VGND VGND VPWR VPWR sky130_fd_sc_hd__decap_3
XTAP_TAPCELL_ROW_10_454 VGND VPWR sky130_fd_sc_hd__tapvpwrvgnd_1
XFILLER_67_9 VGND VGND VPWR VPWR sky130_fd_sc_hd__decap_3
XTAP_TAPCELL_ROW_10_465 VGND VPWR sky130_fd_sc_hd__tapvpwrvgnd_1
XTAP_TAPCELL_ROW_39_1204 VGND VPWR sky130_fd_sc_hd__tapvpwrvgnd_1
XTAP_TAPCELL_ROW_39_1215 VGND VPWR sky130_fd_sc_hd__tapvpwrvgnd_1
XFILLER_5_24 VGND VGND VPWR VPWR sky130_fd_sc_hd__decap_3
XTAP_TAPCELL_ROW_39_1226 VGND VPWR sky130_fd_sc_hd__tapvpwrvgnd_1
XFILLER_5_975 VGND VGND VPWR VPWR sky130_fd_sc_hd__fill_1
XFILLER_4_452 VGND VGND VPWR VPWR sky130_fd_sc_hd__decap_3
XFILLER_5_57 VGND VGND VPWR VPWR sky130_fd_sc_hd__decap_3
XFILLER_10_1173 VGND VGND VPWR VPWR sky130_fd_sc_hd__decap_3
XFILLER_4_485 VGND VGND VPWR VPWR sky130_fd_sc_hd__decap_3
XFILLER_49_1372 VGND VGND VPWR VPWR sky130_fd_sc_hd__decap_3
XFILLER_69_60 VGND VGND VPWR VPWR sky130_fd_sc_hd__fill_1
XFILLER_80_1105 VGND VGND VPWR VPWR sky130_fd_sc_hd__decap_3
XFILLER_45_1236 VGND VGND VPWR VPWR sky130_fd_sc_hd__decap_3
XFILLER_80_1127 VGND VGND VPWR VPWR sky130_fd_sc_hd__decap_3
XFILLER_80_1149 VGND VGND VPWR VPWR sky130_fd_sc_hd__decap_3
XFILLER_45_1269 VGND VGND VPWR VPWR sky130_fd_sc_hd__decap_3
X_3070_ _6366_/Q VGND VGND VPWR VPWR _3070_/Y sky130_fd_sc_hd__inv_2
XFILLER_0_691 VGND VGND VPWR VPWR sky130_fd_sc_hd__decap_3
XFILLER_36_813 VGND VGND VPWR VPWR sky130_fd_sc_hd__fill_1
XFILLER_75_481 VGND VGND VPWR VPWR sky130_fd_sc_hd__decap_3
XFILLER_35_312 VGND VGND VPWR VPWR sky130_fd_sc_hd__decap_3
XFILLER_47_172 VGND VGND VPWR VPWR sky130_fd_sc_hd__fill_2
XFILLER_35_334 VGND VGND VPWR VPWR sky130_fd_sc_hd__fill_2
XTAP_TAPCELL_ROW_69_1989 VGND VPWR sky130_fd_sc_hd__tapvpwrvgnd_1
XFILLER_78_1067 VGND VGND VPWR VPWR sky130_fd_sc_hd__decap_3
XFILLER_1_1363 VGND VGND VPWR VPWR sky130_fd_sc_hd__decap_3
XFILLER_39_1029 VGND VGND VPWR VPWR sky130_fd_sc_hd__fill_1
X_6760_ _7048_/CLK _6760_/D wire655/X VGND VGND VPWR VPWR _6760_/Q sky130_fd_sc_hd__dfrtp_2
XFILLER_35_389 VGND VGND VPWR VPWR sky130_fd_sc_hd__decap_3
XFILLER_51_838 VGND VGND VPWR VPWR sky130_fd_sc_hd__fill_2
XFILLER_1_1396 VGND VGND VPWR VPWR sky130_fd_sc_hd__decap_3
XFILLER_56_1332 VGND VGND VPWR VPWR sky130_fd_sc_hd__decap_3
X_3972_ _4088_/A1 wire154/X _5605_/A3 _3958_/Y _6530_/Q VGND VGND VPWR VPWR _3972_/X
+ sky130_fd_sc_hd__a32o_2
XFILLER_62_197 VGND VGND VPWR VPWR sky130_fd_sc_hd__decap_3
X_5711_ input8/X _5711_/A1 wire89/X VGND VGND VPWR VPWR _6760_/D sky130_fd_sc_hd__mux2_1
XFILLER_17_1316 VGND VGND VPWR VPWR sky130_fd_sc_hd__decap_3
XFILLER_56_1365 VGND VGND VPWR VPWR sky130_fd_sc_hd__decap_3
XFILLER_56_1376 VGND VGND VPWR VPWR sky130_fd_sc_hd__decap_3
X_6691_ _7019_/CLK _6691_/D fanout838/X VGND VGND VPWR VPWR _6691_/Q sky130_fd_sc_hd__dfrtp_2
XFILLER_31_573 VGND VGND VPWR VPWR sky130_fd_sc_hd__fill_1
X_5642_ _5908_/A0 _5642_/A1 wire92/X VGND VGND VPWR VPWR _6699_/D sky130_fd_sc_hd__mux2_1
XFILLER_15_1040 VGND VGND VPWR VPWR sky130_fd_sc_hd__decap_3
X_5573_ _5573_/A1 _5568_/Y _5572_/Y _5574_/A2 VGND VGND VPWR VPWR _6651_/D sky130_fd_sc_hd__a22o_2
XFILLER_15_1084 VGND VGND VPWR VPWR sky130_fd_sc_hd__fill_1
X_4524_ _3889_/A _3889_/B _4562_/C _4665_/B _4394_/A VGND VGND VPWR VPWR _4524_/X
+ sky130_fd_sc_hd__o2111a_2
XFILLER_7_290 VGND VGND VPWR VPWR sky130_fd_sc_hd__decap_3
X_4455_ _4831_/A1 _4452_/X _4453_/Y _4454_/X _4831_/C1 VGND VGND VPWR VPWR _4455_/X
+ sky130_fd_sc_hd__o221a_2
XFILLER_28_1412 VGND VGND VPWR VPWR sky130_fd_sc_hd__decap_3
X_3406_ _6234_/Q _6434_/Q VGND VGND VPWR VPWR _3406_/X sky130_fd_sc_hd__xor2_2
Xfanout704 fanout713/X VGND VGND VPWR VPWR fanout704/X sky130_fd_sc_hd__clkdlybuf4s25_1
X_4386_ _4386_/A _4420_/B _4420_/C _5588_/A3 VGND VGND VPWR VPWR _4386_/X sky130_fd_sc_hd__or4b_2
XFILLER_63_1325 VGND VGND VPWR VPWR sky130_fd_sc_hd__decap_3
XFILLER_28_1456 VGND VGND VPWR VPWR sky130_fd_sc_hd__decap_3
Xfanout737 fanout739/X VGND VGND VPWR VPWR wire738/A sky130_fd_sc_hd__clkdlybuf4s25_1
X_3337_ hold930/X _3336_/X _3401_/S VGND VGND VPWR VPWR _6142_/D sky130_fd_sc_hd__mux2_1
XFILLER_24_1309 VGND VGND VPWR VPWR sky130_fd_sc_hd__decap_3
X_6125_ _7072_/CLK _6125_/D wire687/X VGND VGND VPWR VPWR _6125_/Q sky130_fd_sc_hd__dfrtp_2
XFILLER_58_404 VGND VGND VPWR VPWR sky130_fd_sc_hd__decap_3
XFILLER_59_938 VGND VGND VPWR VPWR sky130_fd_sc_hd__fill_1
Xfanout759 fanout759/A VGND VGND VPWR VPWR fanout759/X sky130_fd_sc_hd__clkdlybuf4s25_1
XFILLER_63_1369 VGND VGND VPWR VPWR sky130_fd_sc_hd__decap_3
Xload_slew160 wire159/A VGND VGND VPWR VPWR _5781_/S sky130_fd_sc_hd__buf_4
XFILLER_74_908 VGND VGND VPWR VPWR sky130_fd_sc_hd__decap_3
X_6056_ hold923/X hold992/X _6058_/S VGND VGND VPWR VPWR _7060_/D sky130_fd_sc_hd__mux2_1
Xload_slew193 fanout192/X VGND VGND VPWR VPWR _3477_/S sky130_fd_sc_hd__clkbuf_4
XFILLER_6_1241 VGND VGND VPWR VPWR sky130_fd_sc_hd__decap_3
XFILLER_22_1011 VGND VGND VPWR VPWR sky130_fd_sc_hd__decap_3
X_3268_ _6269_/Q _6365_/Q VGND VGND VPWR VPWR _3268_/X sky130_fd_sc_hd__xor2_2
XFILLER_65_18 VGND VGND VPWR VPWR sky130_fd_sc_hd__decap_3
XFILLER_26_1191 VGND VGND VPWR VPWR sky130_fd_sc_hd__decap_3
XFILLER_2_1105 VGND VGND VPWR VPWR sky130_fd_sc_hd__decap_3
X_5007_ _6455_/Q _6673_/Q VGND VGND VPWR VPWR _5008_/B sky130_fd_sc_hd__xor2_2
XFILLER_39_673 VGND VGND VPWR VPWR sky130_fd_sc_hd__decap_3
XFILLER_45_109 VGND VGND VPWR VPWR sky130_fd_sc_hd__decap_3
XFILLER_61_1093 VGND VGND VPWR VPWR sky130_fd_sc_hd__fill_2
XFILLER_6_1285 VGND VGND VPWR VPWR sky130_fd_sc_hd__decap_3
XFILLER_22_1055 VGND VGND VPWR VPWR sky130_fd_sc_hd__decap_3
XFILLER_26_301 VGND VGND VPWR VPWR sky130_fd_sc_hd__decap_3
XFILLER_67_993 VGND VGND VPWR VPWR sky130_fd_sc_hd__decap_3
X_3199_ _3213_/A1 _3197_/X _3198_/X _3213_/C1 VGND VGND VPWR VPWR _3202_/B sky130_fd_sc_hd__a211o_2
XFILLER_2_1138 VGND VGND VPWR VPWR sky130_fd_sc_hd__decap_3
XFILLER_2_1149 VGND VGND VPWR VPWR sky130_fd_sc_hd__decap_3
XFILLER_66_492 VGND VGND VPWR VPWR sky130_fd_sc_hd__fill_2
XFILLER_54_643 VGND VGND VPWR VPWR sky130_fd_sc_hd__fill_1
XFILLER_53_131 VGND VGND VPWR VPWR sky130_fd_sc_hd__decap_3
XFILLER_14_507 VGND VGND VPWR VPWR sky130_fd_sc_hd__decap_3
XFILLER_42_816 VGND VGND VPWR VPWR sky130_fd_sc_hd__decap_3
XFILLER_57_1118 VGND VGND VPWR VPWR sky130_fd_sc_hd__fill_2
XFILLER_53_164 VGND VGND VPWR VPWR sky130_fd_sc_hd__decap_3
XFILLER_74_1421 VGND VGND VPWR VPWR sky130_fd_sc_hd__decap_3
XFILLER_41_315 VGND VGND VPWR VPWR sky130_fd_sc_hd__decap_3
XFILLER_74_1432 VGND VGND VPWR VPWR sky130_fd_sc_hd__decap_3
X_6958_ _6958_/CLK _6958_/D fanout761/X VGND VGND VPWR VPWR _6958_/Q sky130_fd_sc_hd__dfrtp_2
XFILLER_41_337 VGND VGND VPWR VPWR sky130_fd_sc_hd__decap_3
XFILLER_74_1465 VGND VGND VPWR VPWR sky130_fd_sc_hd__decap_3
X_5909_ _5909_/A0 _5909_/A1 _5914_/S VGND VGND VPWR VPWR _6916_/D sky130_fd_sc_hd__mux2_1
XFILLER_35_1416 VGND VGND VPWR VPWR sky130_fd_sc_hd__decap_3
X_6889_ _6889_/CLK _6889_/D fanout749/X VGND VGND VPWR VPWR _6889_/Q sky130_fd_sc_hd__dfrtp_2
XFILLER_70_1329 VGND VGND VPWR VPWR sky130_fd_sc_hd__decap_3
XFILLER_14_44 VGND VGND VPWR VPWR sky130_fd_sc_hd__decap_3
XFILLER_35_1449 VGND VGND VPWR VPWR sky130_fd_sc_hd__decap_3
XFILLER_22_584 VGND VGND VPWR VPWR sky130_fd_sc_hd__decap_3
XTAP_TAPCELL_ROW_79_2252 VGND VPWR sky130_fd_sc_hd__tapvpwrvgnd_1
XTAP_TAPCELL_ROW_20_730 VGND VPWR sky130_fd_sc_hd__tapvpwrvgnd_1
XTAP_TAPCELL_ROW_79_2263 VGND VPWR sky130_fd_sc_hd__tapvpwrvgnd_1
XFILLER_6_739 VGND VGND VPWR VPWR sky130_fd_sc_hd__decap_3
XFILLER_33_1195 VGND VGND VPWR VPWR sky130_fd_sc_hd__decap_3
XTAP_TAPCELL_ROW_75_2138 VGND VPWR sky130_fd_sc_hd__tapvpwrvgnd_1
XTAP_TAPCELL_ROW_75_2149 VGND VPWR sky130_fd_sc_hd__tapvpwrvgnd_1
XFILLER_68_1214 VGND VGND VPWR VPWR sky130_fd_sc_hd__decap_3
XFILLER_11_1460 VGND VGND VPWR VPWR sky130_fd_sc_hd__decap_3
XFILLER_68_1247 VGND VGND VPWR VPWR sky130_fd_sc_hd__decap_3
XFILLER_2_923 VGND VGND VPWR VPWR sky130_fd_sc_hd__fill_1
XFILLER_2_934 VGND VGND VPWR VPWR sky130_fd_sc_hd__decap_3
XFILLER_1_411 VGND VGND VPWR VPWR sky130_fd_sc_hd__decap_3
XFILLER_2_967 VGND VGND VPWR VPWR sky130_fd_sc_hd__decap_3
XFILLER_1_455 VGND VGND VPWR VPWR sky130_fd_sc_hd__decap_3
XFILLER_42_1409 VGND VGND VPWR VPWR sky130_fd_sc_hd__decap_3
XFILLER_77_746 VGND VGND VPWR VPWR sky130_fd_sc_hd__decap_3
XFILLER_44_1291 VGND VGND VPWR VPWR sky130_fd_sc_hd__decap_3
XFILLER_79_1310 VGND VGND VPWR VPWR sky130_fd_sc_hd__decap_3
XFILLER_18_813 VGND VGND VPWR VPWR sky130_fd_sc_hd__decap_3
XTAP_TAPCELL_ROW_4_293 VGND VPWR sky130_fd_sc_hd__tapvpwrvgnd_1
XFILLER_79_1343 VGND VGND VPWR VPWR sky130_fd_sc_hd__fill_1
XFILLER_18_846 VGND VGND VPWR VPWR sky130_fd_sc_hd__decap_3
Xhold1480 _6567_/Q VGND VGND VPWR VPWR _5455_/A1 sky130_fd_sc_hd__dlygate4sd3_1
XFILLER_79_1354 VGND VGND VPWR VPWR sky130_fd_sc_hd__decap_3
XFILLER_17_334 VGND VGND VPWR VPWR sky130_fd_sc_hd__fill_2
Xhold1491 _6499_/Q VGND VGND VPWR VPWR _5387_/A1 sky130_fd_sc_hd__dlygate4sd3_1
XFILLER_40_1188 VGND VGND VPWR VPWR sky130_fd_sc_hd__fill_2
XFILLER_55_51 VGND VGND VPWR VPWR sky130_fd_sc_hd__decap_3
XFILLER_75_1207 VGND VGND VPWR VPWR sky130_fd_sc_hd__decap_3
XFILLER_79_1387 VGND VGND VPWR VPWR sky130_fd_sc_hd__decap_3
XFILLER_17_389 VGND VGND VPWR VPWR sky130_fd_sc_hd__decap_3
XFILLER_38_1040 VGND VGND VPWR VPWR sky130_fd_sc_hd__decap_3
XFILLER_44_197 VGND VGND VPWR VPWR sky130_fd_sc_hd__decap_3
XTAP_TAPCELL_ROW_64_1853 VGND VPWR sky130_fd_sc_hd__tapvpwrvgnd_1
XTAP_TAPCELL_ROW_64_1864 VGND VPWR sky130_fd_sc_hd__tapvpwrvgnd_1
XTAP_TAPCELL_ROW_64_1875 VGND VPWR sky130_fd_sc_hd__tapvpwrvgnd_1
XFILLER_13_551 VGND VGND VPWR VPWR sky130_fd_sc_hd__decap_3
XTAP_TAPCELL_ROW_15_579 VGND VPWR sky130_fd_sc_hd__tapvpwrvgnd_1
XFILLER_9_511 VGND VGND VPWR VPWR sky130_fd_sc_hd__decap_3
XFILLER_13_573 VGND VGND VPWR VPWR sky130_fd_sc_hd__decap_3
XFILLER_71_83 VGND VGND VPWR VPWR sky130_fd_sc_hd__decap_3
XFILLER_9_566 VGND VGND VPWR VPWR sky130_fd_sc_hd__decap_3
XFILLER_16_1371 VGND VGND VPWR VPWR sky130_fd_sc_hd__fill_1
XFILLER_51_1251 VGND VGND VPWR VPWR sky130_fd_sc_hd__decap_3
XFILLER_16_1382 VGND VGND VPWR VPWR sky130_fd_sc_hd__decap_3
XFILLER_12_1235 VGND VGND VPWR VPWR sky130_fd_sc_hd__decap_3
XFILLER_51_1284 VGND VGND VPWR VPWR sky130_fd_sc_hd__decap_3
XFILLER_51_1295 VGND VGND VPWR VPWR sky130_fd_sc_hd__decap_3
XFILLER_65_6 VGND VGND VPWR VPWR sky130_fd_sc_hd__decap_3
XFILLER_12_1279 VGND VGND VPWR VPWR sky130_fd_sc_hd__decap_3
X_4240_ _4240_/A _4240_/B VGND VGND VPWR VPWR _4241_/B sky130_fd_sc_hd__xor2_2
X_4171_ _4348_/A _4171_/B VGND VGND VPWR VPWR _4172_/B sky130_fd_sc_hd__xor2_2
X_3122_ _6938_/Q _6081_/B _6076_/A1 _3113_/X _3205_/B1 VGND VGND VPWR VPWR _3123_/C
+ sky130_fd_sc_hd__a221o_2
XFILLER_67_245 VGND VGND VPWR VPWR sky130_fd_sc_hd__decap_3
XFILLER_23_1331 VGND VGND VPWR VPWR sky130_fd_sc_hd__decap_3
XFILLER_62_1391 VGND VGND VPWR VPWR sky130_fd_sc_hd__decap_3
XFILLER_55_418 VGND VGND VPWR VPWR sky130_fd_sc_hd__decap_3
XFILLER_3_1425 VGND VGND VPWR VPWR sky130_fd_sc_hd__decap_3
X_3053_ _6349_/Q VGND VGND VPWR VPWR _3053_/Y sky130_fd_sc_hd__inv_2
XFILLER_76_790 VGND VGND VPWR VPWR sky130_fd_sc_hd__fill_2
XFILLER_23_1375 VGND VGND VPWR VPWR sky130_fd_sc_hd__decap_3
XFILLER_35_131 VGND VGND VPWR VPWR sky130_fd_sc_hd__decap_3
XFILLER_36_665 VGND VGND VPWR VPWR sky130_fd_sc_hd__decap_3
XFILLER_58_1427 VGND VGND VPWR VPWR sky130_fd_sc_hd__fill_1
XFILLER_36_676 VGND VGND VPWR VPWR sky130_fd_sc_hd__decap_3
XFILLER_51_602 VGND VGND VPWR VPWR sky130_fd_sc_hd__decap_3
XFILLER_58_1438 VGND VGND VPWR VPWR sky130_fd_sc_hd__decap_3
XFILLER_63_462 VGND VGND VPWR VPWR sky130_fd_sc_hd__fill_2
XFILLER_1_1160 VGND VGND VPWR VPWR sky130_fd_sc_hd__decap_3
X_6812_ _6943_/CLK _6812_/D fanout823/X VGND VGND VPWR VPWR _6812_/Q sky130_fd_sc_hd__dfrtp_2
XFILLER_35_186 VGND VGND VPWR VPWR sky130_fd_sc_hd__decap_3
XFILLER_23_337 VGND VGND VPWR VPWR sky130_fd_sc_hd__decap_3
XFILLER_56_1140 VGND VGND VPWR VPWR sky130_fd_sc_hd__decap_3
X_6743_ _6807_/CLK _6743_/D fanout824/X VGND VGND VPWR VPWR _6743_/Q sky130_fd_sc_hd__dfrtp_2
X_3955_ _3288_/X _4056_/A2 _4263_/A2 _6841_/Q _4104_/C1 VGND VGND VPWR VPWR _3955_/X
+ sky130_fd_sc_hd__a221o_2
XFILLER_52_1004 VGND VGND VPWR VPWR sky130_fd_sc_hd__decap_3
XFILLER_56_1173 VGND VGND VPWR VPWR sky130_fd_sc_hd__decap_3
XFILLER_52_1037 VGND VGND VPWR VPWR sky130_fd_sc_hd__decap_3
X_6674_ _6858_/CLK _6674_/D load_slew662/X VGND VGND VPWR VPWR _6674_/Q sky130_fd_sc_hd__dfrtp_2
X_3886_ _3886_/A _3886_/B VGND VGND VPWR VPWR _3888_/C sky130_fd_sc_hd__xnor2_2
X_5625_ hold877/X _5664_/A0 _5627_/S VGND VGND VPWR VPWR _6687_/D sky130_fd_sc_hd__mux2_1
XFILLER_30_1335 VGND VGND VPWR VPWR sky130_fd_sc_hd__decap_3
X_5556_ _6357_/Q _5564_/A2 _5556_/B1 _5564_/B2 VGND VGND VPWR VPWR _6639_/D sky130_fd_sc_hd__a22o_2
XFILLER_3_709 VGND VGND VPWR VPWR sky130_fd_sc_hd__decap_3
XFILLER_30_1368 VGND VGND VPWR VPWR sky130_fd_sc_hd__decap_3
XFILLER_30_1379 VGND VGND VPWR VPWR sky130_fd_sc_hd__decap_3
X_4507_ _6266_/Q _4861_/A2 _3326_/X _4861_/B2 VGND VGND VPWR VPWR _4507_/X sky130_fd_sc_hd__a22o_2
X_5487_ _5487_/A1 _5487_/A2 _4103_/X VGND VGND VPWR VPWR _6599_/D sky130_fd_sc_hd__a21o_2
XTAP_TAPCELL_ROW_70_2013 VGND VPWR sky130_fd_sc_hd__tapvpwrvgnd_1
XTAP_TAPCELL_ROW_70_2024 VGND VPWR sky130_fd_sc_hd__tapvpwrvgnd_1
X_4438_ _4438_/A _4617_/B VGND VGND VPWR VPWR _4438_/Y sky130_fd_sc_hd__nor2_2
XFILLER_28_1231 VGND VGND VPWR VPWR sky130_fd_sc_hd__decap_3
XFILLER_8_1303 VGND VGND VPWR VPWR sky130_fd_sc_hd__decap_3
Xfanout523 _5348_/S VGND VGND VPWR VPWR _5178_/B sky130_fd_sc_hd__clkdlybuf4s25_1
XFILLER_28_1264 VGND VGND VPWR VPWR sky130_fd_sc_hd__decap_3
X_4369_ _4394_/A _4369_/B _4842_/B wire23/X VGND VGND VPWR VPWR _4369_/X sky130_fd_sc_hd__or4b_2
XFILLER_8_1347 VGND VGND VPWR VPWR sky130_fd_sc_hd__decap_3
Xfanout556 _3203_/S VGND VGND VPWR VPWR _3206_/S sky130_fd_sc_hd__clkdlybuf4s25_1
XFILLER_63_1177 VGND VGND VPWR VPWR sky130_fd_sc_hd__decap_3
X_6108_ _6959_/CLK _6108_/D load_slew799/X VGND VGND VPWR VPWR _6108_/Q sky130_fd_sc_hd__dfrtp_2
XFILLER_28_1297 VGND VGND VPWR VPWR sky130_fd_sc_hd__decap_3
Xfanout567 _7071_/Q VGND VGND VPWR VPWR _5879_/A sky130_fd_sc_hd__clkdlybuf4s25_1
XFILLER_24_1139 VGND VGND VPWR VPWR sky130_fd_sc_hd__decap_3
Xfanout578 _6607_/Q VGND VGND VPWR VPWR _4886_/A1 sky130_fd_sc_hd__clkdlybuf4s25_1
Xfanout589 _6605_/Q VGND VGND VPWR VPWR _4394_/A sky130_fd_sc_hd__clkdlybuf4s25_1
XFILLER_59_779 VGND VGND VPWR VPWR sky130_fd_sc_hd__decap_3
X_7088_ _7088_/CLK _7088_/D load_slew769/X VGND VGND VPWR VPWR _7088_/Q sky130_fd_sc_hd__dfrtp_2
XFILLER_41_1431 VGND VGND VPWR VPWR sky130_fd_sc_hd__decap_3
XFILLER_58_267 VGND VGND VPWR VPWR sky130_fd_sc_hd__fill_2
X_6039_ _6039_/A0 _6039_/A1 _6047_/S VGND VGND VPWR VPWR _7043_/D sky130_fd_sc_hd__mux2_1
XFILLER_46_429 VGND VGND VPWR VPWR sky130_fd_sc_hd__decap_3
XFILLER_6_1093 VGND VGND VPWR VPWR sky130_fd_sc_hd__decap_3
XTAP_TAPCELL_ROW_1_230 VGND VPWR sky130_fd_sc_hd__tapvpwrvgnd_1
XFILLER_27_676 VGND VGND VPWR VPWR sky130_fd_sc_hd__fill_2
XFILLER_25_21 VGND VGND VPWR VPWR sky130_fd_sc_hd__decap_3
XFILLER_54_473 VGND VGND VPWR VPWR sky130_fd_sc_hd__decap_3
XFILLER_14_315 VGND VGND VPWR VPWR sky130_fd_sc_hd__decap_3
XFILLER_25_54 VGND VGND VPWR VPWR sky130_fd_sc_hd__fill_2
XFILLER_26_197 VGND VGND VPWR VPWR sky130_fd_sc_hd__decap_3
XTAP_TAPCELL_ROW_25_844 VGND VPWR sky130_fd_sc_hd__tapvpwrvgnd_1
XFILLER_39_1360 VGND VGND VPWR VPWR sky130_fd_sc_hd__decap_3
XFILLER_42_657 VGND VGND VPWR VPWR sky130_fd_sc_hd__decap_3
XTAP_TAPCELL_ROW_25_855 VGND VPWR sky130_fd_sc_hd__tapvpwrvgnd_1
XFILLER_42_679 VGND VGND VPWR VPWR sky130_fd_sc_hd__fill_1
XFILLER_74_1273 VGND VGND VPWR VPWR sky130_fd_sc_hd__decap_3
XFILLER_23_871 VGND VGND VPWR VPWR sky130_fd_sc_hd__decap_3
XFILLER_39_1393 VGND VGND VPWR VPWR sky130_fd_sc_hd__decap_3
XFILLER_41_167 VGND VGND VPWR VPWR sky130_fd_sc_hd__fill_1
XTAP_TAPCELL_ROW_12_505 VGND VPWR sky130_fd_sc_hd__tapvpwrvgnd_1
XFILLER_41_178 VGND VGND VPWR VPWR sky130_fd_sc_hd__decap_3
XFILLER_70_1126 VGND VGND VPWR VPWR sky130_fd_sc_hd__decap_3
XTAP_TAPCELL_ROW_12_516 VGND VPWR sky130_fd_sc_hd__tapvpwrvgnd_1
XFILLER_10_510 VGND VGND VPWR VPWR sky130_fd_sc_hd__decap_3
XFILLER_35_1257 VGND VGND VPWR VPWR sky130_fd_sc_hd__decap_3
XFILLER_10_576 VGND VGND VPWR VPWR sky130_fd_sc_hd__decap_3
XFILLER_6_525 VGND VGND VPWR VPWR sky130_fd_sc_hd__decap_3
XFILLER_6_536 VGND VGND VPWR VPWR sky130_fd_sc_hd__decap_3
XFILLER_2_731 VGND VGND VPWR VPWR sky130_fd_sc_hd__decap_3
XFILLER_68_1088 VGND VGND VPWR VPWR sky130_fd_sc_hd__decap_3
XFILLER_46_1320 VGND VGND VPWR VPWR sky130_fd_sc_hd__decap_3
XTAP_TAPCELL_ROW_57_1690 VGND VPWR sky130_fd_sc_hd__tapvpwrvgnd_1
XFILLER_1_252 VGND VGND VPWR VPWR sky130_fd_sc_hd__decap_3
XFILLER_46_1353 VGND VGND VPWR VPWR sky130_fd_sc_hd__decap_3
XFILLER_2_797 VGND VGND VPWR VPWR sky130_fd_sc_hd__decap_3
XFILLER_77_532 VGND VGND VPWR VPWR sky130_fd_sc_hd__decap_3
XFILLER_1_296 VGND VGND VPWR VPWR sky130_fd_sc_hd__decap_3
XFILLER_46_1397 VGND VGND VPWR VPWR sky130_fd_sc_hd__decap_3
XTAP_TAPCELL_ROW_53_1576 VGND VPWR sky130_fd_sc_hd__tapvpwrvgnd_1
XFILLER_2_47 VGND VGND VPWR VPWR sky130_fd_sc_hd__decap_3
XTAP_TAPCELL_ROW_53_1587 VGND VPWR sky130_fd_sc_hd__tapvpwrvgnd_1
XFILLER_65_727 VGND VGND VPWR VPWR sky130_fd_sc_hd__fill_1
XFILLER_66_50 VGND VGND VPWR VPWR sky130_fd_sc_hd__fill_1
XFILLER_65_738 VGND VGND VPWR VPWR sky130_fd_sc_hd__decap_3
XTAP_TAPCELL_ROW_66_1904 VGND VPWR sky130_fd_sc_hd__tapvpwrvgnd_1
XFILLER_79_1151 VGND VGND VPWR VPWR sky130_fd_sc_hd__decap_3
XFILLER_80_719 VGND VGND VPWR VPWR sky130_fd_sc_hd__decap_3
XTAP_TAPCELL_ROW_66_1915 VGND VPWR sky130_fd_sc_hd__tapvpwrvgnd_1
XFILLER_61_900 VGND VGND VPWR VPWR sky130_fd_sc_hd__decap_3
XTAP_TAPCELL_ROW_66_1926 VGND VPWR sky130_fd_sc_hd__tapvpwrvgnd_1
XFILLER_79_1195 VGND VGND VPWR VPWR sky130_fd_sc_hd__decap_3
XFILLER_75_1026 VGND VGND VPWR VPWR sky130_fd_sc_hd__decap_3
XFILLER_18_1400 VGND VGND VPWR VPWR sky130_fd_sc_hd__decap_3
XFILLER_32_134 VGND VGND VPWR VPWR sky130_fd_sc_hd__decap_3
XFILLER_57_1460 VGND VGND VPWR VPWR sky130_fd_sc_hd__decap_3
XFILLER_33_679 VGND VGND VPWR VPWR sky130_fd_sc_hd__decap_3
XFILLER_53_1313 VGND VGND VPWR VPWR sky130_fd_sc_hd__decap_3
XFILLER_18_1444 VGND VGND VPWR VPWR sky130_fd_sc_hd__decap_3
XANTENNA_19 _5359_/X VGND VGND VPWR VPWR sky130_fd_sc_hd__diode_2
XFILLER_14_893 VGND VGND VPWR VPWR sky130_fd_sc_hd__decap_3
X_3740_ _4269_/A _3740_/B VGND VGND VPWR VPWR _4059_/B sky130_fd_sc_hd__xnor2_2
XFILLER_13_381 VGND VGND VPWR VPWR sky130_fd_sc_hd__decap_3
XFILLER_41_690 VGND VGND VPWR VPWR sky130_fd_sc_hd__decap_3
XFILLER_53_1357 VGND VGND VPWR VPWR sky130_fd_sc_hd__decap_3
X_3671_ _3671_/A _3792_/B VGND VGND VPWR VPWR _3676_/A sky130_fd_sc_hd__nand2_2
XFILLER_9_396 VGND VGND VPWR VPWR sky130_fd_sc_hd__decap_3
X_5410_ _5410_/A1 _5477_/A2 _4506_/X VGND VGND VPWR VPWR _6522_/D sky130_fd_sc_hd__a21o_2
XFILLER_63_3 VGND VGND VPWR VPWR sky130_fd_sc_hd__decap_3
X_6390_ _7048_/CLK _6390_/D wire655/X VGND VGND VPWR VPWR _6390_/Q sky130_fd_sc_hd__dfrtp_2
XFILLER_12_1076 VGND VGND VPWR VPWR sky130_fd_sc_hd__decap_3
X_5341_ _6463_/Q _5340_/X _5341_/S VGND VGND VPWR VPWR _6463_/D sky130_fd_sc_hd__mux2_1
XFILLER_47_1117 VGND VGND VPWR VPWR sky130_fd_sc_hd__decap_3
XFILLER_5_591 VGND VGND VPWR VPWR sky130_fd_sc_hd__decap_3
X_5272_ _6432_/Q _5281_/A2 _5271_/X VGND VGND VPWR VPWR _6432_/D sky130_fd_sc_hd__a21o_2
X_7011_ _7011_/CLK _7011_/D load_slew834/X VGND VGND VPWR VPWR _7011_/Q sky130_fd_sc_hd__dfrtp_2
XFILLER_25_1404 VGND VGND VPWR VPWR sky130_fd_sc_hd__decap_3
X_4223_ _4223_/A _4223_/B VGND VGND VPWR VPWR _4808_/B sky130_fd_sc_hd__xnor2_2
XFILLER_64_1453 VGND VGND VPWR VPWR sky130_fd_sc_hd__decap_3
XFILLER_60_1306 VGND VGND VPWR VPWR sky130_fd_sc_hd__decap_3
XFILLER_25_1437 VGND VGND VPWR VPWR sky130_fd_sc_hd__decap_3
XFILLER_60_1317 VGND VGND VPWR VPWR sky130_fd_sc_hd__decap_3
X_4154_ _4318_/A _4754_/B _4149_/X _3486_/B VGND VGND VPWR VPWR _4154_/X sky130_fd_sc_hd__o2bb2a_2
X_3105_ _3114_/B _3106_/B VGND VGND VPWR VPWR _3105_/X sky130_fd_sc_hd__and2_2
X_4085_ _4381_/C1 _4082_/X _4083_/Y _4084_/X _4582_/A VGND VGND VPWR VPWR _4085_/X
+ sky130_fd_sc_hd__o221a_2
XFILLER_3_1222 VGND VGND VPWR VPWR sky130_fd_sc_hd__decap_3
XFILLER_3_1233 VGND VGND VPWR VPWR sky130_fd_sc_hd__decap_3
XFILLER_3_1266 VGND VGND VPWR VPWR sky130_fd_sc_hd__decap_3
XFILLER_23_1194 VGND VGND VPWR VPWR sky130_fd_sc_hd__decap_3
XFILLER_24_613 VGND VGND VPWR VPWR sky130_fd_sc_hd__fill_1
XFILLER_58_1246 VGND VGND VPWR VPWR sky130_fd_sc_hd__decap_3
XTAP_TAPCELL_ROW_19_682 VGND VPWR sky130_fd_sc_hd__tapvpwrvgnd_1
XTAP_TAPCELL_ROW_19_693 VGND VPWR sky130_fd_sc_hd__tapvpwrvgnd_1
XFILLER_63_281 VGND VGND VPWR VPWR sky130_fd_sc_hd__decap_3
XFILLER_51_432 VGND VGND VPWR VPWR sky130_fd_sc_hd__fill_1
XFILLER_58_1279 VGND VGND VPWR VPWR sky130_fd_sc_hd__decap_3
XFILLER_23_156 VGND VGND VPWR VPWR sky130_fd_sc_hd__decap_3
XFILLER_71_1413 VGND VGND VPWR VPWR sky130_fd_sc_hd__decap_3
X_4987_ _6420_/Q _4987_/B VGND VGND VPWR VPWR _5234_/B sky130_fd_sc_hd__xnor2_2
XFILLER_11_329 VGND VGND VPWR VPWR sky130_fd_sc_hd__decap_3
X_6726_ _6918_/CLK _6726_/D load_slew742/X VGND VGND VPWR VPWR _6726_/Q sky130_fd_sc_hd__dfrtp_2
XFILLER_71_1446 VGND VGND VPWR VPWR sky130_fd_sc_hd__decap_3
X_3938_ _3938_/A _3938_/B VGND VGND VPWR VPWR _5581_/B sky130_fd_sc_hd__xor2_2
XFILLER_71_1457 VGND VGND VPWR VPWR sky130_fd_sc_hd__decap_3
XFILLER_32_690 VGND VGND VPWR VPWR sky130_fd_sc_hd__fill_2
X_6657_ _6905_/CLK _6657_/D wire734/X VGND VGND VPWR VPWR _6657_/Q sky130_fd_sc_hd__dfrtp_2
X_3869_ _4010_/A _6308_/Q VGND VGND VPWR VPWR _3869_/X sky130_fd_sc_hd__and2b_2
X_5608_ _5610_/A1 _5578_/Y _5602_/Y _5608_/B2 VGND VGND VPWR VPWR _6679_/D sky130_fd_sc_hd__a22o_2
XFILLER_11_12 VGND VGND VPWR VPWR sky130_fd_sc_hd__decap_3
X_6588_ _6982_/CLK _6588_/D fanout745/X VGND VGND VPWR VPWR _6588_/Q sky130_fd_sc_hd__dfrtp_2
XFILLER_69_1331 VGND VGND VPWR VPWR sky130_fd_sc_hd__decap_3
XFILLER_3_517 VGND VGND VPWR VPWR sky130_fd_sc_hd__decap_3
X_5539_ _6372_/Q _5566_/A2 _5539_/B1 _5566_/B2 VGND VGND VPWR VPWR _6622_/D sky130_fd_sc_hd__a22o_2
XFILLER_69_1375 VGND VGND VPWR VPWR sky130_fd_sc_hd__decap_3
XFILLER_65_1228 VGND VGND VPWR VPWR sky130_fd_sc_hd__decap_3
XFILLER_65_1239 VGND VGND VPWR VPWR sky130_fd_sc_hd__decap_3
XFILLER_8_1111 VGND VGND VPWR VPWR sky130_fd_sc_hd__decap_3
Xfanout320 _3087_/Y VGND VGND VPWR VPWR _4008_/B sky130_fd_sc_hd__clkdlybuf4s25_1
XTAP_TAPCELL_ROW_6_344 VGND VPWR sky130_fd_sc_hd__tapvpwrvgnd_1
XPHY_EDGE_ROW_21_Left_102 VGND VGND VPWR VPWR sky130_fd_sc_hd__decap_3
XFILLER_8_1144 VGND VGND VPWR VPWR sky130_fd_sc_hd__decap_3
Xfanout342 _3722_/X VGND VGND VPWR VPWR _4771_/A1 sky130_fd_sc_hd__clkdlybuf4s25_1
XFILLER_8_1155 VGND VGND VPWR VPWR sky130_fd_sc_hd__decap_3
XTAP_TAPCELL_ROW_6_355 VGND VPWR sky130_fd_sc_hd__tapvpwrvgnd_1
XFILLER_28_1083 VGND VGND VPWR VPWR sky130_fd_sc_hd__decap_3
Xfanout353 _3948_/C1 VGND VGND VPWR VPWR _3921_/C1 sky130_fd_sc_hd__clkdlybuf4s25_1
XTAP_TAPCELL_ROW_6_366 VGND VPWR sky130_fd_sc_hd__tapvpwrvgnd_1
Xfanout364 _3493_/Y VGND VGND VPWR VPWR _3551_/C1 sky130_fd_sc_hd__clkdlybuf4s25_1
XFILLER_4_1008 VGND VGND VPWR VPWR sky130_fd_sc_hd__decap_3
XFILLER_47_716 VGND VGND VPWR VPWR sky130_fd_sc_hd__decap_3
XFILLER_8_1188 VGND VGND VPWR VPWR sky130_fd_sc_hd__decap_3
Xfanout386 _4757_/B2 VGND VGND VPWR VPWR _4262_/B2 sky130_fd_sc_hd__clkdlybuf4s25_1
Xfanout397 _4788_/A VGND VGND VPWR VPWR _4831_/C1 sky130_fd_sc_hd__clkdlybuf4s25_1
XFILLER_41_1272 VGND VGND VPWR VPWR sky130_fd_sc_hd__decap_3
XFILLER_15_613 VGND VGND VPWR VPWR sky130_fd_sc_hd__decap_3
XFILLER_43_922 VGND VGND VPWR VPWR sky130_fd_sc_hd__decap_3
XFILLER_76_1335 VGND VGND VPWR VPWR sky130_fd_sc_hd__decap_3
XFILLER_70_730 VGND VGND VPWR VPWR sky130_fd_sc_hd__decap_3
XFILLER_42_421 VGND VGND VPWR VPWR sky130_fd_sc_hd__decap_3
XFILLER_76_1368 VGND VGND VPWR VPWR sky130_fd_sc_hd__decap_3
XFILLER_37_1319 VGND VGND VPWR VPWR sky130_fd_sc_hd__decap_3
XFILLER_54_292 VGND VGND VPWR VPWR sky130_fd_sc_hd__decap_3
XFILLER_76_1379 VGND VGND VPWR VPWR sky130_fd_sc_hd__decap_3
XFILLER_43_977 VGND VGND VPWR VPWR sky130_fd_sc_hd__decap_3
XFILLER_14_156 VGND VGND VPWR VPWR sky130_fd_sc_hd__decap_3
XFILLER_42_465 VGND VGND VPWR VPWR sky130_fd_sc_hd__decap_3
XPHY_EDGE_ROW_30_Left_111 VGND VGND VPWR VPWR sky130_fd_sc_hd__decap_3
XTAP_TAPCELL_ROW_46_1391 VGND VPWR sky130_fd_sc_hd__tapvpwrvgnd_1
XFILLER_52_52 VGND VGND VPWR VPWR sky130_fd_sc_hd__decap_3
XFILLER_35_1065 VGND VGND VPWR VPWR sky130_fd_sc_hd__decap_3
XFILLER_52_85 VGND VGND VPWR VPWR sky130_fd_sc_hd__decap_3
XTAP_TAPCELL_ROW_42_1288 VGND VPWR sky130_fd_sc_hd__tapvpwrvgnd_1
XTAP_TAPCELL_ROW_42_1299 VGND VPWR sky130_fd_sc_hd__tapvpwrvgnd_1
XFILLER_7_856 VGND VGND VPWR VPWR sky130_fd_sc_hd__fill_2
XFILLER_7_867 VGND VGND VPWR VPWR sky130_fd_sc_hd__decap_3
XFILLER_13_1363 VGND VGND VPWR VPWR sky130_fd_sc_hd__decap_3
XFILLER_6_355 VGND VGND VPWR VPWR sky130_fd_sc_hd__fill_2
XTAP_TAPCELL_ROW_59_1730 VGND VPWR sky130_fd_sc_hd__tapvpwrvgnd_1
XTAP_TAPCELL_ROW_59_1741 VGND VPWR sky130_fd_sc_hd__tapvpwrvgnd_1
XFILLER_13_1396 VGND VGND VPWR VPWR sky130_fd_sc_hd__decap_3
XFILLER_48_1415 VGND VGND VPWR VPWR sky130_fd_sc_hd__decap_3
XTAP_TAPCELL_ROW_55_1627 VGND VPWR sky130_fd_sc_hd__tapvpwrvgnd_1
XTAP_TAPCELL_ROW_55_1638 VGND VPWR sky130_fd_sc_hd__tapvpwrvgnd_1
XFILLER_48_1459 VGND VGND VPWR VPWR sky130_fd_sc_hd__decap_3
Xload_slew726 fanout725/X VGND VGND VPWR VPWR load_slew726/X sky130_fd_sc_hd__clkbuf_2
Xload_slew748 fanout747/X VGND VGND VPWR VPWR load_slew748/X sky130_fd_sc_hd__buf_4
XFILLER_77_60 VGND VGND VPWR VPWR sky130_fd_sc_hd__decap_3
XFILLER_28_6 VGND VGND VPWR VPWR sky130_fd_sc_hd__decap_3
XFILLER_77_93 VGND VGND VPWR VPWR sky130_fd_sc_hd__decap_3
XFILLER_65_502 VGND VGND VPWR VPWR sky130_fd_sc_hd__fill_2
XFILLER_65_524 VGND VGND VPWR VPWR sky130_fd_sc_hd__fill_2
XFILLER_20_1312 VGND VGND VPWR VPWR sky130_fd_sc_hd__decap_3
XFILLER_37_237 VGND VGND VPWR VPWR sky130_fd_sc_hd__decap_3
XFILLER_20_1323 VGND VGND VPWR VPWR sky130_fd_sc_hd__decap_3
XFILLER_37_259 VGND VGND VPWR VPWR sky130_fd_sc_hd__decap_3
XFILLER_80_505 VGND VGND VPWR VPWR sky130_fd_sc_hd__decap_3
XFILLER_19_974 VGND VGND VPWR VPWR sky130_fd_sc_hd__fill_2
XFILLER_46_760 VGND VGND VPWR VPWR sky130_fd_sc_hd__decap_3
XFILLER_20_1356 VGND VGND VPWR VPWR sky130_fd_sc_hd__decap_3
XFILLER_52_207 VGND VGND VPWR VPWR sky130_fd_sc_hd__decap_3
XFILLER_34_922 VGND VGND VPWR VPWR sky130_fd_sc_hd__fill_2
XFILLER_52_218 VGND VGND VPWR VPWR sky130_fd_sc_hd__decap_3
X_4910_ _6409_/Q _4910_/B VGND VGND VPWR VPWR _5201_/B sky130_fd_sc_hd__xnor2_2
XFILLER_46_793 VGND VGND VPWR VPWR sky130_fd_sc_hd__decap_3
X_5890_ _5899_/A0 _5890_/A1 _5896_/S VGND VGND VPWR VPWR _6899_/D sky130_fd_sc_hd__mux2_1
XFILLER_18_495 VGND VGND VPWR VPWR sky130_fd_sc_hd__decap_3
XFILLER_45_292 VGND VGND VPWR VPWR sky130_fd_sc_hd__decap_3
XFILLER_61_741 VGND VGND VPWR VPWR sky130_fd_sc_hd__decap_3
XFILLER_34_966 VGND VGND VPWR VPWR sky130_fd_sc_hd__decap_3
XFILLER_55_1419 VGND VGND VPWR VPWR sky130_fd_sc_hd__decap_3
X_4841_ _6335_/Q _4840_/X _4899_/S VGND VGND VPWR VPWR _6335_/D sky130_fd_sc_hd__mux2_1
XFILLER_33_476 VGND VGND VPWR VPWR sky130_fd_sc_hd__decap_3
XFILLER_61_785 VGND VGND VPWR VPWR sky130_fd_sc_hd__decap_3
XFILLER_18_1241 VGND VGND VPWR VPWR sky130_fd_sc_hd__decap_3
XFILLER_20_115 VGND VGND VPWR VPWR sky130_fd_sc_hd__decap_3
XFILLER_33_498 VGND VGND VPWR VPWR sky130_fd_sc_hd__decap_3
X_4772_ _4768_/X _4769_/X _4771_/Y _4772_/C1 VGND VGND VPWR VPWR _4772_/X sky130_fd_sc_hd__o211a_2
XFILLER_60_295 VGND VGND VPWR VPWR sky130_fd_sc_hd__decap_3
XFILLER_18_1285 VGND VGND VPWR VPWR sky130_fd_sc_hd__decap_3
X_6511_ _6913_/CLK _6511_/D fanout725/X VGND VGND VPWR VPWR _6511_/Q sky130_fd_sc_hd__dfrtp_2
XFILLER_14_1127 VGND VGND VPWR VPWR sky130_fd_sc_hd__decap_3
X_3723_ _6272_/Q _3960_/B _3921_/B1 _6248_/Q _3921_/C1 VGND VGND VPWR VPWR _3723_/X
+ sky130_fd_sc_hd__a221o_2
XFILLER_14_1149 VGND VGND VPWR VPWR sky130_fd_sc_hd__fill_1
XFILLER_53_1198 VGND VGND VPWR VPWR sky130_fd_sc_hd__fill_1
XFILLER_9_193 VGND VGND VPWR VPWR sky130_fd_sc_hd__fill_2
X_6442_ _7004_/CLK _6442_/D fanout835/X VGND VGND VPWR VPWR _6442_/Q sky130_fd_sc_hd__dfrtp_2
X_3654_ _3652_/X _3653_/Y _3617_/A _3617_/B VGND VGND VPWR VPWR _3681_/A sky130_fd_sc_hd__o211ai_2
XFILLER_31_1452 VGND VGND VPWR VPWR sky130_fd_sc_hd__decap_3
XFILLER_31_1463 VGND VGND VPWR VPWR sky130_fd_sc_hd__decap_3
X_6373_ _6772_/CLK _6373_/D load_slew825/X VGND VGND VPWR VPWR _6373_/Q sky130_fd_sc_hd__dfrtp_2
X_3585_ _3607_/B _3607_/C wire95/X VGND VGND VPWR VPWR _3588_/C sky130_fd_sc_hd__a21o_2
X_5324_ _6793_/Q _5008_/B _5340_/S VGND VGND VPWR VPWR _5324_/X sky130_fd_sc_hd__mux2_1
XFILLER_9_1431 VGND VGND VPWR VPWR sky130_fd_sc_hd__decap_3
X_5255_ _5332_/S _5255_/B VGND VGND VPWR VPWR _5255_/Y sky130_fd_sc_hd__nand2_2
XFILLER_64_1250 VGND VGND VPWR VPWR sky130_fd_sc_hd__decap_3
XFILLER_29_1381 VGND VGND VPWR VPWR sky130_fd_sc_hd__decap_3
XFILLER_64_1261 VGND VGND VPWR VPWR sky130_fd_sc_hd__decap_3
X_4206_ _6305_/Q _4765_/A2 _3244_/X _4882_/B2 VGND VGND VPWR VPWR _4206_/X sky130_fd_sc_hd__a22o_2
X_5186_ _6740_/Q _5276_/A VGND VGND VPWR VPWR _5186_/Y sky130_fd_sc_hd__nor2_2
XFILLER_25_1245 VGND VGND VPWR VPWR sky130_fd_sc_hd__decap_3
XFILLER_64_1294 VGND VGND VPWR VPWR sky130_fd_sc_hd__decap_3
XFILLER_69_874 VGND VGND VPWR VPWR sky130_fd_sc_hd__fill_2
XFILLER_5_1328 VGND VGND VPWR VPWR sky130_fd_sc_hd__decap_3
XFILLER_29_716 VGND VGND VPWR VPWR sky130_fd_sc_hd__decap_3
XFILLER_3_90 VGND VGND VPWR VPWR sky130_fd_sc_hd__decap_3
XFILLER_25_1278 VGND VGND VPWR VPWR sky130_fd_sc_hd__decap_3
X_4137_ _6812_/Q _4744_/A2 _4766_/B1 _4136_/X VGND VGND VPWR VPWR _4137_/X sky130_fd_sc_hd__a211o_2
XFILLER_68_384 VGND VGND VPWR VPWR sky130_fd_sc_hd__decap_3
XFILLER_25_1289 VGND VGND VPWR VPWR sky130_fd_sc_hd__decap_3
XFILLER_3_1030 VGND VGND VPWR VPWR sky130_fd_sc_hd__decap_3
XTAP_TAPCELL_ROW_27_906 VGND VPWR sky130_fd_sc_hd__tapvpwrvgnd_1
X_4068_ _3468_/X _4583_/B2 _4584_/A2 _6931_/Q _4068_/C1 VGND VGND VPWR VPWR _4068_/X
+ sky130_fd_sc_hd__a221o_2
XFILLER_73_18 VGND VGND VPWR VPWR sky130_fd_sc_hd__decap_3
XFILLER_56_579 VGND VGND VPWR VPWR sky130_fd_sc_hd__fill_2
XFILLER_3_1063 VGND VGND VPWR VPWR sky130_fd_sc_hd__fill_1
Xwire30 wire30/A VGND VGND VPWR VPWR uo_out[4] sky130_fd_sc_hd__buf_4
XFILLER_3_1074 VGND VGND VPWR VPWR sky130_fd_sc_hd__decap_3
Xwire52 wire52/A VGND VGND VPWR VPWR wire52/X sky130_fd_sc_hd__clkbuf_4
XFILLER_24_421 VGND VGND VPWR VPWR sky130_fd_sc_hd__decap_3
Xwire63 wire63/A VGND VGND VPWR VPWR wire63/X sky130_fd_sc_hd__clkbuf_4
XFILLER_36_292 VGND VGND VPWR VPWR sky130_fd_sc_hd__decap_3
XFILLER_52_741 VGND VGND VPWR VPWR sky130_fd_sc_hd__decap_3
XFILLER_40_903 VGND VGND VPWR VPWR sky130_fd_sc_hd__decap_3
XFILLER_40_925 VGND VGND VPWR VPWR sky130_fd_sc_hd__decap_3
XFILLER_19_1049 VGND VGND VPWR VPWR sky130_fd_sc_hd__decap_3
XFILLER_51_262 VGND VGND VPWR VPWR sky130_fd_sc_hd__decap_3
XFILLER_71_1210 VGND VGND VPWR VPWR sky130_fd_sc_hd__decap_3
XFILLER_24_487 VGND VGND VPWR VPWR sky130_fd_sc_hd__decap_3
XFILLER_75_1390 VGND VGND VPWR VPWR sky130_fd_sc_hd__decap_3
XFILLER_36_1341 VGND VGND VPWR VPWR sky130_fd_sc_hd__decap_3
XFILLER_40_958 VGND VGND VPWR VPWR sky130_fd_sc_hd__decap_3
XFILLER_51_295 VGND VGND VPWR VPWR sky130_fd_sc_hd__decap_3
XFILLER_71_1254 VGND VGND VPWR VPWR sky130_fd_sc_hd__decap_3
XFILLER_32_1205 VGND VGND VPWR VPWR sky130_fd_sc_hd__decap_3
X_6709_ _7092_/CLK _6709_/D load_slew690/X VGND VGND VPWR VPWR _6709_/Q sky130_fd_sc_hd__dfrtp_2
XFILLER_11_159 VGND VGND VPWR VPWR sky130_fd_sc_hd__fill_1
XFILLER_36_1385 VGND VGND VPWR VPWR sky130_fd_sc_hd__decap_3
XFILLER_71_1287 VGND VGND VPWR VPWR sky130_fd_sc_hd__fill_1
XFILLER_32_1238 VGND VGND VPWR VPWR sky130_fd_sc_hd__decap_3
XFILLER_71_1298 VGND VGND VPWR VPWR sky130_fd_sc_hd__decap_3
XFILLER_4_837 VGND VGND VPWR VPWR sky130_fd_sc_hd__decap_3
XFILLER_69_1150 VGND VGND VPWR VPWR sky130_fd_sc_hd__decap_3
XFILLER_69_1183 VGND VGND VPWR VPWR sky130_fd_sc_hd__decap_3
XFILLER_3_358 VGND VGND VPWR VPWR sky130_fd_sc_hd__decap_3
XFILLER_79_638 VGND VGND VPWR VPWR sky130_fd_sc_hd__fill_1
XFILLER_43_1301 VGND VGND VPWR VPWR sky130_fd_sc_hd__decap_3
XTAP_TAPCELL_ROW_50_1502 VGND VPWR sky130_fd_sc_hd__tapvpwrvgnd_1
XFILLER_43_1334 VGND VGND VPWR VPWR sky130_fd_sc_hd__decap_3
XTAP_TAPCELL_ROW_50_1513 VGND VPWR sky130_fd_sc_hd__tapvpwrvgnd_1
XFILLER_43_1345 VGND VGND VPWR VPWR sky130_fd_sc_hd__decap_3
XFILLER_47_502 VGND VGND VPWR VPWR sky130_fd_sc_hd__fill_2
Xfanout172 _3713_/X VGND VGND VPWR VPWR _4768_/A sky130_fd_sc_hd__clkdlybuf4s25_1
Xfanout194 _3078_/Y VGND VGND VPWR VPWR _3459_/S sky130_fd_sc_hd__clkdlybuf4s25_1
XFILLER_43_1378 VGND VGND VPWR VPWR sky130_fd_sc_hd__decap_3
XFILLER_75_844 VGND VGND VPWR VPWR sky130_fd_sc_hd__decap_3
XFILLER_74_321 VGND VGND VPWR VPWR sky130_fd_sc_hd__decap_3
XFILLER_19_237 VGND VGND VPWR VPWR sky130_fd_sc_hd__decap_3
XFILLER_47_63 VGND VGND VPWR VPWR sky130_fd_sc_hd__decap_3
XFILLER_74_365 VGND VGND VPWR VPWR sky130_fd_sc_hd__fill_1
XFILLER_35_719 VGND VGND VPWR VPWR sky130_fd_sc_hd__decap_3
XFILLER_74_387 VGND VGND VPWR VPWR sky130_fd_sc_hd__decap_3
XFILLER_16_922 VGND VGND VPWR VPWR sky130_fd_sc_hd__fill_2
XFILLER_34_229 VGND VGND VPWR VPWR sky130_fd_sc_hd__decap_3
XFILLER_76_1132 VGND VGND VPWR VPWR sky130_fd_sc_hd__decap_3
XFILLER_16_955 VGND VGND VPWR VPWR sky130_fd_sc_hd__decap_3
XFILLER_27_281 VGND VGND VPWR VPWR sky130_fd_sc_hd__fill_2
XTAP_TAPCELL_ROW_48_1442 VGND VPWR sky130_fd_sc_hd__tapvpwrvgnd_1
XTAP_TAPCELL_ROW_48_1453 VGND VPWR sky130_fd_sc_hd__tapvpwrvgnd_1
XFILLER_37_1116 VGND VGND VPWR VPWR sky130_fd_sc_hd__decap_3
XFILLER_76_1176 VGND VGND VPWR VPWR sky130_fd_sc_hd__decap_3
XFILLER_42_240 VGND VGND VPWR VPWR sky130_fd_sc_hd__decap_3
XFILLER_72_1029 VGND VGND VPWR VPWR sky130_fd_sc_hd__decap_3
XFILLER_43_785 VGND VGND VPWR VPWR sky130_fd_sc_hd__fill_1
XFILLER_15_487 VGND VGND VPWR VPWR sky130_fd_sc_hd__decap_3
XTAP_TAPCELL_ROW_44_1339 VGND VPWR sky130_fd_sc_hd__tapvpwrvgnd_1
XFILLER_54_1441 VGND VGND VPWR VPWR sky130_fd_sc_hd__decap_3
XFILLER_8_24 VGND VGND VPWR VPWR sky130_fd_sc_hd__decap_3
XFILLER_8_35 VGND VGND VPWR VPWR sky130_fd_sc_hd__decap_3
XFILLER_30_457 VGND VGND VPWR VPWR sky130_fd_sc_hd__decap_3
XFILLER_15_1425 VGND VGND VPWR VPWR sky130_fd_sc_hd__decap_3
XFILLER_11_671 VGND VGND VPWR VPWR sky130_fd_sc_hd__fill_1
XFILLER_7_620 VGND VGND VPWR VPWR sky130_fd_sc_hd__fill_2
XFILLER_50_1338 VGND VGND VPWR VPWR sky130_fd_sc_hd__decap_3
Xwire540 wire540/A VGND VGND VPWR VPWR _5334_/S sky130_fd_sc_hd__clkbuf_4
XFILLER_10_181 VGND VGND VPWR VPWR sky130_fd_sc_hd__decap_3
XFILLER_7_664 VGND VGND VPWR VPWR sky130_fd_sc_hd__decap_3
XFILLER_6_141 VGND VGND VPWR VPWR sky130_fd_sc_hd__decap_3
X_3370_ _6304_/Q _6416_/Q VGND VGND VPWR VPWR _3370_/X sky130_fd_sc_hd__xor2_2
XFILLER_48_1245 VGND VGND VPWR VPWR sky130_fd_sc_hd__decap_3
XFILLER_48_1267 VGND VGND VPWR VPWR sky130_fd_sc_hd__decap_3
Xload_slew501 _4416_/A2 VGND VGND VPWR VPWR _4750_/A2 sky130_fd_sc_hd__clkbuf_4
Xload_slew512 _4408_/A2 VGND VGND VPWR VPWR _4765_/A2 sky130_fd_sc_hd__clkbuf_4
XFILLER_3_892 VGND VGND VPWR VPWR sky130_fd_sc_hd__decap_3
XFILLER_2_380 VGND VGND VPWR VPWR sky130_fd_sc_hd__decap_3
Xload_slew534 _5340_/S VGND VGND VPWR VPWR _5338_/S sky130_fd_sc_hd__clkbuf_4
XFILLER_61_1401 VGND VGND VPWR VPWR sky130_fd_sc_hd__decap_3
Xload_slew545 _5330_/S VGND VGND VPWR VPWR _5314_/S sky130_fd_sc_hd__buf_4
X_5040_ _6701_/Q _3067_/Y _5322_/S VGND VGND VPWR VPWR _5040_/X sky130_fd_sc_hd__mux2_1
Xhold1309 _6771_/Q VGND VGND VPWR VPWR _5724_/A1 sky130_fd_sc_hd__dlygate4sd3_1
XFILLER_26_3 VGND VGND VPWR VPWR sky130_fd_sc_hd__decap_3
XFILLER_61_1434 VGND VGND VPWR VPWR sky130_fd_sc_hd__decap_3
XFILLER_66_811 VGND VGND VPWR VPWR sky130_fd_sc_hd__fill_1
XFILLER_22_1418 VGND VGND VPWR VPWR sky130_fd_sc_hd__decap_3
XFILLER_22_1429 VGND VGND VPWR VPWR sky130_fd_sc_hd__decap_3
XFILLER_4_1350 VGND VGND VPWR VPWR sky130_fd_sc_hd__decap_3
XFILLER_38_568 VGND VGND VPWR VPWR sky130_fd_sc_hd__fill_1
XFILLER_26_719 VGND VGND VPWR VPWR sky130_fd_sc_hd__fill_2
XFILLER_53_505 VGND VGND VPWR VPWR sky130_fd_sc_hd__decap_3
X_6991_ _6991_/CLK _6991_/D load_slew792/X VGND VGND VPWR VPWR _6991_/Q sky130_fd_sc_hd__dfrtp_2
XFILLER_25_207 VGND VGND VPWR VPWR sky130_fd_sc_hd__decap_3
XFILLER_0_1214 VGND VGND VPWR VPWR sky130_fd_sc_hd__decap_3
XFILLER_65_387 VGND VGND VPWR VPWR sky130_fd_sc_hd__decap_3
XFILLER_4_1394 VGND VGND VPWR VPWR sky130_fd_sc_hd__decap_3
XFILLER_0_1236 VGND VGND VPWR VPWR sky130_fd_sc_hd__decap_3
XFILLER_18_270 VGND VGND VPWR VPWR sky130_fd_sc_hd__decap_3
X_5942_ hold937/X _6946_/Q _6046_/S VGND VGND VPWR VPWR _5942_/X sky130_fd_sc_hd__mux2_1
XFILLER_59_1363 VGND VGND VPWR VPWR sky130_fd_sc_hd__decap_3
XFILLER_55_1205 VGND VGND VPWR VPWR sky130_fd_sc_hd__fill_2
XFILLER_55_1216 VGND VGND VPWR VPWR sky130_fd_sc_hd__fill_2
X_5873_ _6884_/Q _5868_/Y _5915_/C _5791_/X VGND VGND VPWR VPWR _6884_/D sky130_fd_sc_hd__a22o_2
XFILLER_59_1396 VGND VGND VPWR VPWR sky130_fd_sc_hd__decap_3
XFILLER_22_925 VGND VGND VPWR VPWR sky130_fd_sc_hd__decap_3
XFILLER_34_796 VGND VGND VPWR VPWR sky130_fd_sc_hd__decap_3
X_4824_ _4859_/C1 _4821_/X _4822_/Y _4823_/X _4881_/A VGND VGND VPWR VPWR _4824_/X
+ sky130_fd_sc_hd__o221a_2
XFILLER_21_446 VGND VGND VPWR VPWR sky130_fd_sc_hd__fill_2
X_4755_ _6572_/Q _4762_/B _4756_/A1 VGND VGND VPWR VPWR _4755_/X sky130_fd_sc_hd__a21bo_2
XFILLER_18_1093 VGND VGND VPWR VPWR sky130_fd_sc_hd__fill_2
X_3706_ _3706_/A _3755_/B VGND VGND VPWR VPWR _3707_/B sky130_fd_sc_hd__nor2_2
X_4686_ _6314_/Q _4863_/A2 _4683_/X _4685_/X VGND VGND VPWR VPWR _6314_/D sky130_fd_sc_hd__o22a_2
Xclkbuf_4_6__f_clk clkbuf_3_3_0_clk/X VGND VGND VPWR VPWR clkbuf_4_6__f_clk/X sky130_fd_sc_hd__clkbuf_16
XFILLER_31_1260 VGND VGND VPWR VPWR sky130_fd_sc_hd__decap_3
X_6425_ _6988_/CLK _6425_/D fanout812/X VGND VGND VPWR VPWR _6425_/Q sky130_fd_sc_hd__dfrtp_2
XFILLER_49_1009 VGND VGND VPWR VPWR sky130_fd_sc_hd__decap_3
X_3637_ _3755_/A _3637_/B VGND VGND VPWR VPWR _3652_/B sky130_fd_sc_hd__and2b_2
XFILLER_66_1312 VGND VGND VPWR VPWR sky130_fd_sc_hd__decap_3
XTAP_TAPCELL_ROW_8_406 VGND VPWR sky130_fd_sc_hd__tapvpwrvgnd_1
XFILLER_66_1323 VGND VGND VPWR VPWR sky130_fd_sc_hd__decap_3
XTAP_TAPCELL_ROW_8_417 VGND VPWR sky130_fd_sc_hd__tapvpwrvgnd_1
X_6356_ _6918_/CLK _6356_/D load_slew742/X VGND VGND VPWR VPWR _6356_/Q sky130_fd_sc_hd__dfrtp_2
XFILLER_1_818 VGND VGND VPWR VPWR sky130_fd_sc_hd__decap_3
X_3568_ _6322_/Q _5574_/A2 _4723_/B VGND VGND VPWR VPWR _3568_/X sky130_fd_sc_hd__a21o_2
XFILLER_68_18 VGND VGND VPWR VPWR sky130_fd_sc_hd__decap_3
XFILLER_27_1307 VGND VGND VPWR VPWR sky130_fd_sc_hd__decap_3
XFILLER_66_1356 VGND VGND VPWR VPWR sky130_fd_sc_hd__decap_3
XFILLER_68_29 VGND VGND VPWR VPWR sky130_fd_sc_hd__decap_3
X_5307_ _6446_/Q _5306_/X _5307_/S VGND VGND VPWR VPWR _6446_/D sky130_fd_sc_hd__mux2_1
X_6287_ _6889_/CLK _6287_/D load_slew710/X VGND VGND VPWR VPWR _6287_/Q sky130_fd_sc_hd__dfrtp_2
X_3499_ _6649_/Q _4723_/C VGND VGND VPWR VPWR _3499_/X sky130_fd_sc_hd__or2_2
X_5238_ _6759_/Q _5261_/A _5321_/S _5237_/Y VGND VGND VPWR VPWR _5238_/X sky130_fd_sc_hd__o211a_2
XFILLER_9_1272 VGND VGND VPWR VPWR sky130_fd_sc_hd__decap_3
XFILLER_57_811 VGND VGND VPWR VPWR sky130_fd_sc_hd__decap_3
XFILLER_69_682 VGND VGND VPWR VPWR sky130_fd_sc_hd__decap_3
XFILLER_5_1136 VGND VGND VPWR VPWR sky130_fd_sc_hd__decap_3
X_5169_ _6393_/Q _5254_/A2 _5027_/S _5168_/X VGND VGND VPWR VPWR _6393_/D sky130_fd_sc_hd__a22o_2
XFILLER_5_1169 VGND VGND VPWR VPWR sky130_fd_sc_hd__decap_3
XFILLER_72_803 VGND VGND VPWR VPWR sky130_fd_sc_hd__decap_3
XFILLER_56_365 VGND VGND VPWR VPWR sky130_fd_sc_hd__decap_3
XFILLER_57_888 VGND VGND VPWR VPWR sky130_fd_sc_hd__fill_2
XFILLER_72_836 VGND VGND VPWR VPWR sky130_fd_sc_hd__decap_3
XFILLER_77_1452 VGND VGND VPWR VPWR sky130_fd_sc_hd__decap_3
XFILLER_38_1403 VGND VGND VPWR VPWR sky130_fd_sc_hd__decap_3
XFILLER_77_1463 VGND VGND VPWR VPWR sky130_fd_sc_hd__decap_3
XFILLER_71_357 VGND VGND VPWR VPWR sky130_fd_sc_hd__fill_2
XFILLER_73_1316 VGND VGND VPWR VPWR sky130_fd_sc_hd__decap_3
XFILLER_71_379 VGND VGND VPWR VPWR sky130_fd_sc_hd__fill_1
XFILLER_25_785 VGND VGND VPWR VPWR sky130_fd_sc_hd__decap_3
XFILLER_38_1447 VGND VGND VPWR VPWR sky130_fd_sc_hd__decap_3
XFILLER_80_880 VGND VGND VPWR VPWR sky130_fd_sc_hd__decap_3
XFILLER_12_424 VGND VGND VPWR VPWR sky130_fd_sc_hd__decap_3
XFILLER_40_733 VGND VGND VPWR VPWR sky130_fd_sc_hd__decap_3
XFILLER_33_43 VGND VGND VPWR VPWR sky130_fd_sc_hd__decap_3
XFILLER_40_788 VGND VGND VPWR VPWR sky130_fd_sc_hd__decap_3
XFILLER_32_1035 VGND VGND VPWR VPWR sky130_fd_sc_hd__fill_1
XFILLER_20_490 VGND VGND VPWR VPWR sky130_fd_sc_hd__decap_3
XFILLER_10_1300 VGND VGND VPWR VPWR sky130_fd_sc_hd__decap_3
XFILLER_4_601 VGND VGND VPWR VPWR sky130_fd_sc_hd__decap_3
XFILLER_10_1344 VGND VGND VPWR VPWR sky130_fd_sc_hd__decap_3
XFILLER_4_634 VGND VGND VPWR VPWR sky130_fd_sc_hd__fill_2
XFILLER_3_111 VGND VGND VPWR VPWR sky130_fd_sc_hd__fill_1
XFILLER_3_122 VGND VGND VPWR VPWR sky130_fd_sc_hd__decap_3
XFILLER_4_667 VGND VGND VPWR VPWR sky130_fd_sc_hd__decap_3
XFILLER_10_1388 VGND VGND VPWR VPWR sky130_fd_sc_hd__decap_3
XFILLER_79_413 VGND VGND VPWR VPWR sky130_fd_sc_hd__fill_1
XFILLER_45_1407 VGND VGND VPWR VPWR sky130_fd_sc_hd__decap_3
XTAP_TAPCELL_ROW_37_1154 VGND VPWR sky130_fd_sc_hd__tapvpwrvgnd_1
XTAP_TAPCELL_ROW_37_1165 VGND VPWR sky130_fd_sc_hd__tapvpwrvgnd_1
XFILLER_67_608 VGND VGND VPWR VPWR sky130_fd_sc_hd__decap_3
XFILLER_0_862 VGND VGND VPWR VPWR sky130_fd_sc_hd__decap_3
XFILLER_0_884 VGND VGND VPWR VPWR sky130_fd_sc_hd__decap_3
XFILLER_66_129 VGND VGND VPWR VPWR sky130_fd_sc_hd__decap_3
XFILLER_12_9 VGND VGND VPWR VPWR sky130_fd_sc_hd__decap_3
Xclkbuf_leaf_86_clk clkbuf_leaf_2_clk/A VGND VGND VPWR VPWR _6765_/CLK sky130_fd_sc_hd__clkbuf_8
XFILLER_75_641 VGND VGND VPWR VPWR sky130_fd_sc_hd__decap_3
XFILLER_43_1186 VGND VGND VPWR VPWR sky130_fd_sc_hd__decap_3
XFILLER_78_1205 VGND VGND VPWR VPWR sky130_fd_sc_hd__decap_3
XFILLER_35_505 VGND VGND VPWR VPWR sky130_fd_sc_hd__decap_3
XFILLER_21_1440 VGND VGND VPWR VPWR sky130_fd_sc_hd__decap_3
XFILLER_48_899 VGND VGND VPWR VPWR sky130_fd_sc_hd__decap_3
XFILLER_78_1238 VGND VGND VPWR VPWR sky130_fd_sc_hd__decap_3
XFILLER_74_50 VGND VGND VPWR VPWR sky130_fd_sc_hd__decap_3
XFILLER_63_847 VGND VGND VPWR VPWR sky130_fd_sc_hd__decap_3
XFILLER_74_195 VGND VGND VPWR VPWR sky130_fd_sc_hd__fill_1
XFILLER_16_730 VGND VGND VPWR VPWR sky130_fd_sc_hd__decap_3
XFILLER_74_83 VGND VGND VPWR VPWR sky130_fd_sc_hd__fill_1
XFILLER_16_763 VGND VGND VPWR VPWR sky130_fd_sc_hd__decap_3
XFILLER_50_508 VGND VGND VPWR VPWR sky130_fd_sc_hd__decap_3
XFILLER_15_273 VGND VGND VPWR VPWR sky130_fd_sc_hd__decap_3
XFILLER_16_796 VGND VGND VPWR VPWR sky130_fd_sc_hd__fill_1
XFILLER_43_593 VGND VGND VPWR VPWR sky130_fd_sc_hd__fill_2
XFILLER_31_755 VGND VGND VPWR VPWR sky130_fd_sc_hd__decap_3
XFILLER_30_243 VGND VGND VPWR VPWR sky130_fd_sc_hd__fill_1
XFILLER_15_1222 VGND VGND VPWR VPWR sky130_fd_sc_hd__decap_3
XFILLER_31_788 VGND VGND VPWR VPWR sky130_fd_sc_hd__decap_3
XFILLER_15_1233 VGND VGND VPWR VPWR sky130_fd_sc_hd__decap_3
XFILLER_50_1113 VGND VGND VPWR VPWR sky130_fd_sc_hd__decap_3
XFILLER_54_1282 VGND VGND VPWR VPWR sky130_fd_sc_hd__decap_3
XFILLER_15_1266 VGND VGND VPWR VPWR sky130_fd_sc_hd__decap_3
X_4540_ _5514_/A _4608_/B _4344_/X _4487_/X _6527_/Q VGND VGND VPWR VPWR _4540_/X
+ sky130_fd_sc_hd__a32o_2
XFILLER_50_1146 VGND VGND VPWR VPWR sky130_fd_sc_hd__fill_2
XFILLER_11_1108 VGND VGND VPWR VPWR sky130_fd_sc_hd__decap_3
Xclkbuf_leaf_10_clk clkload1/A VGND VGND VPWR VPWR _7057_/CLK sky130_fd_sc_hd__clkbuf_8
XFILLER_8_984 VGND VGND VPWR VPWR sky130_fd_sc_hd__decap_3
XFILLER_7_461 VGND VGND VPWR VPWR sky130_fd_sc_hd__decap_3
X_4471_ _6855_/Q _4883_/A2 _4855_/B1 _4470_/X VGND VGND VPWR VPWR _4471_/X sky130_fd_sc_hd__a211o_2
X_6210_ _7095_/CLK _6210_/D load_slew696/X VGND VGND VPWR VPWR _6210_/Q sky130_fd_sc_hd__dfrtp_2
Xmax_cap147 _3906_/A VGND VGND VPWR VPWR _4232_/B sky130_fd_sc_hd__clkbuf_2
X_3422_ _6322_/Q _6442_/Q VGND VGND VPWR VPWR _3422_/X sky130_fd_sc_hd__xor2_2
XFILLER_48_1031 VGND VGND VPWR VPWR sky130_fd_sc_hd__decap_3
X_6141_ _7056_/CLK _6141_/D fanout657/X VGND VGND VPWR VPWR _6141_/Q sky130_fd_sc_hd__dfrtp_2
X_3353_ _5997_/A0 _3352_/X _3353_/S VGND VGND VPWR VPWR _6150_/D sky130_fd_sc_hd__mux2_1
X_6072_ _7073_/Q _6068_/X _5841_/C VGND VGND VPWR VPWR _7073_/D sky130_fd_sc_hd__a21o_2
XFILLER_6_1412 VGND VGND VPWR VPWR sky130_fd_sc_hd__decap_3
XFILLER_57_107 VGND VGND VPWR VPWR sky130_fd_sc_hd__decap_3
Xclkbuf_4_14__f_clk clkbuf_3_7_0_clk/X VGND VGND VPWR VPWR clkbuf_leaf_54_clk/A sky130_fd_sc_hd__clkbuf_16
X_3284_ _6221_/Q _6373_/Q VGND VGND VPWR VPWR _3284_/X sky130_fd_sc_hd__xor2_2
XFILLER_39_811 VGND VGND VPWR VPWR sky130_fd_sc_hd__decap_3
Xhold1106 _6634_/Q VGND VGND VPWR VPWR _5551_/B1 sky130_fd_sc_hd__dlygate4sd3_1
XFILLER_61_1231 VGND VGND VPWR VPWR sky130_fd_sc_hd__fill_1
Xload_slew375 _4713_/B2 VGND VGND VPWR VPWR _4832_/B2 sky130_fd_sc_hd__clkbuf_4
Xhold1117 _6929_/Q VGND VGND VPWR VPWR _5923_/A0 sky130_fd_sc_hd__dlygate4sd3_1
XFILLER_26_1362 VGND VGND VPWR VPWR sky130_fd_sc_hd__decap_3
XFILLER_61_1242 VGND VGND VPWR VPWR sky130_fd_sc_hd__decap_3
Xhold1128 _7015_/Q VGND VGND VPWR VPWR _6011_/A1 sky130_fd_sc_hd__dlygate4sd3_1
XFILLER_26_1373 VGND VGND VPWR VPWR sky130_fd_sc_hd__decap_3
X_5023_ _6393_/Q _5249_/B VGND VGND VPWR VPWR _5023_/X sky130_fd_sc_hd__or2_2
XFILLER_6_1456 VGND VGND VPWR VPWR sky130_fd_sc_hd__decap_3
Xhold1139 _6132_/Q VGND VGND VPWR VPWR _5979_/A0 sky130_fd_sc_hd__dlygate4sd3_1
Xclkbuf_leaf_77_clk clkload1/A VGND VGND VPWR VPWR _6889_/CLK sky130_fd_sc_hd__clkbuf_8
XFILLER_61_1275 VGND VGND VPWR VPWR sky130_fd_sc_hd__decap_3
XFILLER_2_1309 VGND VGND VPWR VPWR sky130_fd_sc_hd__decap_3
XFILLER_22_1248 VGND VGND VPWR VPWR sky130_fd_sc_hd__decap_3
XFILLER_38_365 VGND VGND VPWR VPWR sky130_fd_sc_hd__fill_2
XFILLER_26_527 VGND VGND VPWR VPWR sky130_fd_sc_hd__decap_3
XFILLER_54_858 VGND VGND VPWR VPWR sky130_fd_sc_hd__decap_3
XFILLER_4_1191 VGND VGND VPWR VPWR sky130_fd_sc_hd__decap_3
XFILLER_54_869 VGND VGND VPWR VPWR sky130_fd_sc_hd__decap_3
X_6974_ _6974_/CLK _6974_/D fanout765/X VGND VGND VPWR VPWR _6974_/Q sky130_fd_sc_hd__dfrtp_2
XFILLER_65_195 VGND VGND VPWR VPWR sky130_fd_sc_hd__decap_3
XFILLER_0_1033 VGND VGND VPWR VPWR sky130_fd_sc_hd__decap_3
XTAP_TAPCELL_ROW_0_169 VGND VPWR sky130_fd_sc_hd__tapvpwrvgnd_1
XFILLER_53_357 VGND VGND VPWR VPWR sky130_fd_sc_hd__decap_3
XFILLER_0_91 VGND VGND VPWR VPWR sky130_fd_sc_hd__decap_3
XFILLER_0_1055 VGND VGND VPWR VPWR sky130_fd_sc_hd__decap_3
XFILLER_41_508 VGND VGND VPWR VPWR sky130_fd_sc_hd__decap_3
X_5925_ input2/X _5925_/A1 _5932_/S VGND VGND VPWR VPWR _6930_/D sky130_fd_sc_hd__mux2_1
XFILLER_0_1077 VGND VGND VPWR VPWR sky130_fd_sc_hd__decap_3
XFILLER_34_560 VGND VGND VPWR VPWR sky130_fd_sc_hd__decap_3
XFILLER_0_1099 VGND VGND VPWR VPWR sky130_fd_sc_hd__decap_3
XFILLER_22_733 VGND VGND VPWR VPWR sky130_fd_sc_hd__decap_3
XFILLER_61_390 VGND VGND VPWR VPWR sky130_fd_sc_hd__fill_2
X_5856_ _5856_/A0 _5903_/A0 _5856_/S VGND VGND VPWR VPWR _6871_/D sky130_fd_sc_hd__mux2_1
XFILLER_10_906 VGND VGND VPWR VPWR sky130_fd_sc_hd__fill_1
XPHY_EDGE_ROW_3_Right_3 VGND VGND VPWR VPWR sky130_fd_sc_hd__decap_3
X_4807_ _4300_/B _6579_/Q _4835_/S VGND VGND VPWR VPWR _4807_/X sky130_fd_sc_hd__mux2_1
XFILLER_72_1371 VGND VGND VPWR VPWR sky130_fd_sc_hd__fill_1
XFILLER_33_1322 VGND VGND VPWR VPWR sky130_fd_sc_hd__decap_3
XFILLER_72_1382 VGND VGND VPWR VPWR sky130_fd_sc_hd__decap_3
X_5787_ _7073_/Q _5859_/C _5850_/B VGND VGND VPWR VPWR _5787_/Y sky130_fd_sc_hd__a21oi_2
XFILLER_21_287 VGND VGND VPWR VPWR sky130_fd_sc_hd__fill_1
XFILLER_33_1366 VGND VGND VPWR VPWR sky130_fd_sc_hd__decap_3
X_4738_ _4738_/A _4738_/B VGND VGND VPWR VPWR _4738_/Y sky130_fd_sc_hd__nor2_2
XFILLER_33_1399 VGND VGND VPWR VPWR sky130_fd_sc_hd__fill_1
XFILLER_68_1418 VGND VGND VPWR VPWR sky130_fd_sc_hd__decap_3
X_4669_ _4885_/B1 _4666_/X _4667_/Y _4668_/X _4889_/A VGND VGND VPWR VPWR _4669_/X
+ sky130_fd_sc_hd__o221a_2
XFILLER_68_1429 VGND VGND VPWR VPWR sky130_fd_sc_hd__decap_3
XFILLER_79_39 VGND VGND VPWR VPWR sky130_fd_sc_hd__decap_3
XTAP_TAPCELL_ROW_77_2191 VGND VPWR sky130_fd_sc_hd__tapvpwrvgnd_1
X_6408_ _6752_/CLK _6408_/D fanout668/X VGND VGND VPWR VPWR _6408_/Q sky130_fd_sc_hd__dfrtp_2
Xhold940 _5995_/X VGND VGND VPWR VPWR _6999_/D sky130_fd_sc_hd__dlygate4sd3_1
XFILLER_1_604 VGND VGND VPWR VPWR sky130_fd_sc_hd__decap_3
Xhold951 _6092_/Q VGND VGND VPWR VPWR hold951/X sky130_fd_sc_hd__dlygate4sd3_1
XFILLER_66_1131 VGND VGND VPWR VPWR sky130_fd_sc_hd__decap_3
Xhold962 _6004_/X VGND VGND VPWR VPWR _7008_/D sky130_fd_sc_hd__dlygate4sd3_1
XFILLER_0_103 VGND VGND VPWR VPWR sky130_fd_sc_hd__decap_3
Xhold973 _6201_/Q VGND VGND VPWR VPWR hold973/X sky130_fd_sc_hd__dlygate4sd3_1
Xhold984 _6711_/Q VGND VGND VPWR VPWR hold984/X sky130_fd_sc_hd__dlygate4sd3_1
XTAP_TAPCELL_ROW_73_2088 VGND VPWR sky130_fd_sc_hd__tapvpwrvgnd_1
X_6339_ _6925_/CLK _6339_/D fanout656/X VGND VGND VPWR VPWR _6339_/Q sky130_fd_sc_hd__dfrtp_2
Xhold995 _6214_/Q VGND VGND VPWR VPWR hold995/X sky130_fd_sc_hd__dlygate4sd3_1
XTAP_TAPCELL_ROW_73_2099 VGND VPWR sky130_fd_sc_hd__tapvpwrvgnd_1
XFILLER_1_648 VGND VGND VPWR VPWR sky130_fd_sc_hd__decap_3
XFILLER_0_125 VGND VGND VPWR VPWR sky130_fd_sc_hd__decap_3
XFILLER_77_906 VGND VGND VPWR VPWR sky130_fd_sc_hd__decap_3
XFILLER_66_1186 VGND VGND VPWR VPWR sky130_fd_sc_hd__decap_3
XFILLER_0_147 VGND VGND VPWR VPWR sky130_fd_sc_hd__decap_3
XFILLER_76_416 VGND VGND VPWR VPWR sky130_fd_sc_hd__decap_3
XFILLER_0_169 VGND VGND VPWR VPWR sky130_fd_sc_hd__decap_3
XFILLER_44_1462 VGND VGND VPWR VPWR sky130_fd_sc_hd__decap_3
XFILLER_76_449 VGND VGND VPWR VPWR sky130_fd_sc_hd__decap_3
XTAP_TAPCELL_ROW_32_1040 VGND VPWR sky130_fd_sc_hd__tapvpwrvgnd_1
XFILLER_28_32 VGND VGND VPWR VPWR sky130_fd_sc_hd__fill_2
XFILLER_40_1315 VGND VGND VPWR VPWR sky130_fd_sc_hd__fill_1
Xclkbuf_leaf_68_clk clkbuf_4_8__f_clk/X VGND VGND VPWR VPWR _7055_/CLK sky130_fd_sc_hd__clkbuf_8
XFILLER_29_332 VGND VGND VPWR VPWR sky130_fd_sc_hd__decap_3
XFILLER_40_1326 VGND VGND VPWR VPWR sky130_fd_sc_hd__decap_3
XFILLER_17_505 VGND VGND VPWR VPWR sky130_fd_sc_hd__decap_3
XFILLER_29_365 VGND VGND VPWR VPWR sky130_fd_sc_hd__decap_3
XFILLER_40_1359 VGND VGND VPWR VPWR sky130_fd_sc_hd__decap_3
XFILLER_45_825 VGND VGND VPWR VPWR sky130_fd_sc_hd__decap_3
XFILLER_56_195 VGND VGND VPWR VPWR sky130_fd_sc_hd__fill_1
XFILLER_71_143 VGND VGND VPWR VPWR sky130_fd_sc_hd__decap_3
XFILLER_77_1260 VGND VGND VPWR VPWR sky130_fd_sc_hd__decap_3
XFILLER_38_1233 VGND VGND VPWR VPWR sky130_fd_sc_hd__decap_3
XFILLER_73_1124 VGND VGND VPWR VPWR sky130_fd_sc_hd__decap_3
XFILLER_25_582 VGND VGND VPWR VPWR sky130_fd_sc_hd__decap_3
XFILLER_73_1157 VGND VGND VPWR VPWR sky130_fd_sc_hd__decap_3
XFILLER_38_1288 VGND VGND VPWR VPWR sky130_fd_sc_hd__decap_3
XFILLER_13_766 VGND VGND VPWR VPWR sky130_fd_sc_hd__decap_3
XFILLER_40_552 VGND VGND VPWR VPWR sky130_fd_sc_hd__fill_1
XFILLER_8_203 VGND VGND VPWR VPWR sky130_fd_sc_hd__fill_2
XFILLER_40_574 VGND VGND VPWR VPWR sky130_fd_sc_hd__decap_3
XFILLER_51_1422 VGND VGND VPWR VPWR sky130_fd_sc_hd__decap_3
XFILLER_8_236 VGND VGND VPWR VPWR sky130_fd_sc_hd__decap_3
XFILLER_12_1406 VGND VGND VPWR VPWR sky130_fd_sc_hd__decap_3
XTAP_TAPCELL_ROW_23_794 VGND VPWR sky130_fd_sc_hd__tapvpwrvgnd_1
XFILLER_51_1455 VGND VGND VPWR VPWR sky130_fd_sc_hd__fill_1
XFILLER_60_52 VGND VGND VPWR VPWR sky130_fd_sc_hd__decap_3
XFILLER_51_1466 VGND VGND VPWR VPWR sky130_fd_sc_hd__decap_3
XTAP_TAPCELL_ROW_10_455 VGND VPWR sky130_fd_sc_hd__tapvpwrvgnd_1
XFILLER_60_85 VGND VGND VPWR VPWR sky130_fd_sc_hd__fill_1
XTAP_TAPCELL_ROW_10_466 VGND VPWR sky130_fd_sc_hd__tapvpwrvgnd_1
XTAP_TAPCELL_ROW_39_1205 VGND VPWR sky130_fd_sc_hd__tapvpwrvgnd_1
XTAP_TAPCELL_ROW_39_1216 VGND VPWR sky130_fd_sc_hd__tapvpwrvgnd_1
XFILLER_10_1141 VGND VGND VPWR VPWR sky130_fd_sc_hd__decap_3
XFILLER_5_36 VGND VGND VPWR VPWR sky130_fd_sc_hd__decap_3
XTAP_TAPCELL_ROW_39_1227 VGND VPWR sky130_fd_sc_hd__tapvpwrvgnd_1
XFILLER_10_1152 VGND VGND VPWR VPWR sky130_fd_sc_hd__decap_3
XFILLER_4_464 VGND VGND VPWR VPWR sky130_fd_sc_hd__decap_3
XFILLER_49_1340 VGND VGND VPWR VPWR sky130_fd_sc_hd__decap_3
XFILLER_5_69 VGND VGND VPWR VPWR sky130_fd_sc_hd__fill_2
XFILLER_49_1351 VGND VGND VPWR VPWR sky130_fd_sc_hd__decap_3
XFILLER_10_1185 VGND VGND VPWR VPWR sky130_fd_sc_hd__decap_3
XFILLER_49_1384 VGND VGND VPWR VPWR sky130_fd_sc_hd__decap_3
XFILLER_80_1117 VGND VGND VPWR VPWR sky130_fd_sc_hd__decap_3
XFILLER_45_1248 VGND VGND VPWR VPWR sky130_fd_sc_hd__decap_3
XFILLER_80_1139 VGND VGND VPWR VPWR sky130_fd_sc_hd__decap_3
XFILLER_68_928 VGND VGND VPWR VPWR sky130_fd_sc_hd__decap_3
XFILLER_48_630 VGND VGND VPWR VPWR sky130_fd_sc_hd__decap_3
Xclkbuf_leaf_59_clk clkload5/A VGND VGND VPWR VPWR _6923_/CLK sky130_fd_sc_hd__clkbuf_8
XFILLER_10_6 VGND VGND VPWR VPWR sky130_fd_sc_hd__decap_3
XFILLER_76_972 VGND VGND VPWR VPWR sky130_fd_sc_hd__fill_1
XFILLER_47_140 VGND VGND VPWR VPWR sky130_fd_sc_hd__decap_3
XFILLER_78_1013 VGND VGND VPWR VPWR sky130_fd_sc_hd__decap_3
XFILLER_75_493 VGND VGND VPWR VPWR sky130_fd_sc_hd__decap_3
XFILLER_1_1331 VGND VGND VPWR VPWR sky130_fd_sc_hd__decap_3
XFILLER_47_195 VGND VGND VPWR VPWR sky130_fd_sc_hd__fill_1
XFILLER_35_346 VGND VGND VPWR VPWR sky130_fd_sc_hd__decap_3
XFILLER_21_1281 VGND VGND VPWR VPWR sky130_fd_sc_hd__decap_3
XFILLER_21_1292 VGND VGND VPWR VPWR sky130_fd_sc_hd__decap_3
XFILLER_78_1079 VGND VGND VPWR VPWR sky130_fd_sc_hd__decap_3
XFILLER_56_1300 VGND VGND VPWR VPWR sky130_fd_sc_hd__decap_3
XFILLER_1_1375 VGND VGND VPWR VPWR sky130_fd_sc_hd__decap_3
X_3971_ _6225_/Q wire77/X _3969_/X _3970_/X VGND VGND VPWR VPWR _6225_/D sky130_fd_sc_hd__o22a_2
XFILLER_56_1344 VGND VGND VPWR VPWR sky130_fd_sc_hd__decap_3
X_5710_ _5912_/A0 _5710_/A1 wire89/X VGND VGND VPWR VPWR _6759_/D sky130_fd_sc_hd__mux2_1
XFILLER_50_338 VGND VGND VPWR VPWR sky130_fd_sc_hd__fill_2
X_6690_ _6954_/CLK _6690_/D load_slew648/X VGND VGND VPWR VPWR _6690_/Q sky130_fd_sc_hd__dfrtp_2
XFILLER_17_1328 VGND VGND VPWR VPWR sky130_fd_sc_hd__decap_3
XFILLER_56_1388 VGND VGND VPWR VPWR sky130_fd_sc_hd__decap_3
X_5641_ _5907_/A0 _5641_/A1 wire92/A VGND VGND VPWR VPWR _6698_/D sky130_fd_sc_hd__mux2_1
X_5572_ _5572_/A VGND VGND VPWR VPWR _5572_/Y sky130_fd_sc_hd__inv_2
X_4523_ _6292_/Q wire60/X _4520_/X _4522_/X VGND VGND VPWR VPWR _6292_/D sky130_fd_sc_hd__o22a_2
XPHY_EDGE_ROW_68_Left_149 VGND VGND VPWR VPWR sky130_fd_sc_hd__decap_3
X_4454_ _6515_/Q _4534_/B _4831_/A1 VGND VGND VPWR VPWR _4454_/X sky130_fd_sc_hd__a21bo_2
XFILLER_67_1440 VGND VGND VPWR VPWR sky130_fd_sc_hd__decap_3
X_3405_ _6023_/A0 _3404_/X _3421_/S VGND VGND VPWR VPWR _6176_/D sky130_fd_sc_hd__mux2_1
XFILLER_28_1424 VGND VGND VPWR VPWR sky130_fd_sc_hd__decap_3
XFILLER_63_1304 VGND VGND VPWR VPWR sky130_fd_sc_hd__decap_3
XFILLER_28_1435 VGND VGND VPWR VPWR sky130_fd_sc_hd__decap_3
X_4385_ _6274_/Q _4745_/A2 _4382_/X _4384_/X VGND VGND VPWR VPWR _6274_/D sky130_fd_sc_hd__o22a_2
Xfanout716 fanout717/X VGND VGND VPWR VPWR fanout716/X sky130_fd_sc_hd__clkdlybuf4s25_1
Xfanout727 fanout730/X VGND VGND VPWR VPWR fanout727/X sky130_fd_sc_hd__clkdlybuf4s25_1
X_6124_ _7007_/CLK _6124_/D load_slew819/X VGND VGND VPWR VPWR _6124_/Q sky130_fd_sc_hd__dfrtp_2
XFILLER_63_1337 VGND VGND VPWR VPWR sky130_fd_sc_hd__decap_3
X_3336_ _6295_/Q _6399_/Q VGND VGND VPWR VPWR _3336_/X sky130_fd_sc_hd__xor2_2
XFILLER_28_1468 VGND VGND VPWR VPWR sky130_fd_sc_hd__fill_1
XFILLER_63_1348 VGND VGND VPWR VPWR sky130_fd_sc_hd__decap_3
Xfanout749 fanout752/X VGND VGND VPWR VPWR fanout749/X sky130_fd_sc_hd__clkdlybuf4s25_1
XFILLER_6_1220 VGND VGND VPWR VPWR sky130_fd_sc_hd__decap_3
X_6055_ hold959/X _6055_/A1 _6058_/S VGND VGND VPWR VPWR _7059_/D sky130_fd_sc_hd__mux2_1
X_3267_ _5954_/A0 _3266_/X _3379_/S VGND VGND VPWR VPWR _6107_/D sky130_fd_sc_hd__mux2_1
XFILLER_61_1050 VGND VGND VPWR VPWR sky130_fd_sc_hd__decap_3
XFILLER_6_1253 VGND VGND VPWR VPWR sky130_fd_sc_hd__decap_3
XFILLER_67_961 VGND VGND VPWR VPWR sky130_fd_sc_hd__decap_3
XFILLER_73_408 VGND VGND VPWR VPWR sky130_fd_sc_hd__decap_3
XFILLER_6_1264 VGND VGND VPWR VPWR sky130_fd_sc_hd__decap_3
X_5006_ _6358_/Q _5005_/X _5006_/S VGND VGND VPWR VPWR _6358_/D sky130_fd_sc_hd__mux2_1
XFILLER_27_803 VGND VGND VPWR VPWR sky130_fd_sc_hd__fill_1
XFILLER_2_1117 VGND VGND VPWR VPWR sky130_fd_sc_hd__decap_3
XFILLER_6_1297 VGND VGND VPWR VPWR sky130_fd_sc_hd__decap_3
X_3198_ _6081_/A _6968_/Q _6976_/Q _3207_/B2 VGND VGND VPWR VPWR _3198_/X sky130_fd_sc_hd__a22o_2
XFILLER_27_847 VGND VGND VPWR VPWR sky130_fd_sc_hd__decap_3
XPHY_EDGE_ROW_77_Left_158 VGND VGND VPWR VPWR sky130_fd_sc_hd__decap_3
XFILLER_74_1400 VGND VGND VPWR VPWR sky130_fd_sc_hd__decap_3
XFILLER_26_368 VGND VGND VPWR VPWR sky130_fd_sc_hd__decap_3
XFILLER_42_828 VGND VGND VPWR VPWR sky130_fd_sc_hd__decap_3
X_6957_ _7050_/CLK _6957_/D load_slew637/X VGND VGND VPWR VPWR _6957_/Q sky130_fd_sc_hd__dfrtp_2
XFILLER_54_699 VGND VGND VPWR VPWR sky130_fd_sc_hd__fill_1
XFILLER_74_1444 VGND VGND VPWR VPWR sky130_fd_sc_hd__decap_3
XFILLER_14_12 VGND VGND VPWR VPWR sky130_fd_sc_hd__decap_3
X_5908_ _5908_/A0 _5908_/A1 _5914_/S VGND VGND VPWR VPWR _6915_/D sky130_fd_sc_hd__mux2_1
X_6888_ _6888_/CLK _6888_/D load_slew664/X VGND VGND VPWR VPWR _6888_/Q sky130_fd_sc_hd__dfrtp_2
XFILLER_35_1428 VGND VGND VPWR VPWR sky130_fd_sc_hd__decap_3
XFILLER_50_872 VGND VGND VPWR VPWR sky130_fd_sc_hd__fill_1
X_5839_ _5913_/A0 _5839_/A1 _5839_/S VGND VGND VPWR VPWR _6856_/D sky130_fd_sc_hd__mux2_1
XFILLER_10_714 VGND VGND VPWR VPWR sky130_fd_sc_hd__decap_3
XFILLER_33_1130 VGND VGND VPWR VPWR sky130_fd_sc_hd__decap_3
XTAP_TAPCELL_ROW_79_2242 VGND VPWR sky130_fd_sc_hd__tapvpwrvgnd_1
XTAP_TAPCELL_ROW_20_720 VGND VPWR sky130_fd_sc_hd__tapvpwrvgnd_1
XTAP_TAPCELL_ROW_79_2253 VGND VPWR sky130_fd_sc_hd__tapvpwrvgnd_1
XTAP_TAPCELL_ROW_20_731 VGND VPWR sky130_fd_sc_hd__tapvpwrvgnd_1
XTAP_TAPCELL_ROW_79_2264 VGND VPWR sky130_fd_sc_hd__tapvpwrvgnd_1
XFILLER_5_228 VGND VGND VPWR VPWR sky130_fd_sc_hd__fill_2
XTAP_TAPCELL_ROW_75_2139 VGND VPWR sky130_fd_sc_hd__tapvpwrvgnd_1
XFILLER_68_1226 VGND VGND VPWR VPWR sky130_fd_sc_hd__decap_3
XFILLER_2_902 VGND VGND VPWR VPWR sky130_fd_sc_hd__decap_3
XFILLER_68_1259 VGND VGND VPWR VPWR sky130_fd_sc_hd__fill_1
XFILLER_2_946 VGND VGND VPWR VPWR sky130_fd_sc_hd__decap_3
XFILLER_1_434 VGND VGND VPWR VPWR sky130_fd_sc_hd__decap_3
XFILLER_2_979 VGND VGND VPWR VPWR sky130_fd_sc_hd__fill_1
XFILLER_1_478 VGND VGND VPWR VPWR sky130_fd_sc_hd__decap_3
XFILLER_44_1270 VGND VGND VPWR VPWR sky130_fd_sc_hd__decap_3
XFILLER_18_803 VGND VGND VPWR VPWR sky130_fd_sc_hd__decap_3
XFILLER_40_1134 VGND VGND VPWR VPWR sky130_fd_sc_hd__fill_1
XFILLER_64_419 VGND VGND VPWR VPWR sky130_fd_sc_hd__fill_1
XFILLER_79_1322 VGND VGND VPWR VPWR sky130_fd_sc_hd__decap_3
XFILLER_45_611 VGND VGND VPWR VPWR sky130_fd_sc_hd__decap_3
XTAP_TAPCELL_ROW_4_294 VGND VPWR sky130_fd_sc_hd__tapvpwrvgnd_1
XFILLER_17_313 VGND VGND VPWR VPWR sky130_fd_sc_hd__decap_3
XFILLER_18_836 VGND VGND VPWR VPWR sky130_fd_sc_hd__decap_3
Xhold1470 _6551_/Q VGND VGND VPWR VPWR _5439_/A1 sky130_fd_sc_hd__dlygate4sd3_1
Xhold1481 _6738_/Q VGND VGND VPWR VPWR _5686_/A0 sky130_fd_sc_hd__dlygate4sd3_1
Xhold1492 _6494_/Q VGND VGND VPWR VPWR _5382_/A1 sky130_fd_sc_hd__dlygate4sd3_1
XFILLER_72_430 VGND VGND VPWR VPWR sky130_fd_sc_hd__decap_3
XFILLER_18_858 VGND VGND VPWR VPWR sky130_fd_sc_hd__fill_2
XFILLER_79_1366 VGND VGND VPWR VPWR sky130_fd_sc_hd__decap_3
XFILLER_18_869 VGND VGND VPWR VPWR sky130_fd_sc_hd__decap_3
XFILLER_45_666 VGND VGND VPWR VPWR sky130_fd_sc_hd__decap_3
XFILLER_75_1219 VGND VGND VPWR VPWR sky130_fd_sc_hd__decap_3
XFILLER_79_1399 VGND VGND VPWR VPWR sky130_fd_sc_hd__fill_1
XFILLER_26_880 VGND VGND VPWR VPWR sky130_fd_sc_hd__decap_3
XFILLER_38_1052 VGND VGND VPWR VPWR sky130_fd_sc_hd__decap_3
XTAP_TAPCELL_ROW_64_1854 VGND VPWR sky130_fd_sc_hd__tapvpwrvgnd_1
XTAP_TAPCELL_ROW_64_1865 VGND VPWR sky130_fd_sc_hd__tapvpwrvgnd_1
XTAP_TAPCELL_ROW_64_1876 VGND VPWR sky130_fd_sc_hd__tapvpwrvgnd_1
XFILLER_41_861 VGND VGND VPWR VPWR sky130_fd_sc_hd__decap_3
XFILLER_71_51 VGND VGND VPWR VPWR sky130_fd_sc_hd__decap_3
XFILLER_9_523 VGND VGND VPWR VPWR sky130_fd_sc_hd__decap_3
XFILLER_41_894 VGND VGND VPWR VPWR sky130_fd_sc_hd__fill_2
XFILLER_9_545 VGND VGND VPWR VPWR sky130_fd_sc_hd__fill_2
XFILLER_16_1350 VGND VGND VPWR VPWR sky130_fd_sc_hd__decap_3
XFILLER_12_1214 VGND VGND VPWR VPWR sky130_fd_sc_hd__decap_3
XFILLER_51_1263 VGND VGND VPWR VPWR sky130_fd_sc_hd__decap_3
XFILLER_9_589 VGND VGND VPWR VPWR sky130_fd_sc_hd__decap_3
XFILLER_16_1394 VGND VGND VPWR VPWR sky130_fd_sc_hd__decap_3
XFILLER_12_1247 VGND VGND VPWR VPWR sky130_fd_sc_hd__decap_3
XFILLER_5_751 VGND VGND VPWR VPWR sky130_fd_sc_hd__fill_1
XFILLER_58_6 VGND VGND VPWR VPWR sky130_fd_sc_hd__fill_1
XFILLER_45_1012 VGND VGND VPWR VPWR sky130_fd_sc_hd__decap_3
XFILLER_45_1023 VGND VGND VPWR VPWR sky130_fd_sc_hd__decap_3
X_4170_ _4170_/A _4327_/A VGND VGND VPWR VPWR _4241_/A sky130_fd_sc_hd__xnor2_2
XFILLER_68_725 VGND VGND VPWR VPWR sky130_fd_sc_hd__decap_3
X_3121_ _6076_/A1 _3109_/X _3110_/X _3213_/C1 VGND VGND VPWR VPWR _3123_/B sky130_fd_sc_hd__a211o_2
XFILLER_23_1310 VGND VGND VPWR VPWR sky130_fd_sc_hd__decap_3
XFILLER_3_1404 VGND VGND VPWR VPWR sky130_fd_sc_hd__decap_3
XFILLER_23_1343 VGND VGND VPWR VPWR sky130_fd_sc_hd__fill_1
XFILLER_23_1354 VGND VGND VPWR VPWR sky130_fd_sc_hd__decap_3
X_3052_ _6348_/Q VGND VGND VPWR VPWR _3052_/Y sky130_fd_sc_hd__inv_2
XFILLER_3_1437 VGND VGND VPWR VPWR sky130_fd_sc_hd__decap_3
XFILLER_36_611 VGND VGND VPWR VPWR sky130_fd_sc_hd__fill_2
XFILLER_48_471 VGND VGND VPWR VPWR sky130_fd_sc_hd__decap_3
XFILLER_23_1387 VGND VGND VPWR VPWR sky130_fd_sc_hd__decap_3
XFILLER_48_493 VGND VGND VPWR VPWR sky130_fd_sc_hd__decap_3
XFILLER_58_1406 VGND VGND VPWR VPWR sky130_fd_sc_hd__decap_3
XFILLER_75_290 VGND VGND VPWR VPWR sky130_fd_sc_hd__decap_3
XFILLER_63_430 VGND VGND VPWR VPWR sky130_fd_sc_hd__decap_3
X_6811_ _7039_/CLK _6811_/D load_slew822/X VGND VGND VPWR VPWR _6811_/Q sky130_fd_sc_hd__dfrtp_2
XFILLER_51_614 VGND VGND VPWR VPWR sky130_fd_sc_hd__fill_2
XFILLER_1_1172 VGND VGND VPWR VPWR sky130_fd_sc_hd__decap_3
XFILLER_24_839 VGND VGND VPWR VPWR sky130_fd_sc_hd__decap_3
XFILLER_63_485 VGND VGND VPWR VPWR sky130_fd_sc_hd__fill_1
XFILLER_1_1183 VGND VGND VPWR VPWR sky130_fd_sc_hd__decap_3
XFILLER_17_891 VGND VGND VPWR VPWR sky130_fd_sc_hd__decap_3
XFILLER_23_327 VGND VGND VPWR VPWR sky130_fd_sc_hd__decap_3
X_6742_ _7063_/CLK _6742_/D fanout770/X VGND VGND VPWR VPWR _6742_/Q sky130_fd_sc_hd__dfrtp_2
XFILLER_23_349 VGND VGND VPWR VPWR sky130_fd_sc_hd__decap_3
XFILLER_50_135 VGND VGND VPWR VPWR sky130_fd_sc_hd__decap_3
XFILLER_51_669 VGND VGND VPWR VPWR sky130_fd_sc_hd__decap_3
X_3954_ _6503_/Q _4261_/A2 _4005_/C1 _3953_/X VGND VGND VPWR VPWR _3954_/X sky130_fd_sc_hd__o211a_2
XFILLER_17_1114 VGND VGND VPWR VPWR sky130_fd_sc_hd__decap_3
XFILLER_32_872 VGND VGND VPWR VPWR sky130_fd_sc_hd__decap_3
X_6673_ _6889_/CLK _6673_/D fanout708/X VGND VGND VPWR VPWR _6673_/Q sky130_fd_sc_hd__dfrtp_2
X_3885_ _3886_/B VGND VGND VPWR VPWR _3913_/C sky130_fd_sc_hd__inv_2
XFILLER_17_1169 VGND VGND VPWR VPWR sky130_fd_sc_hd__decap_3
XFILLER_31_393 VGND VGND VPWR VPWR sky130_fd_sc_hd__decap_3
XFILLER_34_1450 VGND VGND VPWR VPWR sky130_fd_sc_hd__decap_3
X_5624_ _5624_/A0 _5902_/A0 _5627_/S VGND VGND VPWR VPWR _6686_/D sky130_fd_sc_hd__mux2_1
XFILLER_30_1303 VGND VGND VPWR VPWR sky130_fd_sc_hd__decap_3
X_5555_ _6356_/Q _5566_/A2 _5555_/B1 _5566_/B2 VGND VGND VPWR VPWR _6638_/D sky130_fd_sc_hd__a22o_2
XFILLER_30_1347 VGND VGND VPWR VPWR sky130_fd_sc_hd__decap_3
X_4506_ _4683_/A _4506_/B _4506_/C VGND VGND VPWR VPWR _4506_/X sky130_fd_sc_hd__and3_2
X_5486_ _5486_/A1 _5486_/A2 _4097_/X VGND VGND VPWR VPWR _6598_/D sky130_fd_sc_hd__a21o_2
XTAP_TAPCELL_ROW_70_2014 VGND VPWR sky130_fd_sc_hd__tapvpwrvgnd_1
X_4437_ _4277_/B _6513_/Q _4480_/S VGND VGND VPWR VPWR _4437_/X sky130_fd_sc_hd__mux2_1
XTAP_TAPCELL_ROW_70_2025 VGND VPWR sky130_fd_sc_hd__tapvpwrvgnd_1
Xfanout502 _4773_/A2 VGND VGND VPWR VPWR _3489_/A sky130_fd_sc_hd__clkdlybuf4s25_1
XFILLER_67_1281 VGND VGND VPWR VPWR sky130_fd_sc_hd__decap_3
XFILLER_28_1243 VGND VGND VPWR VPWR sky130_fd_sc_hd__decap_3
Xfanout513 wire515/X VGND VGND VPWR VPWR _4743_/A2 sky130_fd_sc_hd__clkdlybuf4s25_1
XFILLER_67_1292 VGND VGND VPWR VPWR sky130_fd_sc_hd__decap_3
XFILLER_8_1315 VGND VGND VPWR VPWR sky130_fd_sc_hd__fill_1
XFILLER_8_1326 VGND VGND VPWR VPWR sky130_fd_sc_hd__decap_3
X_4368_ _5508_/A wire23/X _4562_/C VGND VGND VPWR VPWR _4368_/X sky130_fd_sc_hd__and3_2
XFILLER_76_18 VGND VGND VPWR VPWR sky130_fd_sc_hd__decap_3
Xfanout535 _7083_/Q VGND VGND VPWR VPWR fanout535/X sky130_fd_sc_hd__clkdlybuf4s25_1
XFILLER_76_29 VGND VGND VPWR VPWR sky130_fd_sc_hd__decap_3
XFILLER_28_1276 VGND VGND VPWR VPWR sky130_fd_sc_hd__decap_3
Xfanout546 _5261_/A VGND VGND VPWR VPWR _5328_/S sky130_fd_sc_hd__clkdlybuf4s25_1
XFILLER_8_1359 VGND VGND VPWR VPWR sky130_fd_sc_hd__decap_3
X_6107_ _6990_/CLK _6107_/D fanout761/X VGND VGND VPWR VPWR _6107_/Q sky130_fd_sc_hd__dfrtp_2
XFILLER_58_224 VGND VGND VPWR VPWR sky130_fd_sc_hd__decap_3
X_3319_ _5980_/A0 _3318_/X _3447_/S VGND VGND VPWR VPWR _6133_/D sky130_fd_sc_hd__mux2_1
Xfanout568 _5801_/A_N VGND VGND VPWR VPWR _5915_/D sky130_fd_sc_hd__clkdlybuf4s25_1
X_7087_ _7096_/CLK _7087_/D fanout680/X VGND VGND VPWR VPWR _7087_/Q sky130_fd_sc_hd__dfrtp_2
Xfanout579 _4403_/A VGND VGND VPWR VPWR _4487_/A sky130_fd_sc_hd__clkdlybuf4s25_1
XFILLER_41_1410 VGND VGND VPWR VPWR sky130_fd_sc_hd__decap_3
X_4299_ _6266_/Q _4863_/A2 _4296_/X _4298_/X VGND VGND VPWR VPWR _6266_/D sky130_fd_sc_hd__o22a_2
X_6038_ hold979/X _6038_/A1 _6046_/S VGND VGND VPWR VPWR _7042_/D sky130_fd_sc_hd__mux2_1
XFILLER_41_1443 VGND VGND VPWR VPWR sky130_fd_sc_hd__decap_3
XFILLER_46_419 VGND VGND VPWR VPWR sky130_fd_sc_hd__fill_1
XFILLER_73_216 VGND VGND VPWR VPWR sky130_fd_sc_hd__fill_1
XFILLER_27_611 VGND VGND VPWR VPWR sky130_fd_sc_hd__decap_3
XTAP_TAPCELL_ROW_1_220 VGND VPWR sky130_fd_sc_hd__tapvpwrvgnd_1
XTAP_TAPCELL_ROW_1_231 VGND VPWR sky130_fd_sc_hd__tapvpwrvgnd_1
XFILLER_27_655 VGND VGND VPWR VPWR sky130_fd_sc_hd__decap_3
XFILLER_70_901 VGND VGND VPWR VPWR sky130_fd_sc_hd__decap_3
XFILLER_26_165 VGND VGND VPWR VPWR sky130_fd_sc_hd__fill_1
XFILLER_41_102 VGND VGND VPWR VPWR sky130_fd_sc_hd__fill_2
XFILLER_41_113 VGND VGND VPWR VPWR sky130_fd_sc_hd__fill_2
XTAP_TAPCELL_ROW_25_845 VGND VPWR sky130_fd_sc_hd__tapvpwrvgnd_1
XFILLER_74_1241 VGND VGND VPWR VPWR sky130_fd_sc_hd__decap_3
XTAP_TAPCELL_ROW_25_856 VGND VPWR sky130_fd_sc_hd__tapvpwrvgnd_1
XFILLER_35_1203 VGND VGND VPWR VPWR sky130_fd_sc_hd__decap_3
XFILLER_39_1372 VGND VGND VPWR VPWR sky130_fd_sc_hd__decap_3
XTAP_TAPCELL_ROW_12_506 VGND VPWR sky130_fd_sc_hd__tapvpwrvgnd_1
XFILLER_74_1285 VGND VGND VPWR VPWR sky130_fd_sc_hd__decap_3
XTAP_TAPCELL_ROW_12_517 VGND VPWR sky130_fd_sc_hd__tapvpwrvgnd_1
XFILLER_35_1236 VGND VGND VPWR VPWR sky130_fd_sc_hd__decap_3
XFILLER_70_1138 VGND VGND VPWR VPWR sky130_fd_sc_hd__decap_3
XFILLER_10_522 VGND VGND VPWR VPWR sky130_fd_sc_hd__decap_3
XFILLER_70_1149 VGND VGND VPWR VPWR sky130_fd_sc_hd__decap_3
XFILLER_35_1269 VGND VGND VPWR VPWR sky130_fd_sc_hd__decap_3
XFILLER_10_555 VGND VGND VPWR VPWR sky130_fd_sc_hd__decap_3
XFILLER_6_504 VGND VGND VPWR VPWR sky130_fd_sc_hd__decap_3
XFILLER_41_54 VGND VGND VPWR VPWR sky130_fd_sc_hd__fill_2
XFILLER_41_87 VGND VGND VPWR VPWR sky130_fd_sc_hd__decap_3
XFILLER_2_710 VGND VGND VPWR VPWR sky130_fd_sc_hd__decap_3
XFILLER_29_1007 VGND VGND VPWR VPWR sky130_fd_sc_hd__fill_1
XFILLER_68_1056 VGND VGND VPWR VPWR sky130_fd_sc_hd__decap_3
XFILLER_29_1018 VGND VGND VPWR VPWR sky130_fd_sc_hd__fill_2
XFILLER_1_220 VGND VGND VPWR VPWR sky130_fd_sc_hd__decap_3
XFILLER_2_743 VGND VGND VPWR VPWR sky130_fd_sc_hd__decap_3
XFILLER_1_231 VGND VGND VPWR VPWR sky130_fd_sc_hd__decap_3
XTAP_TAPCELL_ROW_57_1680 VGND VPWR sky130_fd_sc_hd__tapvpwrvgnd_1
XFILLER_46_1332 VGND VGND VPWR VPWR sky130_fd_sc_hd__decap_3
XTAP_TAPCELL_ROW_57_1691 VGND VPWR sky130_fd_sc_hd__tapvpwrvgnd_1
XFILLER_1_264 VGND VGND VPWR VPWR sky130_fd_sc_hd__decap_3
XFILLER_46_1365 VGND VGND VPWR VPWR sky130_fd_sc_hd__decap_3
XFILLER_2_15 VGND VGND VPWR VPWR sky130_fd_sc_hd__decap_3
XFILLER_46_1376 VGND VGND VPWR VPWR sky130_fd_sc_hd__decap_3
XTAP_TAPCELL_ROW_53_1566 VGND VPWR sky130_fd_sc_hd__tapvpwrvgnd_1
XTAP_TAPCELL_ROW_53_1577 VGND VPWR sky130_fd_sc_hd__tapvpwrvgnd_1
XTAP_TAPCELL_ROW_53_1588 VGND VPWR sky130_fd_sc_hd__tapvpwrvgnd_1
XFILLER_2_59 VGND VGND VPWR VPWR sky130_fd_sc_hd__decap_3
XFILLER_65_706 VGND VGND VPWR VPWR sky130_fd_sc_hd__decap_3
XFILLER_49_268 VGND VGND VPWR VPWR sky130_fd_sc_hd__fill_2
XFILLER_49_279 VGND VGND VPWR VPWR sky130_fd_sc_hd__fill_1
XFILLER_66_62 VGND VGND VPWR VPWR sky130_fd_sc_hd__decap_3
XFILLER_79_1130 VGND VGND VPWR VPWR sky130_fd_sc_hd__decap_3
XFILLER_45_430 VGND VGND VPWR VPWR sky130_fd_sc_hd__decap_3
XFILLER_64_249 VGND VGND VPWR VPWR sky130_fd_sc_hd__decap_3
XTAP_TAPCELL_ROW_66_1905 VGND VPWR sky130_fd_sc_hd__tapvpwrvgnd_1
XFILLER_17_132 VGND VGND VPWR VPWR sky130_fd_sc_hd__fill_1
XFILLER_79_1163 VGND VGND VPWR VPWR sky130_fd_sc_hd__decap_3
XTAP_TAPCELL_ROW_66_1916 VGND VPWR sky130_fd_sc_hd__tapvpwrvgnd_1
XFILLER_73_761 VGND VGND VPWR VPWR sky130_fd_sc_hd__fill_2
XFILLER_18_677 VGND VGND VPWR VPWR sky130_fd_sc_hd__decap_3
XTAP_TAPCELL_ROW_66_1927 VGND VPWR sky130_fd_sc_hd__tapvpwrvgnd_1
XFILLER_17_154 VGND VGND VPWR VPWR sky130_fd_sc_hd__decap_3
XFILLER_33_614 VGND VGND VPWR VPWR sky130_fd_sc_hd__fill_2
XFILLER_75_1038 VGND VGND VPWR VPWR sky130_fd_sc_hd__decap_3
XFILLER_75_1049 VGND VGND VPWR VPWR sky130_fd_sc_hd__decap_3
XFILLER_60_444 VGND VGND VPWR VPWR sky130_fd_sc_hd__decap_3
XFILLER_18_1412 VGND VGND VPWR VPWR sky130_fd_sc_hd__decap_3
XFILLER_61_989 VGND VGND VPWR VPWR sky130_fd_sc_hd__decap_3
XFILLER_53_1325 VGND VGND VPWR VPWR sky130_fd_sc_hd__decap_3
XFILLER_60_477 VGND VGND VPWR VPWR sky130_fd_sc_hd__fill_2
XFILLER_18_1456 VGND VGND VPWR VPWR sky130_fd_sc_hd__decap_3
XFILLER_14_1309 VGND VGND VPWR VPWR sky130_fd_sc_hd__decap_3
XFILLER_13_393 VGND VGND VPWR VPWR sky130_fd_sc_hd__fill_1
XFILLER_53_1369 VGND VGND VPWR VPWR sky130_fd_sc_hd__decap_3
X_3670_ _3670_/A _3670_/B VGND VGND VPWR VPWR _3792_/B sky130_fd_sc_hd__xor2_2
XFILLER_12_1000 VGND VGND VPWR VPWR sky130_fd_sc_hd__decap_3
XFILLER_9_364 VGND VGND VPWR VPWR sky130_fd_sc_hd__fill_1
XFILLER_9_386 VGND VGND VPWR VPWR sky130_fd_sc_hd__decap_3
X_5340_ _6801_/Q _5064_/B _5340_/S VGND VGND VPWR VPWR _5340_/X sky130_fd_sc_hd__mux2_1
XFILLER_56_3 VGND VGND VPWR VPWR sky130_fd_sc_hd__decap_3
XFILLER_5_570 VGND VGND VPWR VPWR sky130_fd_sc_hd__decap_3
X_5271_ _6770_/Q _5342_/S _5271_/B1 _5270_/Y VGND VGND VPWR VPWR _5271_/X sky130_fd_sc_hd__o211a_2
XFILLER_64_1421 VGND VGND VPWR VPWR sky130_fd_sc_hd__decap_3
X_7010_ _7050_/CLK _7010_/D fanout646/X VGND VGND VPWR VPWR _7010_/Q sky130_fd_sc_hd__dfrtp_2
X_4222_ _4222_/A _4222_/B VGND VGND VPWR VPWR _4223_/B sky130_fd_sc_hd__xor2_2
XFILLER_64_1432 VGND VGND VPWR VPWR sky130_fd_sc_hd__decap_3
XFILLER_25_1416 VGND VGND VPWR VPWR sky130_fd_sc_hd__decap_3
XFILLER_64_1465 VGND VGND VPWR VPWR sky130_fd_sc_hd__decap_3
XFILLER_68_533 VGND VGND VPWR VPWR sky130_fd_sc_hd__fill_1
X_4153_ _4153_/A _4153_/B VGND VGND VPWR VPWR _4754_/B sky130_fd_sc_hd__xnor2_2
XFILLER_25_1449 VGND VGND VPWR VPWR sky130_fd_sc_hd__decap_3
XFILLER_29_909 VGND VGND VPWR VPWR sky130_fd_sc_hd__fill_2
XFILLER_60_1329 VGND VGND VPWR VPWR sky130_fd_sc_hd__decap_3
XFILLER_56_706 VGND VGND VPWR VPWR sky130_fd_sc_hd__decap_3
X_3104_ _6075_/S _7075_/Q _6081_/A VGND VGND VPWR VPWR _3106_/B sky130_fd_sc_hd__o21ai_2
XFILLER_3_1201 VGND VGND VPWR VPWR sky130_fd_sc_hd__decap_3
XFILLER_7_1381 VGND VGND VPWR VPWR sky130_fd_sc_hd__decap_3
X_4084_ _6596_/Q _4083_/A _4381_/C1 VGND VGND VPWR VPWR _4084_/X sky130_fd_sc_hd__a21bo_2
XFILLER_23_1173 VGND VGND VPWR VPWR sky130_fd_sc_hd__decap_3
XFILLER_3_1245 VGND VGND VPWR VPWR sky130_fd_sc_hd__decap_3
XFILLER_37_953 VGND VGND VPWR VPWR sky130_fd_sc_hd__decap_3
XFILLER_58_1203 VGND VGND VPWR VPWR sky130_fd_sc_hd__fill_1
XFILLER_3_1278 VGND VGND VPWR VPWR sky130_fd_sc_hd__decap_3
XFILLER_3_1289 VGND VGND VPWR VPWR sky130_fd_sc_hd__decap_3
XFILLER_70_208 VGND VGND VPWR VPWR sky130_fd_sc_hd__decap_3
XFILLER_37_997 VGND VGND VPWR VPWR sky130_fd_sc_hd__decap_3
XFILLER_64_783 VGND VGND VPWR VPWR sky130_fd_sc_hd__decap_3
XTAP_TAPCELL_ROW_19_683 VGND VPWR sky130_fd_sc_hd__tapvpwrvgnd_1
XFILLER_23_113 VGND VGND VPWR VPWR sky130_fd_sc_hd__decap_3
XFILLER_58_1258 VGND VGND VPWR VPWR sky130_fd_sc_hd__fill_2
XTAP_TAPCELL_ROW_19_694 VGND VPWR sky130_fd_sc_hd__tapvpwrvgnd_1
XFILLER_24_669 VGND VGND VPWR VPWR sky130_fd_sc_hd__fill_2
X_4986_ _6452_/Q _6670_/Q VGND VGND VPWR VPWR _4987_/B sky130_fd_sc_hd__xor2_2
XFILLER_52_989 VGND VGND VPWR VPWR sky130_fd_sc_hd__decap_3
XFILLER_51_466 VGND VGND VPWR VPWR sky130_fd_sc_hd__decap_3
XFILLER_71_1425 VGND VGND VPWR VPWR sky130_fd_sc_hd__decap_3
X_6725_ _6765_/CLK _6725_/D wire639/X VGND VGND VPWR VPWR _6725_/Q sky130_fd_sc_hd__dfrtp_2
X_3937_ _6222_/Q _4081_/A2 _3935_/X _3936_/X VGND VGND VPWR VPWR _6222_/D sky130_fd_sc_hd__o22a_2
XFILLER_32_1409 VGND VGND VPWR VPWR sky130_fd_sc_hd__decap_3
X_6656_ _6905_/CLK _6656_/D fanout731/X VGND VGND VPWR VPWR _6656_/Q sky130_fd_sc_hd__dfrtp_2
XFILLER_20_864 VGND VGND VPWR VPWR sky130_fd_sc_hd__decap_3
X_3868_ _6324_/Q _4872_/A _3866_/X _3867_/X VGND VGND VPWR VPWR _4316_/B sky130_fd_sc_hd__o22a_2
X_5607_ _5607_/A1 _5607_/A2 _4312_/B _5602_/Y _5607_/B2 VGND VGND VPWR VPWR _6678_/D
+ sky130_fd_sc_hd__a32o_2
XFILLER_34_1291 VGND VGND VPWR VPWR sky130_fd_sc_hd__decap_3
X_6587_ _6897_/CLK _6587_/D fanout703/X VGND VGND VPWR VPWR _6587_/Q sky130_fd_sc_hd__dfrtp_2
XFILLER_69_1310 VGND VGND VPWR VPWR sky130_fd_sc_hd__decap_3
XFILLER_30_1144 VGND VGND VPWR VPWR sky130_fd_sc_hd__decap_3
X_3799_ _6290_/Q _3928_/A2 _3928_/B1 _6266_/Q _3928_/C1 VGND VGND VPWR VPWR _3799_/X
+ sky130_fd_sc_hd__a221o_2
X_5538_ _6371_/Q _5501_/B _5538_/B1 _5562_/B2 VGND VGND VPWR VPWR _6621_/D sky130_fd_sc_hd__a22o_2
XFILLER_69_1343 VGND VGND VPWR VPWR sky130_fd_sc_hd__fill_1
XFILLER_69_1354 VGND VGND VPWR VPWR sky130_fd_sc_hd__decap_3
XFILLER_3_529 VGND VGND VPWR VPWR sky130_fd_sc_hd__decap_3
XFILLER_11_79 VGND VGND VPWR VPWR sky130_fd_sc_hd__decap_3
XFILLER_69_1387 VGND VGND VPWR VPWR sky130_fd_sc_hd__decap_3
X_5469_ _5469_/A1 _5474_/A2 _4824_/X VGND VGND VPWR VPWR _6581_/D sky130_fd_sc_hd__a21o_2
XFILLER_8_1123 VGND VGND VPWR VPWR sky130_fd_sc_hd__decap_3
Xfanout321 _3087_/Y VGND VGND VPWR VPWR _4040_/A1 sky130_fd_sc_hd__clkdlybuf4s25_1
Xfanout332 _4786_/B VGND VGND VPWR VPWR _3864_/A2 sky130_fd_sc_hd__clkdlybuf4s25_1
XTAP_TAPCELL_ROW_6_345 VGND VPWR sky130_fd_sc_hd__tapvpwrvgnd_1
Xfanout343 _3722_/X VGND VGND VPWR VPWR _4083_/A sky130_fd_sc_hd__clkdlybuf4s25_1
XTAP_TAPCELL_ROW_6_356 VGND VPWR sky130_fd_sc_hd__tapvpwrvgnd_1
XTAP_TAPCELL_ROW_6_367 VGND VPWR sky130_fd_sc_hd__tapvpwrvgnd_1
Xfanout354 _3721_/Y VGND VGND VPWR VPWR _3948_/C1 sky130_fd_sc_hd__clkdlybuf4s25_1
XFILLER_8_1167 VGND VGND VPWR VPWR sky130_fd_sc_hd__decap_3
Xfanout376 _4773_/B2 VGND VGND VPWR VPWR _4080_/A2 sky130_fd_sc_hd__clkdlybuf4s25_1
Xfanout398 _4788_/A VGND VGND VPWR VPWR _4889_/A sky130_fd_sc_hd__clkdlybuf4s25_1
XFILLER_74_536 VGND VGND VPWR VPWR sky130_fd_sc_hd__fill_2
XFILLER_41_1251 VGND VGND VPWR VPWR sky130_fd_sc_hd__decap_3
XFILLER_46_227 VGND VGND VPWR VPWR sky130_fd_sc_hd__decap_3
XFILLER_39_290 VGND VGND VPWR VPWR sky130_fd_sc_hd__decap_3
XFILLER_41_1284 VGND VGND VPWR VPWR sky130_fd_sc_hd__decap_3
XFILLER_41_1295 VGND VGND VPWR VPWR sky130_fd_sc_hd__decap_3
XFILLER_76_1303 VGND VGND VPWR VPWR sky130_fd_sc_hd__decap_3
XFILLER_27_452 VGND VGND VPWR VPWR sky130_fd_sc_hd__decap_3
XFILLER_36_54 VGND VGND VPWR VPWR sky130_fd_sc_hd__decap_3
XFILLER_76_1347 VGND VGND VPWR VPWR sky130_fd_sc_hd__decap_3
XFILLER_43_945 VGND VGND VPWR VPWR sky130_fd_sc_hd__decap_3
XFILLER_36_98 VGND VGND VPWR VPWR sky130_fd_sc_hd__fill_1
XFILLER_43_956 VGND VGND VPWR VPWR sky130_fd_sc_hd__decap_3
XFILLER_42_433 VGND VGND VPWR VPWR sky130_fd_sc_hd__fill_2
XFILLER_30_606 VGND VGND VPWR VPWR sky130_fd_sc_hd__decap_3
XFILLER_42_477 VGND VGND VPWR VPWR sky130_fd_sc_hd__fill_1
XFILLER_39_1180 VGND VGND VPWR VPWR sky130_fd_sc_hd__decap_3
XFILLER_74_1082 VGND VGND VPWR VPWR sky130_fd_sc_hd__decap_3
XFILLER_42_499 VGND VGND VPWR VPWR sky130_fd_sc_hd__decap_3
XFILLER_74_1093 VGND VGND VPWR VPWR sky130_fd_sc_hd__decap_3
XFILLER_11_831 VGND VGND VPWR VPWR sky130_fd_sc_hd__decap_3
XFILLER_35_1044 VGND VGND VPWR VPWR sky130_fd_sc_hd__decap_3
XTAP_TAPCELL_ROW_46_1392 VGND VPWR sky130_fd_sc_hd__tapvpwrvgnd_1
XFILLER_10_341 VGND VGND VPWR VPWR sky130_fd_sc_hd__decap_3
XFILLER_13_1331 VGND VGND VPWR VPWR sky130_fd_sc_hd__decap_3
XTAP_TAPCELL_ROW_42_1289 VGND VPWR sky130_fd_sc_hd__tapvpwrvgnd_1
XFILLER_11_897 VGND VGND VPWR VPWR sky130_fd_sc_hd__decap_3
XFILLER_52_1391 VGND VGND VPWR VPWR sky130_fd_sc_hd__decap_3
XFILLER_13_1375 VGND VGND VPWR VPWR sky130_fd_sc_hd__decap_3
XTAP_TAPCELL_ROW_59_1731 VGND VPWR sky130_fd_sc_hd__tapvpwrvgnd_1
XTAP_TAPCELL_ROW_59_1742 VGND VPWR sky130_fd_sc_hd__tapvpwrvgnd_1
XFILLER_48_1427 VGND VGND VPWR VPWR sky130_fd_sc_hd__fill_1
XFILLER_48_1438 VGND VGND VPWR VPWR sky130_fd_sc_hd__decap_3
XTAP_TAPCELL_ROW_55_1628 VGND VPWR sky130_fd_sc_hd__tapvpwrvgnd_1
XFILLER_42_9 VGND VGND VPWR VPWR sky130_fd_sc_hd__decap_3
XTAP_TAPCELL_ROW_55_1639 VGND VPWR sky130_fd_sc_hd__tapvpwrvgnd_1
XFILLER_2_551 VGND VGND VPWR VPWR sky130_fd_sc_hd__fill_1
Xload_slew705 fanout704/X VGND VGND VPWR VPWR load_slew705/X sky130_fd_sc_hd__buf_4
XFILLER_2_562 VGND VGND VPWR VPWR sky130_fd_sc_hd__decap_3
XFILLER_77_72 VGND VGND VPWR VPWR sky130_fd_sc_hd__decap_3
XFILLER_78_875 VGND VGND VPWR VPWR sky130_fd_sc_hd__decap_3
XFILLER_38_706 VGND VGND VPWR VPWR sky130_fd_sc_hd__decap_3
XFILLER_42_1037 VGND VGND VPWR VPWR sky130_fd_sc_hd__decap_3
XFILLER_0_1407 VGND VGND VPWR VPWR sky130_fd_sc_hd__decap_3
XFILLER_20_1335 VGND VGND VPWR VPWR sky130_fd_sc_hd__decap_3
XFILLER_65_569 VGND VGND VPWR VPWR sky130_fd_sc_hd__decap_3
XFILLER_80_517 VGND VGND VPWR VPWR sky130_fd_sc_hd__decap_3
XFILLER_0_1429 VGND VGND VPWR VPWR sky130_fd_sc_hd__decap_3
XFILLER_18_463 VGND VGND VPWR VPWR sky130_fd_sc_hd__decap_3
XFILLER_46_772 VGND VGND VPWR VPWR sky130_fd_sc_hd__decap_3
XFILLER_20_1368 VGND VGND VPWR VPWR sky130_fd_sc_hd__decap_3
XFILLER_80_539 VGND VGND VPWR VPWR sky130_fd_sc_hd__fill_1
XFILLER_20_1379 VGND VGND VPWR VPWR sky130_fd_sc_hd__decap_3
XFILLER_33_411 VGND VGND VPWR VPWR sky130_fd_sc_hd__decap_3
XFILLER_73_591 VGND VGND VPWR VPWR sky130_fd_sc_hd__decap_3
XTAP_TAPCELL_ROW_16_620 VGND VPWR sky130_fd_sc_hd__tapvpwrvgnd_1
X_4840_ _6921_/Q _4898_/A2 _4838_/X _4839_/X VGND VGND VPWR VPWR _4840_/X sky130_fd_sc_hd__a211o_2
XFILLER_33_455 VGND VGND VPWR VPWR sky130_fd_sc_hd__decap_3
XFILLER_21_606 VGND VGND VPWR VPWR sky130_fd_sc_hd__decap_3
XFILLER_18_1220 VGND VGND VPWR VPWR sky130_fd_sc_hd__decap_3
XFILLER_60_274 VGND VGND VPWR VPWR sky130_fd_sc_hd__decap_3
X_4771_ _4771_/A1 _4413_/B _4770_/Y _4771_/C1 VGND VGND VPWR VPWR _4771_/Y sky130_fd_sc_hd__o211ai_2
XFILLER_18_1253 VGND VGND VPWR VPWR sky130_fd_sc_hd__decap_3
XFILLER_53_1133 VGND VGND VPWR VPWR sky130_fd_sc_hd__decap_3
XFILLER_18_1264 VGND VGND VPWR VPWR sky130_fd_sc_hd__decap_3
XFILLER_20_138 VGND VGND VPWR VPWR sky130_fd_sc_hd__fill_2
X_6510_ _6912_/CLK _6510_/D wire715/X VGND VGND VPWR VPWR _6510_/Q sky130_fd_sc_hd__dfrtp_2
X_3722_ _3722_/A _6608_/Q VGND VGND VPWR VPWR _3722_/X sky130_fd_sc_hd__or2_2
XFILLER_18_1297 VGND VGND VPWR VPWR sky130_fd_sc_hd__decap_3
XFILLER_14_1139 VGND VGND VPWR VPWR sky130_fd_sc_hd__decap_3
XFILLER_9_172 VGND VGND VPWR VPWR sky130_fd_sc_hd__decap_3
XFILLER_31_1431 VGND VGND VPWR VPWR sky130_fd_sc_hd__decap_3
X_6441_ _7035_/CLK _6441_/D load_slew829/X VGND VGND VPWR VPWR _6441_/Q sky130_fd_sc_hd__dfrtp_2
X_3653_ _3652_/A _3652_/C _3652_/D _3652_/B VGND VGND VPWR VPWR _3653_/Y sky130_fd_sc_hd__a31oi_2
X_6372_ _7001_/CLK _6372_/D fanout774/X VGND VGND VPWR VPWR _6372_/Q sky130_fd_sc_hd__dfrtp_2
X_3584_ wire95/X _3607_/B _3607_/C VGND VGND VPWR VPWR _3588_/B sky130_fd_sc_hd__nand3_2
X_5323_ _6454_/Q _5322_/X _5333_/S VGND VGND VPWR VPWR _6454_/D sky130_fd_sc_hd__mux2_1
X_5254_ _6426_/Q _5254_/A2 _5253_/X VGND VGND VPWR VPWR _6426_/D sky130_fd_sc_hd__a21o_2
XFILLER_9_1410 VGND VGND VPWR VPWR sky130_fd_sc_hd__decap_3
XFILLER_29_1360 VGND VGND VPWR VPWR sky130_fd_sc_hd__decap_3
XFILLER_9_1443 VGND VGND VPWR VPWR sky130_fd_sc_hd__decap_3
X_4205_ _6481_/Q _4330_/A2 _4881_/A _4204_/X VGND VGND VPWR VPWR _4205_/X sky130_fd_sc_hd__o211a_2
XFILLER_29_1393 VGND VGND VPWR VPWR sky130_fd_sc_hd__decap_3
XFILLER_64_1273 VGND VGND VPWR VPWR sky130_fd_sc_hd__decap_3
X_5185_ _5184_/Y _5082_/X _5278_/A2 _6401_/Q VGND VGND VPWR VPWR _6401_/D sky130_fd_sc_hd__a2bb2o_2
XFILLER_69_864 VGND VGND VPWR VPWR sky130_fd_sc_hd__fill_1
XFILLER_5_1307 VGND VGND VPWR VPWR sky130_fd_sc_hd__decap_3
XFILLER_25_1257 VGND VGND VPWR VPWR sky130_fd_sc_hd__decap_3
X_4136_ _6274_/Q _4765_/A2 _3230_/X _4743_/B2 VGND VGND VPWR VPWR _4136_/X sky130_fd_sc_hd__a22o_2
XFILLER_69_897 VGND VGND VPWR VPWR sky130_fd_sc_hd__decap_3
XFILLER_56_536 VGND VGND VPWR VPWR sky130_fd_sc_hd__decap_3
X_4067_ _3485_/B _4064_/X _4065_/Y _4066_/X _4734_/C1 VGND VGND VPWR VPWR _4067_/X
+ sky130_fd_sc_hd__o221a_2
XFILLER_3_1042 VGND VGND VPWR VPWR sky130_fd_sc_hd__decap_3
XTAP_TAPCELL_ROW_27_907 VGND VPWR sky130_fd_sc_hd__tapvpwrvgnd_1
XFILLER_71_517 VGND VGND VPWR VPWR sky130_fd_sc_hd__decap_3
Xwire31 wire31/A VGND VGND VPWR VPWR wire31/X sky130_fd_sc_hd__buf_2
XFILLER_37_783 VGND VGND VPWR VPWR sky130_fd_sc_hd__fill_1
XFILLER_3_1086 VGND VGND VPWR VPWR sky130_fd_sc_hd__decap_3
XFILLER_24_400 VGND VGND VPWR VPWR sky130_fd_sc_hd__decap_3
XFILLER_25_956 VGND VGND VPWR VPWR sky130_fd_sc_hd__decap_3
XFILLER_19_1006 VGND VGND VPWR VPWR sky130_fd_sc_hd__fill_2
XFILLER_24_444 VGND VGND VPWR VPWR sky130_fd_sc_hd__decap_3
XFILLER_52_753 VGND VGND VPWR VPWR sky130_fd_sc_hd__decap_3
XFILLER_19_1028 VGND VGND VPWR VPWR sky130_fd_sc_hd__decap_3
XFILLER_25_989 VGND VGND VPWR VPWR sky130_fd_sc_hd__decap_3
Xwire97 wire97/A VGND VGND VPWR VPWR wire97/X sky130_fd_sc_hd__buf_2
XFILLER_24_477 VGND VGND VPWR VPWR sky130_fd_sc_hd__fill_2
XFILLER_36_1320 VGND VGND VPWR VPWR sky130_fd_sc_hd__decap_3
XFILLER_52_786 VGND VGND VPWR VPWR sky130_fd_sc_hd__decap_3
XFILLER_24_499 VGND VGND VPWR VPWR sky130_fd_sc_hd__decap_3
XFILLER_71_1222 VGND VGND VPWR VPWR sky130_fd_sc_hd__decap_3
XFILLER_11_116 VGND VGND VPWR VPWR sky130_fd_sc_hd__decap_3
X_4969_ _4967_/X _4968_/Y _5153_/A2 VGND VGND VPWR VPWR _4971_/S sky130_fd_sc_hd__a21oi_2
XFILLER_71_1233 VGND VGND VPWR VPWR sky130_fd_sc_hd__decap_3
XFILLER_36_1353 VGND VGND VPWR VPWR sky130_fd_sc_hd__decap_3
X_6708_ _6772_/CLK _6708_/D fanout832/X VGND VGND VPWR VPWR _6708_/Q sky130_fd_sc_hd__dfrtp_2
XFILLER_71_1266 VGND VGND VPWR VPWR sky130_fd_sc_hd__decap_3
XFILLER_22_12 VGND VGND VPWR VPWR sky130_fd_sc_hd__decap_3
XFILLER_36_1397 VGND VGND VPWR VPWR sky130_fd_sc_hd__decap_3
XFILLER_22_56 VGND VGND VPWR VPWR sky130_fd_sc_hd__decap_3
X_6639_ _6959_/CLK _6639_/D load_slew799/X VGND VGND VPWR VPWR _6639_/Q sky130_fd_sc_hd__dfrtp_2
XFILLER_4_849 VGND VGND VPWR VPWR sky130_fd_sc_hd__decap_3
XFILLER_69_1162 VGND VGND VPWR VPWR sky130_fd_sc_hd__decap_3
XFILLER_3_337 VGND VGND VPWR VPWR sky130_fd_sc_hd__decap_3
XFILLER_79_606 VGND VGND VPWR VPWR sky130_fd_sc_hd__decap_3
XFILLER_69_1195 VGND VGND VPWR VPWR sky130_fd_sc_hd__decap_3
XFILLER_79_617 VGND VGND VPWR VPWR sky130_fd_sc_hd__decap_3
XFILLER_65_1037 VGND VGND VPWR VPWR sky130_fd_sc_hd__decap_3
XFILLER_65_1059 VGND VGND VPWR VPWR sky130_fd_sc_hd__decap_3
XFILLER_47_1460 VGND VGND VPWR VPWR sky130_fd_sc_hd__decap_3
XFILLER_43_1313 VGND VGND VPWR VPWR sky130_fd_sc_hd__decap_3
XTAP_TAPCELL_ROW_50_1503 VGND VPWR sky130_fd_sc_hd__tapvpwrvgnd_1
Xfanout140 _4265_/Y VGND VGND VPWR VPWR _4586_/C sky130_fd_sc_hd__clkdlybuf4s25_1
XFILLER_43_1357 VGND VGND VPWR VPWR sky130_fd_sc_hd__decap_3
Xfanout173 _3085_/Y VGND VGND VPWR VPWR _5515_/A1 sky130_fd_sc_hd__clkdlybuf4s25_1
Xfanout184 _3481_/S VGND VGND VPWR VPWR _3415_/S sky130_fd_sc_hd__clkdlybuf4s25_1
Xfanout195 _3461_/S VGND VGND VPWR VPWR _3261_/S sky130_fd_sc_hd__clkdlybuf4s25_1
XFILLER_59_396 VGND VGND VPWR VPWR sky130_fd_sc_hd__decap_3
XFILLER_75_856 VGND VGND VPWR VPWR sky130_fd_sc_hd__fill_1
XFILLER_47_547 VGND VGND VPWR VPWR sky130_fd_sc_hd__decap_3
XFILLER_78_1409 VGND VGND VPWR VPWR sky130_fd_sc_hd__decap_3
XFILLER_74_344 VGND VGND VPWR VPWR sky130_fd_sc_hd__decap_3
XFILLER_47_569 VGND VGND VPWR VPWR sky130_fd_sc_hd__decap_3
XFILLER_74_355 VGND VGND VPWR VPWR sky130_fd_sc_hd__decap_3
XFILLER_28_750 VGND VGND VPWR VPWR sky130_fd_sc_hd__decap_3
XFILLER_41_1081 VGND VGND VPWR VPWR sky130_fd_sc_hd__decap_3
XFILLER_34_219 VGND VGND VPWR VPWR sky130_fd_sc_hd__fill_2
XFILLER_76_1111 VGND VGND VPWR VPWR sky130_fd_sc_hd__decap_3
XFILLER_74_399 VGND VGND VPWR VPWR sky130_fd_sc_hd__decap_3
XFILLER_76_1144 VGND VGND VPWR VPWR sky130_fd_sc_hd__decap_3
XTAP_TAPCELL_ROW_48_1443 VGND VPWR sky130_fd_sc_hd__tapvpwrvgnd_1
XFILLER_76_1155 VGND VGND VPWR VPWR sky130_fd_sc_hd__decap_3
XFILLER_16_967 VGND VGND VPWR VPWR sky130_fd_sc_hd__decap_3
XTAP_TAPCELL_ROW_48_1454 VGND VPWR sky130_fd_sc_hd__tapvpwrvgnd_1
XFILLER_43_764 VGND VGND VPWR VPWR sky130_fd_sc_hd__decap_3
XFILLER_15_466 VGND VGND VPWR VPWR sky130_fd_sc_hd__decap_3
XFILLER_76_1188 VGND VGND VPWR VPWR sky130_fd_sc_hd__decap_3
XFILLER_70_572 VGND VGND VPWR VPWR sky130_fd_sc_hd__decap_3
XFILLER_42_296 VGND VGND VPWR VPWR sky130_fd_sc_hd__decap_3
XFILLER_15_1404 VGND VGND VPWR VPWR sky130_fd_sc_hd__decap_3
XFILLER_54_1453 VGND VGND VPWR VPWR sky130_fd_sc_hd__decap_3
XFILLER_50_1306 VGND VGND VPWR VPWR sky130_fd_sc_hd__decap_3
XFILLER_15_1437 VGND VGND VPWR VPWR sky130_fd_sc_hd__decap_3
XFILLER_50_1317 VGND VGND VPWR VPWR sky130_fd_sc_hd__decap_3
XFILLER_6_197 VGND VGND VPWR VPWR sky130_fd_sc_hd__decap_3
XFILLER_48_1224 VGND VGND VPWR VPWR sky130_fd_sc_hd__decap_3
XFILLER_40_6 VGND VGND VPWR VPWR sky130_fd_sc_hd__decap_3
XFILLER_48_1257 VGND VGND VPWR VPWR sky130_fd_sc_hd__decap_3
XFILLER_3_871 VGND VGND VPWR VPWR sky130_fd_sc_hd__decap_3
XFILLER_48_1279 VGND VGND VPWR VPWR sky130_fd_sc_hd__decap_3
Xload_slew524 _5178_/B VGND VGND VPWR VPWR _5322_/S sky130_fd_sc_hd__clkbuf_4
XFILLER_69_127 VGND VGND VPWR VPWR sky130_fd_sc_hd__decap_3
XFILLER_61_1413 VGND VGND VPWR VPWR sky130_fd_sc_hd__decap_3
XFILLER_2_392 VGND VGND VPWR VPWR sky130_fd_sc_hd__decap_3
Xload_slew557 _3206_/S VGND VGND VPWR VPWR _3200_/S sky130_fd_sc_hd__buf_4
XFILLER_38_503 VGND VGND VPWR VPWR sky130_fd_sc_hd__decap_3
XFILLER_61_1446 VGND VGND VPWR VPWR sky130_fd_sc_hd__decap_3
XFILLER_61_1457 VGND VGND VPWR VPWR sky130_fd_sc_hd__decap_3
XFILLER_66_823 VGND VGND VPWR VPWR sky130_fd_sc_hd__fill_1
XFILLER_19_3 VGND VGND VPWR VPWR sky130_fd_sc_hd__decap_3
XFILLER_4_1362 VGND VGND VPWR VPWR sky130_fd_sc_hd__decap_3
X_6990_ _6990_/CLK _6990_/D fanout746/X VGND VGND VPWR VPWR _6990_/Q sky130_fd_sc_hd__dfrtp_2
XFILLER_66_889 VGND VGND VPWR VPWR sky130_fd_sc_hd__decap_3
XFILLER_4_1373 VGND VGND VPWR VPWR sky130_fd_sc_hd__decap_3
XFILLER_19_761 VGND VGND VPWR VPWR sky130_fd_sc_hd__fill_2
XFILLER_20_1143 VGND VGND VPWR VPWR sky130_fd_sc_hd__decap_3
XFILLER_0_1226 VGND VGND VPWR VPWR sky130_fd_sc_hd__decap_3
XFILLER_34_720 VGND VGND VPWR VPWR sky130_fd_sc_hd__fill_2
X_5941_ _5941_/A0 _5941_/A1 _6021_/S VGND VGND VPWR VPWR _6945_/D sky130_fd_sc_hd__mux2_1
XFILLER_59_1331 VGND VGND VPWR VPWR sky130_fd_sc_hd__decap_3
XFILLER_0_1248 VGND VGND VPWR VPWR sky130_fd_sc_hd__decap_3
XFILLER_20_1187 VGND VGND VPWR VPWR sky130_fd_sc_hd__decap_3
XFILLER_34_742 VGND VGND VPWR VPWR sky130_fd_sc_hd__decap_3
XFILLER_34_753 VGND VGND VPWR VPWR sky130_fd_sc_hd__decap_3
XFILLER_59_1375 VGND VGND VPWR VPWR sky130_fd_sc_hd__decap_3
X_5872_ _6883_/Q _5868_/Y _5915_/C _5789_/X VGND VGND VPWR VPWR _6883_/D sky130_fd_sc_hd__a22o_2
XFILLER_55_1239 VGND VGND VPWR VPWR sky130_fd_sc_hd__decap_3
XFILLER_61_572 VGND VGND VPWR VPWR sky130_fd_sc_hd__decap_3
X_4823_ _6581_/Q _4822_/A _4859_/C1 VGND VGND VPWR VPWR _4823_/X sky130_fd_sc_hd__a21bo_2
XFILLER_21_414 VGND VGND VPWR VPWR sky130_fd_sc_hd__decap_3
XFILLER_18_1061 VGND VGND VPWR VPWR sky130_fd_sc_hd__decap_3
X_4754_ _4762_/B _4754_/B VGND VGND VPWR VPWR _4754_/Y sky130_fd_sc_hd__nor2_2
XFILLER_30_981 VGND VGND VPWR VPWR sky130_fd_sc_hd__decap_3
X_3705_ _3705_/A _3705_/B VGND VGND VPWR VPWR _3755_/B sky130_fd_sc_hd__xnor2_2
X_4685_ _6892_/Q _4805_/A2 _4862_/B1 _4684_/X VGND VGND VPWR VPWR _4685_/X sky130_fd_sc_hd__a211o_2
X_3636_ _3636_/A _3671_/A VGND VGND VPWR VPWR _3670_/B sky130_fd_sc_hd__xnor2_2
X_6424_ _6858_/CLK _6424_/D wire652/X VGND VGND VPWR VPWR _6424_/Q sky130_fd_sc_hd__dfrtp_2
XFILLER_31_1272 VGND VGND VPWR VPWR sky130_fd_sc_hd__decap_3
X_6355_ clkload7/A _6355_/D wire641/X VGND VGND VPWR VPWR _6355_/Q sky130_fd_sc_hd__dfrtp_2
XTAP_TAPCELL_ROW_8_407 VGND VPWR sky130_fd_sc_hd__tapvpwrvgnd_1
X_3567_ _6338_/Q _4312_/A _5607_/A2 _6330_/Q _3566_/X VGND VGND VPWR VPWR _3567_/X
+ sky130_fd_sc_hd__a221o_2
XTAP_TAPCELL_ROW_8_418 VGND VPWR sky130_fd_sc_hd__tapvpwrvgnd_1
XFILLER_66_1335 VGND VGND VPWR VPWR sky130_fd_sc_hd__decap_3
X_5306_ _6784_/Q _4945_/B _5306_/S VGND VGND VPWR VPWR _5306_/X sky130_fd_sc_hd__mux2_1
X_6286_ _6925_/CLK _6286_/D fanout659/X VGND VGND VPWR VPWR _6286_/Q sky130_fd_sc_hd__dfrtp_2
XFILLER_0_318 VGND VGND VPWR VPWR sky130_fd_sc_hd__decap_3
XFILLER_27_1319 VGND VGND VPWR VPWR sky130_fd_sc_hd__decap_3
XFILLER_66_1368 VGND VGND VPWR VPWR sky130_fd_sc_hd__decap_3
X_3498_ _6625_/Q wire431/X _3495_/X VGND VGND VPWR VPWR _3498_/X sky130_fd_sc_hd__a21o_2
XFILLER_66_1379 VGND VGND VPWR VPWR sky130_fd_sc_hd__decap_3
X_5237_ _5261_/A _5237_/B VGND VGND VPWR VPWR _5237_/Y sky130_fd_sc_hd__nand2_2
XFILLER_76_609 VGND VGND VPWR VPWR sky130_fd_sc_hd__decap_3
XFILLER_9_1251 VGND VGND VPWR VPWR sky130_fd_sc_hd__decap_3
XFILLER_5_1104 VGND VGND VPWR VPWR sky130_fd_sc_hd__decap_3
XFILLER_75_119 VGND VGND VPWR VPWR sky130_fd_sc_hd__decap_3
XFILLER_9_1284 VGND VGND VPWR VPWR sky130_fd_sc_hd__decap_3
XFILLER_57_823 VGND VGND VPWR VPWR sky130_fd_sc_hd__decap_3
XFILLER_9_1295 VGND VGND VPWR VPWR sky130_fd_sc_hd__decap_3
X_5168_ _6731_/Q _5328_/S VGND VGND VPWR VPWR _5168_/X sky130_fd_sc_hd__or2_2
XFILLER_5_1148 VGND VGND VPWR VPWR sky130_fd_sc_hd__decap_3
XFILLER_29_547 VGND VGND VPWR VPWR sky130_fd_sc_hd__decap_3
XFILLER_56_333 VGND VGND VPWR VPWR sky130_fd_sc_hd__decap_3
X_4119_ _4269_/A _4258_/B VGND VGND VPWR VPWR _4119_/Y sky130_fd_sc_hd__xnor2_2
XFILLER_57_867 VGND VGND VPWR VPWR sky130_fd_sc_hd__decap_3
X_5099_ _5123_/A _5099_/B VGND VGND VPWR VPWR _5099_/X sky130_fd_sc_hd__or2_2
XFILLER_16_219 VGND VGND VPWR VPWR sky130_fd_sc_hd__decap_3
XFILLER_77_1431 VGND VGND VPWR VPWR sky130_fd_sc_hd__decap_3
XFILLER_44_539 VGND VGND VPWR VPWR sky130_fd_sc_hd__decap_3
XFILLER_25_720 VGND VGND VPWR VPWR sky130_fd_sc_hd__decap_3
XFILLER_38_1415 VGND VGND VPWR VPWR sky130_fd_sc_hd__decap_3
XFILLER_73_1328 VGND VGND VPWR VPWR sky130_fd_sc_hd__decap_3
XFILLER_40_701 VGND VGND VPWR VPWR sky130_fd_sc_hd__decap_3
XFILLER_25_797 VGND VGND VPWR VPWR sky130_fd_sc_hd__decap_3
XFILLER_38_1459 VGND VGND VPWR VPWR sky130_fd_sc_hd__decap_3
XFILLER_13_959 VGND VGND VPWR VPWR sky130_fd_sc_hd__decap_3
XFILLER_12_436 VGND VGND VPWR VPWR sky130_fd_sc_hd__decap_3
XFILLER_24_296 VGND VGND VPWR VPWR sky130_fd_sc_hd__decap_3
XFILLER_40_745 VGND VGND VPWR VPWR sky130_fd_sc_hd__decap_3
XFILLER_8_407 VGND VGND VPWR VPWR sky130_fd_sc_hd__decap_3
XFILLER_10_1312 VGND VGND VPWR VPWR sky130_fd_sc_hd__decap_3
XFILLER_10_1323 VGND VGND VPWR VPWR sky130_fd_sc_hd__decap_3
XFILLER_4_613 VGND VGND VPWR VPWR sky130_fd_sc_hd__decap_3
XFILLER_10_1356 VGND VGND VPWR VPWR sky130_fd_sc_hd__decap_3
XFILLER_3_134 VGND VGND VPWR VPWR sky130_fd_sc_hd__fill_1
XFILLER_4_679 VGND VGND VPWR VPWR sky130_fd_sc_hd__decap_3
XFILLER_3_156 VGND VGND VPWR VPWR sky130_fd_sc_hd__decap_3
XFILLER_3_189 VGND VGND VPWR VPWR sky130_fd_sc_hd__decap_3
XTAP_TAPCELL_ROW_37_1155 VGND VPWR sky130_fd_sc_hd__tapvpwrvgnd_1
XFILLER_45_1419 VGND VGND VPWR VPWR sky130_fd_sc_hd__decap_3
XTAP_TAPCELL_ROW_37_1166 VGND VPWR sky130_fd_sc_hd__tapvpwrvgnd_1
XFILLER_79_458 VGND VGND VPWR VPWR sky130_fd_sc_hd__decap_3
XFILLER_0_841 VGND VGND VPWR VPWR sky130_fd_sc_hd__decap_3
XFILLER_43_1143 VGND VGND VPWR VPWR sky130_fd_sc_hd__decap_3
XFILLER_48_823 VGND VGND VPWR VPWR sky130_fd_sc_hd__fill_2
XFILLER_58_85 VGND VGND VPWR VPWR sky130_fd_sc_hd__decap_3
XFILLER_47_300 VGND VGND VPWR VPWR sky130_fd_sc_hd__decap_3
XFILLER_48_878 VGND VGND VPWR VPWR sky130_fd_sc_hd__decap_3
XFILLER_78_1217 VGND VGND VPWR VPWR sky130_fd_sc_hd__decap_3
XFILLER_21_1452 VGND VGND VPWR VPWR sky130_fd_sc_hd__decap_3
XFILLER_35_517 VGND VGND VPWR VPWR sky130_fd_sc_hd__decap_3
XFILLER_63_837 VGND VGND VPWR VPWR sky130_fd_sc_hd__decap_3
XFILLER_21_1463 VGND VGND VPWR VPWR sky130_fd_sc_hd__decap_3
XFILLER_74_62 VGND VGND VPWR VPWR sky130_fd_sc_hd__decap_3
XFILLER_63_859 VGND VGND VPWR VPWR sky130_fd_sc_hd__decap_3
XFILLER_16_753 VGND VGND VPWR VPWR sky130_fd_sc_hd__decap_3
XFILLER_71_870 VGND VGND VPWR VPWR sky130_fd_sc_hd__decap_3
XFILLER_16_775 VGND VGND VPWR VPWR sky130_fd_sc_hd__decap_3
XFILLER_43_561 VGND VGND VPWR VPWR sky130_fd_sc_hd__decap_3
XFILLER_43_572 VGND VGND VPWR VPWR sky130_fd_sc_hd__decap_3
XFILLER_30_200 VGND VGND VPWR VPWR sky130_fd_sc_hd__decap_3
XFILLER_31_723 VGND VGND VPWR VPWR sky130_fd_sc_hd__decap_3
XFILLER_15_296 VGND VGND VPWR VPWR sky130_fd_sc_hd__decap_3
XFILLER_70_391 VGND VGND VPWR VPWR sky130_fd_sc_hd__fill_2
XFILLER_54_1250 VGND VGND VPWR VPWR sky130_fd_sc_hd__decap_3
XFILLER_19_1381 VGND VGND VPWR VPWR sky130_fd_sc_hd__decap_3
XFILLER_54_1261 VGND VGND VPWR VPWR sky130_fd_sc_hd__decap_3
XFILLER_12_981 VGND VGND VPWR VPWR sky130_fd_sc_hd__decap_3
XFILLER_15_1245 VGND VGND VPWR VPWR sky130_fd_sc_hd__decap_3
XFILLER_54_1294 VGND VGND VPWR VPWR sky130_fd_sc_hd__decap_3
XFILLER_11_480 VGND VGND VPWR VPWR sky130_fd_sc_hd__decap_3
XFILLER_15_1278 VGND VGND VPWR VPWR sky130_fd_sc_hd__decap_3
XFILLER_50_1158 VGND VGND VPWR VPWR sky130_fd_sc_hd__decap_3
XFILLER_15_1289 VGND VGND VPWR VPWR sky130_fd_sc_hd__decap_3
X_4470_ _6333_/Q _4854_/A2 _3316_/X _4882_/B2 VGND VGND VPWR VPWR _4470_/X sky130_fd_sc_hd__a22o_2
XFILLER_7_473 VGND VGND VPWR VPWR sky130_fd_sc_hd__decap_3
X_3421_ _6031_/A0 _3420_/X _3421_/S VGND VGND VPWR VPWR _6184_/D sky130_fd_sc_hd__mux2_1
X_6140_ _7055_/CLK _6140_/D load_slew792/X VGND VGND VPWR VPWR _6140_/Q sky130_fd_sc_hd__dfrtp_2
XFILLER_48_1043 VGND VGND VPWR VPWR sky130_fd_sc_hd__fill_1
X_3352_ _6231_/Q _6407_/Q VGND VGND VPWR VPWR _3352_/X sky130_fd_sc_hd__xor2_2
Xload_slew310 _3223_/A1 VGND VGND VPWR VPWR _3180_/A1 sky130_fd_sc_hd__clkbuf_4
X_6071_ _5868_/A _5773_/Y _5804_/X _6068_/X _5924_/A VGND VGND VPWR VPWR _7072_/D
+ sky130_fd_sc_hd__a32o_2
X_3283_ _5962_/A0 _3282_/X _3385_/S VGND VGND VPWR VPWR _6115_/D sky130_fd_sc_hd__mux2_1
XFILLER_26_1341 VGND VGND VPWR VPWR sky130_fd_sc_hd__decap_3
XFILLER_65_1390 VGND VGND VPWR VPWR sky130_fd_sc_hd__decap_3
Xload_slew365 _5574_/A2 VGND VGND VPWR VPWR _5576_/A2 sky130_fd_sc_hd__buf_2
XFILLER_6_1424 VGND VGND VPWR VPWR sky130_fd_sc_hd__decap_3
X_5022_ _6425_/Q _5022_/B VGND VGND VPWR VPWR _5249_/B sky130_fd_sc_hd__xnor2_2
Xhold1107 _6817_/Q VGND VGND VPWR VPWR _5782_/A0 sky130_fd_sc_hd__dlygate4sd3_1
XFILLER_57_119 VGND VGND VPWR VPWR sky130_fd_sc_hd__decap_3
Xhold1118 _7062_/Q VGND VGND VPWR VPWR _6058_/A1 sky130_fd_sc_hd__dlygate4sd3_1
XFILLER_6_1435 VGND VGND VPWR VPWR sky130_fd_sc_hd__decap_3
XFILLER_39_823 VGND VGND VPWR VPWR sky130_fd_sc_hd__fill_2
Xload_slew387 _4262_/B2 VGND VGND VPWR VPWR _4875_/B2 sky130_fd_sc_hd__clkbuf_4
XFILLER_61_1254 VGND VGND VPWR VPWR sky130_fd_sc_hd__decap_3
Xhold1129 _6836_/Q VGND VGND VPWR VPWR _5817_/A0 sky130_fd_sc_hd__dlygate4sd3_1
XFILLER_26_1385 VGND VGND VPWR VPWR sky130_fd_sc_hd__decap_3
XFILLER_22_1227 VGND VGND VPWR VPWR sky130_fd_sc_hd__decap_3
XFILLER_6_1468 VGND VGND VPWR VPWR sky130_fd_sc_hd__fill_1
XFILLER_61_1287 VGND VGND VPWR VPWR sky130_fd_sc_hd__fill_1
XFILLER_61_1298 VGND VGND VPWR VPWR sky130_fd_sc_hd__decap_3
XFILLER_66_686 VGND VGND VPWR VPWR sky130_fd_sc_hd__fill_1
XFILLER_80_100 VGND VGND VPWR VPWR sky130_fd_sc_hd__decap_3
XFILLER_4_1170 VGND VGND VPWR VPWR sky130_fd_sc_hd__decap_3
XFILLER_53_314 VGND VGND VPWR VPWR sky130_fd_sc_hd__fill_1
XFILLER_0_1012 VGND VGND VPWR VPWR sky130_fd_sc_hd__decap_3
XFILLER_26_539 VGND VGND VPWR VPWR sky130_fd_sc_hd__fill_1
X_6973_ _7034_/CLK _6973_/D fanout672/X VGND VGND VPWR VPWR _6973_/Q sky130_fd_sc_hd__dfrtp_2
XFILLER_80_122 VGND VGND VPWR VPWR sky130_fd_sc_hd__decap_3
XFILLER_80_144 VGND VGND VPWR VPWR sky130_fd_sc_hd__fill_1
XFILLER_0_81 VGND VGND VPWR VPWR sky130_fd_sc_hd__decap_3
X_5924_ _5924_/A _5924_/B _5924_/C VGND VGND VPWR VPWR _5932_/S sky130_fd_sc_hd__or3_2
XFILLER_59_1172 VGND VGND VPWR VPWR sky130_fd_sc_hd__decap_3
XFILLER_59_1183 VGND VGND VPWR VPWR sky130_fd_sc_hd__decap_3
XFILLER_0_1089 VGND VGND VPWR VPWR sky130_fd_sc_hd__decap_3
XFILLER_22_712 VGND VGND VPWR VPWR sky130_fd_sc_hd__fill_1
XFILLER_34_572 VGND VGND VPWR VPWR sky130_fd_sc_hd__fill_1
XFILLER_21_200 VGND VGND VPWR VPWR sky130_fd_sc_hd__decap_3
X_5855_ _5855_/A0 _5929_/A0 _5856_/S VGND VGND VPWR VPWR _6870_/D sky130_fd_sc_hd__mux2_1
XFILLER_72_1350 VGND VGND VPWR VPWR sky130_fd_sc_hd__decap_3
XFILLER_22_767 VGND VGND VPWR VPWR sky130_fd_sc_hd__fill_2
XFILLER_33_1301 VGND VGND VPWR VPWR sky130_fd_sc_hd__decap_3
X_4806_ _6330_/Q _4863_/A2 _4803_/X _4805_/X VGND VGND VPWR VPWR _6330_/D sky130_fd_sc_hd__o22a_2
X_5786_ _5786_/A _5868_/C VGND VGND VPWR VPWR _5850_/B sky130_fd_sc_hd__or2_2
XFILLER_33_1334 VGND VGND VPWR VPWR sky130_fd_sc_hd__decap_3
XFILLER_72_1394 VGND VGND VPWR VPWR sky130_fd_sc_hd__decap_3
XFILLER_33_1345 VGND VGND VPWR VPWR sky130_fd_sc_hd__decap_3
X_4737_ _6321_/Q _4745_/A2 _4734_/X _4736_/X VGND VGND VPWR VPWR _6321_/D sky130_fd_sc_hd__o22a_2
XFILLER_33_1378 VGND VGND VPWR VPWR sky130_fd_sc_hd__decap_3
X_4668_ _6552_/Q _4710_/A _4885_/B1 VGND VGND VPWR VPWR _4668_/X sky130_fd_sc_hd__a21bo_2
XFILLER_79_18 VGND VGND VPWR VPWR sky130_fd_sc_hd__decap_3
XTAP_TAPCELL_ROW_77_2192 VGND VPWR sky130_fd_sc_hd__tapvpwrvgnd_1
X_6407_ _7065_/CLK _6407_/D load_slew736/X VGND VGND VPWR VPWR _6407_/Q sky130_fd_sc_hd__dfrtp_2
X_3619_ _6240_/Q _3631_/A2 _3630_/C1 _6320_/Q _3618_/X VGND VGND VPWR VPWR _3619_/X
+ sky130_fd_sc_hd__a221o_2
Xhold930 _6142_/Q VGND VGND VPWR VPWR hold930/X sky130_fd_sc_hd__dlygate4sd3_1
Xhold941 _6199_/Q VGND VGND VPWR VPWR hold941/X sky130_fd_sc_hd__dlygate4sd3_1
X_4599_ _6880_/Q _4774_/A2 wire36/A _4598_/X VGND VGND VPWR VPWR _4599_/X sky130_fd_sc_hd__a211o_2
Xhold952 _6131_/Q VGND VGND VPWR VPWR hold952/X sky130_fd_sc_hd__dlygate4sd3_1
Xhold963 _6146_/Q VGND VGND VPWR VPWR hold963/X sky130_fd_sc_hd__dlygate4sd3_1
X_6338_ _7015_/CLK _6338_/D fanout797/X VGND VGND VPWR VPWR _6338_/Q sky130_fd_sc_hd__dfrtp_2
Xhold974 _6101_/Q VGND VGND VPWR VPWR hold974/X sky130_fd_sc_hd__dlygate4sd3_1
XTAP_TAPCELL_ROW_73_2089 VGND VPWR sky130_fd_sc_hd__tapvpwrvgnd_1
Xhold985 _6127_/Q VGND VGND VPWR VPWR hold985/X sky130_fd_sc_hd__dlygate4sd3_1
XFILLER_66_1165 VGND VGND VPWR VPWR sky130_fd_sc_hd__decap_3
Xhold996 _6061_/X VGND VGND VPWR VPWR _7065_/D sky130_fd_sc_hd__dlygate4sd3_1
XFILLER_0_137 VGND VGND VPWR VPWR sky130_fd_sc_hd__decap_3
XFILLER_27_1138 VGND VGND VPWR VPWR sky130_fd_sc_hd__decap_3
XFILLER_77_918 VGND VGND VPWR VPWR sky130_fd_sc_hd__decap_3
X_6269_ _6959_/CLK _6269_/D load_slew760/X VGND VGND VPWR VPWR _6269_/Q sky130_fd_sc_hd__dfrtp_2
XFILLER_66_1198 VGND VGND VPWR VPWR sky130_fd_sc_hd__decap_3
XFILLER_0_159 VGND VGND VPWR VPWR sky130_fd_sc_hd__decap_3
XFILLER_44_1441 VGND VGND VPWR VPWR sky130_fd_sc_hd__decap_3
XFILLER_48_119 VGND VGND VPWR VPWR sky130_fd_sc_hd__decap_3
XTAP_TAPCELL_ROW_32_1030 VGND VPWR sky130_fd_sc_hd__tapvpwrvgnd_1
XTAP_TAPCELL_ROW_32_1041 VGND VPWR sky130_fd_sc_hd__tapvpwrvgnd_1
XFILLER_28_55 VGND VGND VPWR VPWR sky130_fd_sc_hd__decap_3
XFILLER_40_1338 VGND VGND VPWR VPWR sky130_fd_sc_hd__decap_3
XFILLER_56_141 VGND VGND VPWR VPWR sky130_fd_sc_hd__decap_3
XFILLER_72_601 VGND VGND VPWR VPWR sky130_fd_sc_hd__fill_2
XFILLER_29_377 VGND VGND VPWR VPWR sky130_fd_sc_hd__decap_3
XFILLER_44_303 VGND VGND VPWR VPWR sky130_fd_sc_hd__decap_3
XFILLER_17_528 VGND VGND VPWR VPWR sky130_fd_sc_hd__decap_3
XFILLER_28_99 VGND VGND VPWR VPWR sky130_fd_sc_hd__decap_3
XFILLER_45_837 VGND VGND VPWR VPWR sky130_fd_sc_hd__decap_3
XFILLER_29_399 VGND VGND VPWR VPWR sky130_fd_sc_hd__decap_3
XFILLER_72_645 VGND VGND VPWR VPWR sky130_fd_sc_hd__decap_3
XFILLER_71_122 VGND VGND VPWR VPWR sky130_fd_sc_hd__decap_3
XFILLER_44_21 VGND VGND VPWR VPWR sky130_fd_sc_hd__fill_2
XFILLER_60_807 VGND VGND VPWR VPWR sky130_fd_sc_hd__decap_3
XFILLER_72_678 VGND VGND VPWR VPWR sky130_fd_sc_hd__decap_3
XFILLER_77_1272 VGND VGND VPWR VPWR sky130_fd_sc_hd__decap_3
XFILLER_25_561 VGND VGND VPWR VPWR sky130_fd_sc_hd__decap_3
XFILLER_44_54 VGND VGND VPWR VPWR sky130_fd_sc_hd__decap_3
XFILLER_13_723 VGND VGND VPWR VPWR sky130_fd_sc_hd__decap_3
XFILLER_38_1245 VGND VGND VPWR VPWR sky130_fd_sc_hd__decap_3
XFILLER_73_1136 VGND VGND VPWR VPWR sky130_fd_sc_hd__decap_3
XFILLER_52_380 VGND VGND VPWR VPWR sky130_fd_sc_hd__decap_3
XFILLER_38_1267 VGND VGND VPWR VPWR sky130_fd_sc_hd__decap_3
XFILLER_73_1169 VGND VGND VPWR VPWR sky130_fd_sc_hd__decap_3
XFILLER_9_716 VGND VGND VPWR VPWR sky130_fd_sc_hd__decap_3
XFILLER_51_1401 VGND VGND VPWR VPWR sky130_fd_sc_hd__decap_3
XFILLER_51_1434 VGND VGND VPWR VPWR sky130_fd_sc_hd__decap_3
XTAP_TAPCELL_ROW_23_795 VGND VPWR sky130_fd_sc_hd__tapvpwrvgnd_1
XFILLER_12_1418 VGND VGND VPWR VPWR sky130_fd_sc_hd__decap_3
XFILLER_12_1429 VGND VGND VPWR VPWR sky130_fd_sc_hd__decap_3
XFILLER_5_900 VGND VGND VPWR VPWR sky130_fd_sc_hd__decap_3
XTAP_TAPCELL_ROW_10_456 VGND VPWR sky130_fd_sc_hd__tapvpwrvgnd_1
XTAP_TAPCELL_ROW_10_467 VGND VPWR sky130_fd_sc_hd__tapvpwrvgnd_1
XTAP_TAPCELL_ROW_39_1206 VGND VPWR sky130_fd_sc_hd__tapvpwrvgnd_1
XFILLER_5_15 VGND VGND VPWR VPWR sky130_fd_sc_hd__decap_3
XFILLER_4_421 VGND VGND VPWR VPWR sky130_fd_sc_hd__decap_3
XTAP_TAPCELL_ROW_39_1217 VGND VPWR sky130_fd_sc_hd__tapvpwrvgnd_1
XFILLER_4_443 VGND VGND VPWR VPWR sky130_fd_sc_hd__decap_3
XFILLER_5_48 VGND VGND VPWR VPWR sky130_fd_sc_hd__decap_3
XFILLER_10_1164 VGND VGND VPWR VPWR sky130_fd_sc_hd__decap_3
XFILLER_49_1363 VGND VGND VPWR VPWR sky130_fd_sc_hd__decap_3
XFILLER_69_51 VGND VGND VPWR VPWR sky130_fd_sc_hd__decap_3
XFILLER_10_1197 VGND VGND VPWR VPWR sky130_fd_sc_hd__decap_3
XFILLER_49_1396 VGND VGND VPWR VPWR sky130_fd_sc_hd__decap_3
XFILLER_68_907 VGND VGND VPWR VPWR sky130_fd_sc_hd__decap_3
XFILLER_0_660 VGND VGND VPWR VPWR sky130_fd_sc_hd__decap_3
XFILLER_0_682 VGND VGND VPWR VPWR sky130_fd_sc_hd__decap_3
XFILLER_76_951 VGND VGND VPWR VPWR sky130_fd_sc_hd__fill_2
XFILLER_48_642 VGND VGND VPWR VPWR sky130_fd_sc_hd__fill_2
XPHY_EDGE_ROW_13_Right_13 VGND VGND VPWR VPWR sky130_fd_sc_hd__decap_3
XFILLER_47_152 VGND VGND VPWR VPWR sky130_fd_sc_hd__decap_3
XFILLER_48_675 VGND VGND VPWR VPWR sky130_fd_sc_hd__decap_3
XFILLER_1_1310 VGND VGND VPWR VPWR sky130_fd_sc_hd__decap_3
XFILLER_21_1260 VGND VGND VPWR VPWR sky130_fd_sc_hd__decap_3
XFILLER_1_1343 VGND VGND VPWR VPWR sky130_fd_sc_hd__fill_1
XFILLER_1_1354 VGND VGND VPWR VPWR sky130_fd_sc_hd__decap_3
XFILLER_35_358 VGND VGND VPWR VPWR sky130_fd_sc_hd__decap_3
X_3970_ _3340_/X _4743_/B2 _4744_/A2 _6867_/Q _4092_/C1 VGND VGND VPWR VPWR _3970_/X
+ sky130_fd_sc_hd__a221o_2
XFILLER_56_1312 VGND VGND VPWR VPWR sky130_fd_sc_hd__decap_3
XFILLER_62_155 VGND VGND VPWR VPWR sky130_fd_sc_hd__fill_2
XFILLER_16_561 VGND VGND VPWR VPWR sky130_fd_sc_hd__decap_3
XFILLER_51_829 VGND VGND VPWR VPWR sky130_fd_sc_hd__decap_3
XFILLER_1_1387 VGND VGND VPWR VPWR sky130_fd_sc_hd__decap_3
XFILLER_56_1323 VGND VGND VPWR VPWR sky130_fd_sc_hd__decap_3
XFILLER_17_1307 VGND VGND VPWR VPWR sky130_fd_sc_hd__decap_3
XFILLER_56_1356 VGND VGND VPWR VPWR sky130_fd_sc_hd__decap_3
XFILLER_43_391 VGND VGND VPWR VPWR sky130_fd_sc_hd__fill_1
XFILLER_31_553 VGND VGND VPWR VPWR sky130_fd_sc_hd__decap_3
X_5640_ _5749_/A _5722_/A _7067_/Q _5685_/C VGND VGND VPWR VPWR wire92/A sky130_fd_sc_hd__or4b_2
XFILLER_15_1020 VGND VGND VPWR VPWR sky130_fd_sc_hd__decap_3
XFILLER_15_1031 VGND VGND VPWR VPWR sky130_fd_sc_hd__decap_3
XPHY_EDGE_ROW_22_Right_22 VGND VGND VPWR VPWR sky130_fd_sc_hd__decap_3
X_5571_ _5577_/A wire23/X VGND VGND VPWR VPWR _5572_/A sky130_fd_sc_hd__nand2_2
XFILLER_8_760 VGND VGND VPWR VPWR sky130_fd_sc_hd__fill_2
X_4522_ _6862_/Q wire295/X _4876_/B1 _4521_/X VGND VGND VPWR VPWR _4522_/X sky130_fd_sc_hd__a211o_2
XFILLER_15_1097 VGND VGND VPWR VPWR sky130_fd_sc_hd__decap_3
XFILLER_7_281 VGND VGND VPWR VPWR sky130_fd_sc_hd__decap_3
X_4453_ _4534_/B _4808_/B VGND VGND VPWR VPWR _4453_/Y sky130_fd_sc_hd__nor2_2
X_3404_ _6233_/Q _6433_/Q VGND VGND VPWR VPWR _3404_/X sky130_fd_sc_hd__xor2_2
XFILLER_28_1403 VGND VGND VPWR VPWR sky130_fd_sc_hd__decap_3
XFILLER_67_1452 VGND VGND VPWR VPWR sky130_fd_sc_hd__decap_3
X_4384_ _6844_/Q _4744_/A2 _4766_/B1 _4383_/X VGND VGND VPWR VPWR _4384_/X sky130_fd_sc_hd__a211o_2
XFILLER_67_1463 VGND VGND VPWR VPWR sky130_fd_sc_hd__decap_3
Xfanout706 fanout708/X VGND VGND VPWR VPWR fanout706/X sky130_fd_sc_hd__clkdlybuf4s25_1
XFILLER_63_1316 VGND VGND VPWR VPWR sky130_fd_sc_hd__decap_3
XFILLER_28_1447 VGND VGND VPWR VPWR sky130_fd_sc_hd__decap_3
X_6123_ _7009_/CLK _6123_/D wire764/A VGND VGND VPWR VPWR _6123_/Q sky130_fd_sc_hd__dfrtp_2
Xfanout717 fanout740/X VGND VGND VPWR VPWR fanout717/X sky130_fd_sc_hd__clkdlybuf4s25_1
X_3335_ _5988_/A0 _3334_/X _3463_/S VGND VGND VPWR VPWR _6141_/D sky130_fd_sc_hd__mux2_1
Xfanout739 fanout740/X VGND VGND VPWR VPWR fanout739/X sky130_fd_sc_hd__clkdlybuf4s25_1
X_6054_ _6054_/A0 _7058_/Q _6061_/S VGND VGND VPWR VPWR _6054_/X sky130_fd_sc_hd__mux2_1
X_3266_ _6268_/Q _6364_/Q VGND VGND VPWR VPWR _3266_/X sky130_fd_sc_hd__xor2_2
XPHY_EDGE_ROW_31_Right_31 VGND VGND VPWR VPWR sky130_fd_sc_hd__decap_3
XFILLER_6_1232 VGND VGND VPWR VPWR sky130_fd_sc_hd__decap_3
XFILLER_22_1002 VGND VGND VPWR VPWR sky130_fd_sc_hd__decap_3
X_5005_ _6696_/Q _3062_/Y _5178_/B VGND VGND VPWR VPWR _5005_/X sky130_fd_sc_hd__mux2_1
XFILLER_39_642 VGND VGND VPWR VPWR sky130_fd_sc_hd__decap_3
XFILLER_22_1035 VGND VGND VPWR VPWR sky130_fd_sc_hd__fill_1
XFILLER_38_141 VGND VGND VPWR VPWR sky130_fd_sc_hd__decap_3
XFILLER_61_1084 VGND VGND VPWR VPWR sky130_fd_sc_hd__decap_3
X_3197_ _6984_/Q _6992_/Q _3206_/S VGND VGND VPWR VPWR _3197_/X sky130_fd_sc_hd__mux2_1
XFILLER_6_1276 VGND VGND VPWR VPWR sky130_fd_sc_hd__decap_3
XFILLER_2_1129 VGND VGND VPWR VPWR sky130_fd_sc_hd__decap_3
XFILLER_27_837 VGND VGND VPWR VPWR sky130_fd_sc_hd__decap_3
XFILLER_66_472 VGND VGND VPWR VPWR sky130_fd_sc_hd__decap_3
XFILLER_54_623 VGND VGND VPWR VPWR sky130_fd_sc_hd__decap_3
XFILLER_66_483 VGND VGND VPWR VPWR sky130_fd_sc_hd__decap_3
XFILLER_54_645 VGND VGND VPWR VPWR sky130_fd_sc_hd__decap_3
XFILLER_53_122 VGND VGND VPWR VPWR sky130_fd_sc_hd__decap_3
XFILLER_26_358 VGND VGND VPWR VPWR sky130_fd_sc_hd__decap_3
XFILLER_74_1412 VGND VGND VPWR VPWR sky130_fd_sc_hd__decap_3
X_6956_ _7012_/CLK _6956_/D load_slew810/X VGND VGND VPWR VPWR _6956_/Q sky130_fd_sc_hd__dfrtp_2
X_5907_ _5907_/A0 _5907_/A1 _5913_/S VGND VGND VPWR VPWR _6914_/D sky130_fd_sc_hd__mux2_1
XFILLER_74_1456 VGND VGND VPWR VPWR sky130_fd_sc_hd__decap_3
XFILLER_35_1407 VGND VGND VPWR VPWR sky130_fd_sc_hd__decap_3
XFILLER_22_531 VGND VGND VPWR VPWR sky130_fd_sc_hd__fill_1
X_6887_ _7022_/CLK _6887_/D load_slew748/X VGND VGND VPWR VPWR _6887_/Q sky130_fd_sc_hd__dfrtp_2
XFILLER_70_1309 VGND VGND VPWR VPWR sky130_fd_sc_hd__decap_3
XFILLER_14_35 VGND VGND VPWR VPWR sky130_fd_sc_hd__decap_3
XFILLER_22_564 VGND VGND VPWR VPWR sky130_fd_sc_hd__fill_1
X_5838_ _5912_/A0 _5838_/A1 _5840_/S VGND VGND VPWR VPWR _6855_/D sky130_fd_sc_hd__mux2_1
XPHY_EDGE_ROW_40_Right_40 VGND VGND VPWR VPWR sky130_fd_sc_hd__decap_3
XFILLER_50_884 VGND VGND VPWR VPWR sky130_fd_sc_hd__fill_2
XFILLER_10_726 VGND VGND VPWR VPWR sky130_fd_sc_hd__decap_3
XTAP_TAPCELL_ROW_20_710 VGND VPWR sky130_fd_sc_hd__tapvpwrvgnd_1
XTAP_TAPCELL_ROW_79_2243 VGND VPWR sky130_fd_sc_hd__tapvpwrvgnd_1
XTAP_TAPCELL_ROW_20_721 VGND VPWR sky130_fd_sc_hd__tapvpwrvgnd_1
XFILLER_72_1191 VGND VGND VPWR VPWR sky130_fd_sc_hd__decap_3
XTAP_TAPCELL_ROW_20_732 VGND VPWR sky130_fd_sc_hd__tapvpwrvgnd_1
XTAP_TAPCELL_ROW_79_2254 VGND VPWR sky130_fd_sc_hd__tapvpwrvgnd_1
X_5769_ _5769_/A _6085_/C VGND VGND VPWR VPWR _5786_/A sky130_fd_sc_hd__or2_2
XTAP_TAPCELL_ROW_79_2265 VGND VPWR sky130_fd_sc_hd__tapvpwrvgnd_1
XFILLER_33_1175 VGND VGND VPWR VPWR sky130_fd_sc_hd__fill_1
XFILLER_30_12 VGND VGND VPWR VPWR sky130_fd_sc_hd__decap_3
XPHY_EDGE_ROW_12_Left_93 VGND VGND VPWR VPWR sky130_fd_sc_hd__decap_3
XFILLER_68_1205 VGND VGND VPWR VPWR sky130_fd_sc_hd__decap_3
XFILLER_11_1440 VGND VGND VPWR VPWR sky130_fd_sc_hd__decap_3
XFILLER_30_67 VGND VGND VPWR VPWR sky130_fd_sc_hd__decap_3
XFILLER_68_1238 VGND VGND VPWR VPWR sky130_fd_sc_hd__decap_3
XFILLER_2_914 VGND VGND VPWR VPWR sky130_fd_sc_hd__decap_3
XFILLER_2_925 VGND VGND VPWR VPWR sky130_fd_sc_hd__decap_3
XFILLER_1_402 VGND VGND VPWR VPWR sky130_fd_sc_hd__decap_3
XFILLER_2_958 VGND VGND VPWR VPWR sky130_fd_sc_hd__decap_3
XFILLER_1_446 VGND VGND VPWR VPWR sky130_fd_sc_hd__fill_2
XFILLER_77_726 VGND VGND VPWR VPWR sky130_fd_sc_hd__fill_2
XFILLER_39_54 VGND VGND VPWR VPWR sky130_fd_sc_hd__fill_2
XFILLER_77_737 VGND VGND VPWR VPWR sky130_fd_sc_hd__decap_3
XFILLER_49_428 VGND VGND VPWR VPWR sky130_fd_sc_hd__decap_3
XFILLER_76_225 VGND VGND VPWR VPWR sky130_fd_sc_hd__fill_1
XFILLER_44_1282 VGND VGND VPWR VPWR sky130_fd_sc_hd__decap_3
XFILLER_79_1301 VGND VGND VPWR VPWR sky130_fd_sc_hd__decap_3
Xhold1460 _6564_/Q VGND VGND VPWR VPWR _5452_/A1 sky130_fd_sc_hd__dlygate4sd3_1
XFILLER_57_461 VGND VGND VPWR VPWR sky130_fd_sc_hd__fill_2
XFILLER_79_1334 VGND VGND VPWR VPWR sky130_fd_sc_hd__decap_3
Xhold1471 _6561_/Q VGND VGND VPWR VPWR _5449_/A1 sky130_fd_sc_hd__dlygate4sd3_1
XTAP_TAPCELL_ROW_4_295 VGND VPWR sky130_fd_sc_hd__tapvpwrvgnd_1
XFILLER_79_1345 VGND VGND VPWR VPWR sky130_fd_sc_hd__decap_3
XFILLER_17_325 VGND VGND VPWR VPWR sky130_fd_sc_hd__decap_3
Xhold1482 _6530_/Q VGND VGND VPWR VPWR _5418_/A1 sky130_fd_sc_hd__dlygate4sd3_1
Xhold1493 _6532_/Q VGND VGND VPWR VPWR _5420_/A1 sky130_fd_sc_hd__dlygate4sd3_1
XFILLER_40_1179 VGND VGND VPWR VPWR sky130_fd_sc_hd__decap_3
XFILLER_55_42 VGND VGND VPWR VPWR sky130_fd_sc_hd__decap_3
XFILLER_29_196 VGND VGND VPWR VPWR sky130_fd_sc_hd__decap_3
XFILLER_79_1378 VGND VGND VPWR VPWR sky130_fd_sc_hd__decap_3
XTAP_TAPCELL_ROW_68_1980 VGND VPWR sky130_fd_sc_hd__tapvpwrvgnd_1
XFILLER_32_317 VGND VGND VPWR VPWR sky130_fd_sc_hd__decap_3
XFILLER_38_1020 VGND VGND VPWR VPWR sky130_fd_sc_hd__decap_3
XFILLER_77_1080 VGND VGND VPWR VPWR sky130_fd_sc_hd__decap_3
XFILLER_60_648 VGND VGND VPWR VPWR sky130_fd_sc_hd__decap_3
XFILLER_13_520 VGND VGND VPWR VPWR sky130_fd_sc_hd__decap_3
XTAP_TAPCELL_ROW_64_1855 VGND VPWR sky130_fd_sc_hd__tapvpwrvgnd_1
XFILLER_25_391 VGND VGND VPWR VPWR sky130_fd_sc_hd__fill_1
XTAP_TAPCELL_ROW_64_1866 VGND VPWR sky130_fd_sc_hd__tapvpwrvgnd_1
XFILLER_71_30 VGND VGND VPWR VPWR sky130_fd_sc_hd__decap_3
XTAP_TAPCELL_ROW_64_1877 VGND VPWR sky130_fd_sc_hd__tapvpwrvgnd_1
XFILLER_13_564 VGND VGND VPWR VPWR sky130_fd_sc_hd__decap_3
XFILLER_41_873 VGND VGND VPWR VPWR sky130_fd_sc_hd__decap_3
XFILLER_16_1362 VGND VGND VPWR VPWR sky130_fd_sc_hd__decap_3
XFILLER_51_1242 VGND VGND VPWR VPWR sky130_fd_sc_hd__decap_3
XFILLER_72_9 VGND VGND VPWR VPWR sky130_fd_sc_hd__decap_3
XFILLER_16_1373 VGND VGND VPWR VPWR sky130_fd_sc_hd__decap_3
XFILLER_12_1226 VGND VGND VPWR VPWR sky130_fd_sc_hd__decap_3
XFILLER_51_1275 VGND VGND VPWR VPWR sky130_fd_sc_hd__decap_3
XFILLER_12_1259 VGND VGND VPWR VPWR sky130_fd_sc_hd__fill_1
XFILLER_4_251 VGND VGND VPWR VPWR sky130_fd_sc_hd__fill_1
XFILLER_5_785 VGND VGND VPWR VPWR sky130_fd_sc_hd__decap_3
XFILLER_45_1035 VGND VGND VPWR VPWR sky130_fd_sc_hd__decap_3
XFILLER_1_980 VGND VGND VPWR VPWR sky130_fd_sc_hd__decap_3
X_3120_ _6076_/A1 _3118_/X _3119_/X _3205_/B1 VGND VGND VPWR VPWR _3120_/X sky130_fd_sc_hd__a211o_2
XFILLER_67_225 VGND VGND VPWR VPWR sky130_fd_sc_hd__fill_1
XFILLER_45_1079 VGND VGND VPWR VPWR sky130_fd_sc_hd__fill_2
XFILLER_23_1322 VGND VGND VPWR VPWR sky130_fd_sc_hd__decap_3
XFILLER_49_951 VGND VGND VPWR VPWR sky130_fd_sc_hd__fill_1
XFILLER_62_1371 VGND VGND VPWR VPWR sky130_fd_sc_hd__fill_1
XFILLER_49_962 VGND VGND VPWR VPWR sky130_fd_sc_hd__fill_2
XFILLER_62_1382 VGND VGND VPWR VPWR sky130_fd_sc_hd__decap_3
X_3051_ _6347_/Q VGND VGND VPWR VPWR _3051_/Y sky130_fd_sc_hd__inv_2
XFILLER_55_409 VGND VGND VPWR VPWR sky130_fd_sc_hd__decap_3
XFILLER_3_1416 VGND VGND VPWR VPWR sky130_fd_sc_hd__decap_3
XFILLER_76_781 VGND VGND VPWR VPWR sky130_fd_sc_hd__decap_3
XFILLER_23_1366 VGND VGND VPWR VPWR sky130_fd_sc_hd__decap_3
XFILLER_3_1449 VGND VGND VPWR VPWR sky130_fd_sc_hd__decap_3
XFILLER_23_1399 VGND VGND VPWR VPWR sky130_fd_sc_hd__fill_1
XFILLER_36_656 VGND VGND VPWR VPWR sky130_fd_sc_hd__decap_3
XFILLER_58_1418 VGND VGND VPWR VPWR sky130_fd_sc_hd__decap_3
XFILLER_58_1429 VGND VGND VPWR VPWR sky130_fd_sc_hd__decap_3
X_6810_ _6954_/CLK _6810_/D load_slew674/X VGND VGND VPWR VPWR _6810_/Q sky130_fd_sc_hd__dfrtp_2
XFILLER_1_1151 VGND VGND VPWR VPWR sky130_fd_sc_hd__decap_3
XFILLER_17_870 VGND VGND VPWR VPWR sky130_fd_sc_hd__decap_3
XFILLER_51_626 VGND VGND VPWR VPWR sky130_fd_sc_hd__decap_3
XFILLER_1_1195 VGND VGND VPWR VPWR sky130_fd_sc_hd__decap_3
XFILLER_56_1131 VGND VGND VPWR VPWR sky130_fd_sc_hd__decap_3
X_6741_ _7092_/CLK _6741_/D fanout676/X VGND VGND VPWR VPWR _6741_/Q sky130_fd_sc_hd__dfrtp_2
XFILLER_51_659 VGND VGND VPWR VPWR sky130_fd_sc_hd__fill_2
X_3953_ _3933_/A _4101_/B _3939_/X _4779_/A1 VGND VGND VPWR VPWR _3953_/X sky130_fd_sc_hd__o2bb2a_2
XFILLER_32_862 VGND VGND VPWR VPWR sky130_fd_sc_hd__fill_1
X_3884_ _3884_/A _3938_/B VGND VGND VPWR VPWR _3886_/B sky130_fd_sc_hd__xor2_2
X_6672_ _6925_/CLK _6672_/D wire655/X VGND VGND VPWR VPWR _6672_/Q sky130_fd_sc_hd__dfrtp_2
XFILLER_31_361 VGND VGND VPWR VPWR sky130_fd_sc_hd__fill_2
XTAP_TAPCELL_ROW_14_570 VGND VPWR sky130_fd_sc_hd__tapvpwrvgnd_1
X_5623_ hold888/X _5928_/A0 _5626_/S VGND VGND VPWR VPWR _6685_/D sky130_fd_sc_hd__mux2_1
XFILLER_34_1462 VGND VGND VPWR VPWR sky130_fd_sc_hd__decap_3
XFILLER_30_1315 VGND VGND VPWR VPWR sky130_fd_sc_hd__fill_1
XFILLER_30_1326 VGND VGND VPWR VPWR sky130_fd_sc_hd__decap_3
X_5554_ _6355_/Q _5501_/B _5554_/B1 _5562_/B2 VGND VGND VPWR VPWR _6637_/D sky130_fd_sc_hd__a22o_2
XFILLER_30_1359 VGND VGND VPWR VPWR sky130_fd_sc_hd__decap_3
X_4505_ _4526_/B _4294_/Y _4504_/Y _4647_/A1 VGND VGND VPWR VPWR _4506_/C sky130_fd_sc_hd__o211ai_2
X_5485_ _5485_/A1 _5485_/A2 _4091_/X VGND VGND VPWR VPWR _6597_/D sky130_fd_sc_hd__a21o_2
X_4436_ _6280_/Q wire49/X _4433_/X _4435_/X VGND VGND VPWR VPWR _6280_/D sky130_fd_sc_hd__o22a_2
XTAP_TAPCELL_ROW_70_2015 VGND VPWR sky130_fd_sc_hd__tapvpwrvgnd_1
XFILLER_67_1260 VGND VGND VPWR VPWR sky130_fd_sc_hd__decap_3
XTAP_TAPCELL_ROW_70_2026 VGND VPWR sky130_fd_sc_hd__tapvpwrvgnd_1
X_4367_ _6272_/Q wire54/X _4364_/X _4366_/X VGND VGND VPWR VPWR _6272_/D sky130_fd_sc_hd__o22a_2
Xfanout514 _7085_/Q VGND VGND VPWR VPWR wire515/A sky130_fd_sc_hd__clkdlybuf4s25_1
XFILLER_28_1255 VGND VGND VPWR VPWR sky130_fd_sc_hd__decap_3
Xfanout525 _5306_/S VGND VGND VPWR VPWR _5216_/A sky130_fd_sc_hd__clkdlybuf4s25_1
XFILLER_63_1135 VGND VGND VPWR VPWR sky130_fd_sc_hd__decap_3
XFILLER_59_726 VGND VGND VPWR VPWR sky130_fd_sc_hd__fill_2
XFILLER_8_1338 VGND VGND VPWR VPWR sky130_fd_sc_hd__decap_3
Xfanout547 _7083_/Q VGND VGND VPWR VPWR _5336_/S sky130_fd_sc_hd__clkdlybuf4s25_1
X_3318_ _6286_/Q _6390_/Q VGND VGND VPWR VPWR _3318_/X sky130_fd_sc_hd__xor2_2
X_6106_ clkload8/A _6106_/D load_slew637/X VGND VGND VPWR VPWR _6106_/Q sky130_fd_sc_hd__dfrtp_2
XFILLER_63_1168 VGND VGND VPWR VPWR sky130_fd_sc_hd__decap_3
XFILLER_28_1288 VGND VGND VPWR VPWR sky130_fd_sc_hd__decap_3
Xfanout558 _3203_/S VGND VGND VPWR VPWR _6075_/S sky130_fd_sc_hd__clkdlybuf4s25_1
X_7086_ _7090_/CLK _7086_/D load_slew723/X VGND VGND VPWR VPWR _7086_/Q sky130_fd_sc_hd__dfrtp_2
X_4298_ _6828_/Q _4862_/A2 _4862_/B1 _4297_/X VGND VGND VPWR VPWR _4298_/X sky130_fd_sc_hd__a211o_2
Xfanout569 _5801_/A_N VGND VGND VPWR VPWR _6069_/S sky130_fd_sc_hd__clkdlybuf4s25_1
XFILLER_80_1460 VGND VGND VPWR VPWR sky130_fd_sc_hd__decap_3
XFILLER_41_1422 VGND VGND VPWR VPWR sky130_fd_sc_hd__decap_3
X_3249_ hold971/X _3248_/X _3457_/S VGND VGND VPWR VPWR _6098_/D sky130_fd_sc_hd__mux2_1
X_6037_ hold994/X _6037_/A1 _6053_/S VGND VGND VPWR VPWR _7041_/D sky130_fd_sc_hd__mux2_1
XFILLER_74_729 VGND VGND VPWR VPWR sky130_fd_sc_hd__decap_3
XFILLER_41_1455 VGND VGND VPWR VPWR sky130_fd_sc_hd__fill_1
XFILLER_6_1084 VGND VGND VPWR VPWR sky130_fd_sc_hd__decap_3
XFILLER_41_1466 VGND VGND VPWR VPWR sky130_fd_sc_hd__decap_3
XTAP_TAPCELL_ROW_1_221 VGND VPWR sky130_fd_sc_hd__tapvpwrvgnd_1
XTAP_TAPCELL_ROW_1_232 VGND VPWR sky130_fd_sc_hd__tapvpwrvgnd_1
XFILLER_25_12 VGND VGND VPWR VPWR sky130_fd_sc_hd__decap_3
XFILLER_54_464 VGND VGND VPWR VPWR sky130_fd_sc_hd__decap_3
XFILLER_55_998 VGND VGND VPWR VPWR sky130_fd_sc_hd__decap_3
XFILLER_74_1220 VGND VGND VPWR VPWR sky130_fd_sc_hd__decap_3
XFILLER_70_946 VGND VGND VPWR VPWR sky130_fd_sc_hd__decap_3
XFILLER_39_1340 VGND VGND VPWR VPWR sky130_fd_sc_hd__decap_3
XFILLER_39_1351 VGND VGND VPWR VPWR sky130_fd_sc_hd__decap_3
XFILLER_42_648 VGND VGND VPWR VPWR sky130_fd_sc_hd__decap_3
XTAP_TAPCELL_ROW_25_846 VGND VPWR sky130_fd_sc_hd__tapvpwrvgnd_1
X_6939_ _7035_/CLK _6939_/D load_slew843/X VGND VGND VPWR VPWR _6939_/Q sky130_fd_sc_hd__dfrtp_2
XTAP_TAPCELL_ROW_25_857 VGND VPWR sky130_fd_sc_hd__tapvpwrvgnd_1
XFILLER_74_1253 VGND VGND VPWR VPWR sky130_fd_sc_hd__decap_3
XFILLER_74_1264 VGND VGND VPWR VPWR sky130_fd_sc_hd__decap_3
XFILLER_23_862 VGND VGND VPWR VPWR sky130_fd_sc_hd__decap_3
XFILLER_39_1384 VGND VGND VPWR VPWR sky130_fd_sc_hd__decap_3
XTAP_TAPCELL_ROW_12_507 VGND VPWR sky130_fd_sc_hd__tapvpwrvgnd_1
XFILLER_74_1297 VGND VGND VPWR VPWR sky130_fd_sc_hd__decap_3
XTAP_TAPCELL_ROW_12_518 VGND VPWR sky130_fd_sc_hd__tapvpwrvgnd_1
XFILLER_35_1248 VGND VGND VPWR VPWR sky130_fd_sc_hd__decap_3
XFILLER_50_670 VGND VGND VPWR VPWR sky130_fd_sc_hd__decap_3
XFILLER_10_567 VGND VGND VPWR VPWR sky130_fd_sc_hd__fill_2
XFILLER_6_516 VGND VGND VPWR VPWR sky130_fd_sc_hd__decap_3
XFILLER_10_589 VGND VGND VPWR VPWR sky130_fd_sc_hd__decap_3
XFILLER_41_99 VGND VGND VPWR VPWR sky130_fd_sc_hd__decap_3
XFILLER_68_1035 VGND VGND VPWR VPWR sky130_fd_sc_hd__fill_1
XFILLER_11_1281 VGND VGND VPWR VPWR sky130_fd_sc_hd__decap_3
XFILLER_11_1292 VGND VGND VPWR VPWR sky130_fd_sc_hd__decap_3
XFILLER_2_722 VGND VGND VPWR VPWR sky130_fd_sc_hd__decap_3
XFILLER_68_1068 VGND VGND VPWR VPWR sky130_fd_sc_hd__decap_3
XFILLER_46_1300 VGND VGND VPWR VPWR sky130_fd_sc_hd__decap_3
XFILLER_2_755 VGND VGND VPWR VPWR sky130_fd_sc_hd__fill_1
XTAP_TAPCELL_ROW_57_1670 VGND VPWR sky130_fd_sc_hd__tapvpwrvgnd_1
XTAP_TAPCELL_ROW_57_1681 VGND VPWR sky130_fd_sc_hd__tapvpwrvgnd_1
XFILLER_1_243 VGND VGND VPWR VPWR sky130_fd_sc_hd__decap_3
XFILLER_2_766 VGND VGND VPWR VPWR sky130_fd_sc_hd__fill_1
XTAP_TAPCELL_ROW_57_1692 VGND VPWR sky130_fd_sc_hd__tapvpwrvgnd_1
XFILLER_46_1344 VGND VGND VPWR VPWR sky130_fd_sc_hd__decap_3
XFILLER_2_788 VGND VGND VPWR VPWR sky130_fd_sc_hd__decap_3
XFILLER_1_276 VGND VGND VPWR VPWR sky130_fd_sc_hd__decap_3
XFILLER_1_287 VGND VGND VPWR VPWR sky130_fd_sc_hd__decap_3
XFILLER_2_27 VGND VGND VPWR VPWR sky130_fd_sc_hd__fill_1
XTAP_TAPCELL_ROW_53_1567 VGND VPWR sky130_fd_sc_hd__tapvpwrvgnd_1
XFILLER_2_38 VGND VGND VPWR VPWR sky130_fd_sc_hd__decap_3
XFILLER_46_1388 VGND VGND VPWR VPWR sky130_fd_sc_hd__decap_3
XTAP_TAPCELL_ROW_53_1578 VGND VPWR sky130_fd_sc_hd__tapvpwrvgnd_1
XTAP_TAPCELL_ROW_53_1589 VGND VPWR sky130_fd_sc_hd__tapvpwrvgnd_1
XFILLER_77_556 VGND VGND VPWR VPWR sky130_fd_sc_hd__decap_3
XFILLER_37_409 VGND VGND VPWR VPWR sky130_fd_sc_hd__fill_1
XFILLER_66_41 VGND VGND VPWR VPWR sky130_fd_sc_hd__decap_3
XFILLER_64_206 VGND VGND VPWR VPWR sky130_fd_sc_hd__decap_3
XFILLER_65_729 VGND VGND VPWR VPWR sky130_fd_sc_hd__decap_3
XFILLER_46_921 VGND VGND VPWR VPWR sky130_fd_sc_hd__decap_3
XFILLER_66_74 VGND VGND VPWR VPWR sky130_fd_sc_hd__decap_3
XFILLER_66_85 VGND VGND VPWR VPWR sky130_fd_sc_hd__fill_2
XFILLER_18_645 VGND VGND VPWR VPWR sky130_fd_sc_hd__fill_2
XFILLER_79_1142 VGND VGND VPWR VPWR sky130_fd_sc_hd__decap_3
XFILLER_17_122 VGND VGND VPWR VPWR sky130_fd_sc_hd__fill_1
XTAP_TAPCELL_ROW_66_1906 VGND VPWR sky130_fd_sc_hd__tapvpwrvgnd_1
Xhold1290 _6774_/Q VGND VGND VPWR VPWR _5727_/A1 sky130_fd_sc_hd__dlygate4sd3_1
XTAP_TAPCELL_ROW_66_1917 VGND VPWR sky130_fd_sc_hd__tapvpwrvgnd_1
XTAP_TAPCELL_ROW_66_1928 VGND VPWR sky130_fd_sc_hd__tapvpwrvgnd_1
XFILLER_79_1175 VGND VGND VPWR VPWR sky130_fd_sc_hd__fill_1
XFILLER_75_1006 VGND VGND VPWR VPWR sky130_fd_sc_hd__fill_2
XFILLER_79_1186 VGND VGND VPWR VPWR sky130_fd_sc_hd__decap_3
XFILLER_45_475 VGND VGND VPWR VPWR sky130_fd_sc_hd__decap_3
XFILLER_60_401 VGND VGND VPWR VPWR sky130_fd_sc_hd__decap_3
XFILLER_72_283 VGND VGND VPWR VPWR sky130_fd_sc_hd__fill_1
XFILLER_57_1440 VGND VGND VPWR VPWR sky130_fd_sc_hd__decap_3
XFILLER_14_851 VGND VGND VPWR VPWR sky130_fd_sc_hd__fill_2
XFILLER_53_1304 VGND VGND VPWR VPWR sky130_fd_sc_hd__decap_3
XFILLER_18_1424 VGND VGND VPWR VPWR sky130_fd_sc_hd__decap_3
XFILLER_32_158 VGND VGND VPWR VPWR sky130_fd_sc_hd__decap_3
XFILLER_18_1435 VGND VGND VPWR VPWR sky130_fd_sc_hd__decap_3
XFILLER_20_309 VGND VGND VPWR VPWR sky130_fd_sc_hd__fill_2
XFILLER_53_1337 VGND VGND VPWR VPWR sky130_fd_sc_hd__decap_3
XFILLER_18_1468 VGND VGND VPWR VPWR sky130_fd_sc_hd__fill_1
XFILLER_41_681 VGND VGND VPWR VPWR sky130_fd_sc_hd__decap_3
XFILLER_53_1348 VGND VGND VPWR VPWR sky130_fd_sc_hd__decap_3
XFILLER_9_343 VGND VGND VPWR VPWR sky130_fd_sc_hd__fill_2
XFILLER_9_354 VGND VGND VPWR VPWR sky130_fd_sc_hd__fill_2
XFILLER_40_191 VGND VGND VPWR VPWR sky130_fd_sc_hd__decap_3
XFILLER_70_6 VGND VGND VPWR VPWR sky130_fd_sc_hd__decap_3
XFILLER_12_1012 VGND VGND VPWR VPWR sky130_fd_sc_hd__decap_3
XFILLER_16_1181 VGND VGND VPWR VPWR sky130_fd_sc_hd__fill_2
XFILLER_51_1061 VGND VGND VPWR VPWR sky130_fd_sc_hd__decap_3
X_5270_ _5342_/S _5270_/B VGND VGND VPWR VPWR _5270_/Y sky130_fd_sc_hd__nand2_2
XFILLER_49_3 VGND VGND VPWR VPWR sky130_fd_sc_hd__decap_3
XFILLER_64_1400 VGND VGND VPWR VPWR sky130_fd_sc_hd__decap_3
X_4221_ _4221_/A _4302_/B VGND VGND VPWR VPWR _4223_/A sky130_fd_sc_hd__xnor2_2
XFILLER_64_1444 VGND VGND VPWR VPWR sky130_fd_sc_hd__decap_3
XFILLER_25_1428 VGND VGND VPWR VPWR sky130_fd_sc_hd__decap_3
X_4152_ _4152_/A _4326_/B VGND VGND VPWR VPWR _4153_/B sky130_fd_sc_hd__xnor2_2
X_3103_ _6075_/S _7075_/Q _6081_/A VGND VGND VPWR VPWR _3114_/B sky130_fd_sc_hd__or3_2
XFILLER_7_1360 VGND VGND VPWR VPWR sky130_fd_sc_hd__decap_3
XFILLER_28_409 VGND VGND VPWR VPWR sky130_fd_sc_hd__decap_3
X_4083_ _4083_/A _4083_/B VGND VGND VPWR VPWR _4083_/Y sky130_fd_sc_hd__nor2_2
XFILLER_62_1190 VGND VGND VPWR VPWR sky130_fd_sc_hd__fill_1
XFILLER_3_1213 VGND VGND VPWR VPWR sky130_fd_sc_hd__decap_3
XFILLER_7_1393 VGND VGND VPWR VPWR sky130_fd_sc_hd__decap_3
XFILLER_55_228 VGND VGND VPWR VPWR sky130_fd_sc_hd__decap_3
XFILLER_37_943 VGND VGND VPWR VPWR sky130_fd_sc_hd__decap_3
XFILLER_3_1257 VGND VGND VPWR VPWR sky130_fd_sc_hd__decap_3
XFILLER_37_976 VGND VGND VPWR VPWR sky130_fd_sc_hd__fill_2
XFILLER_58_1237 VGND VGND VPWR VPWR sky130_fd_sc_hd__decap_3
XFILLER_64_795 VGND VGND VPWR VPWR sky130_fd_sc_hd__decap_3
XTAP_TAPCELL_ROW_19_684 VGND VPWR sky130_fd_sc_hd__tapvpwrvgnd_1
XFILLER_36_497 VGND VGND VPWR VPWR sky130_fd_sc_hd__decap_3
XTAP_TAPCELL_ROW_19_695 VGND VPWR sky130_fd_sc_hd__tapvpwrvgnd_1
XFILLER_51_423 VGND VGND VPWR VPWR sky130_fd_sc_hd__decap_3
XFILLER_63_294 VGND VGND VPWR VPWR sky130_fd_sc_hd__decap_3
X_4985_ _6355_/Q _4984_/X _4985_/S VGND VGND VPWR VPWR _6355_/D sky130_fd_sc_hd__mux2_1
XFILLER_52_979 VGND VGND VPWR VPWR sky130_fd_sc_hd__fill_1
XFILLER_71_1404 VGND VGND VPWR VPWR sky130_fd_sc_hd__decap_3
XFILLER_23_169 VGND VGND VPWR VPWR sky130_fd_sc_hd__decap_3
X_6724_ _6988_/CLK _6724_/D fanout816/X VGND VGND VPWR VPWR _6724_/Q sky130_fd_sc_hd__dfrtp_2
XFILLER_51_478 VGND VGND VPWR VPWR sky130_fd_sc_hd__decap_3
X_3936_ _3286_/X _4080_/A2 _4080_/B1 _6840_/Q _4080_/C1 VGND VGND VPWR VPWR _3936_/X
+ sky130_fd_sc_hd__a221o_2
XFILLER_71_1437 VGND VGND VPWR VPWR sky130_fd_sc_hd__decap_3
XFILLER_32_681 VGND VGND VPWR VPWR sky130_fd_sc_hd__decap_3
X_6655_ _6807_/CLK _6655_/D fanout787/X VGND VGND VPWR VPWR _6655_/Q sky130_fd_sc_hd__dfrtp_2
XFILLER_31_191 VGND VGND VPWR VPWR sky130_fd_sc_hd__decap_3
X_3867_ _6276_/Q _4010_/B _3902_/B1 _6252_/Q _3902_/C1 VGND VGND VPWR VPWR _3867_/X
+ sky130_fd_sc_hd__a221o_2
XFILLER_34_1270 VGND VGND VPWR VPWR sky130_fd_sc_hd__decap_3
X_5606_ _5606_/A1 _5606_/A2 _4300_/B _5610_/B1 _5606_/B2 VGND VGND VPWR VPWR _6677_/D
+ sky130_fd_sc_hd__a32o_2
X_6586_ _6863_/CLK _6586_/D fanout758/X VGND VGND VPWR VPWR _6586_/Q sky130_fd_sc_hd__dfrtp_2
X_3798_ _3927_/A_N _6314_/Q VGND VGND VPWR VPWR _3798_/X sky130_fd_sc_hd__and2b_2
XFILLER_69_1322 VGND VGND VPWR VPWR sky130_fd_sc_hd__decap_3
X_5537_ _6370_/Q _5564_/A2 hold893/X _5564_/B2 VGND VGND VPWR VPWR _6620_/D sky130_fd_sc_hd__a22o_2
XFILLER_69_1366 VGND VGND VPWR VPWR sky130_fd_sc_hd__decap_3
XFILLER_65_1219 VGND VGND VPWR VPWR sky130_fd_sc_hd__decap_3
X_5468_ _5468_/A1 _5468_/A2 _4817_/X VGND VGND VPWR VPWR _6580_/D sky130_fd_sc_hd__a21o_2
XFILLER_2_9 VGND VGND VPWR VPWR sky130_fd_sc_hd__decap_3
XFILLER_69_1399 VGND VGND VPWR VPWR sky130_fd_sc_hd__fill_1
XFILLER_28_1030 VGND VGND VPWR VPWR sky130_fd_sc_hd__decap_3
X_4419_ _5508_/A _5581_/B _4586_/C VGND VGND VPWR VPWR _4419_/X sky130_fd_sc_hd__and3_2
Xfanout300 _4766_/A2 VGND VGND VPWR VPWR _4744_/A2 sky130_fd_sc_hd__clkdlybuf4s25_1
Xfanout311 _3106_/Y VGND VGND VPWR VPWR _3213_/C1 sky130_fd_sc_hd__clkdlybuf4s25_1
X_5399_ _5399_/A1 _5487_/A2 _4424_/X VGND VGND VPWR VPWR _6511_/D sky130_fd_sc_hd__a21o_2
Xfanout322 _3084_/Y VGND VGND VPWR VPWR _5512_/A sky130_fd_sc_hd__clkdlybuf4s25_1
XFILLER_8_1135 VGND VGND VPWR VPWR sky130_fd_sc_hd__decap_3
XTAP_TAPCELL_ROW_6_346 VGND VPWR sky130_fd_sc_hd__tapvpwrvgnd_1
XFILLER_28_1074 VGND VGND VPWR VPWR sky130_fd_sc_hd__decap_3
XTAP_TAPCELL_ROW_6_357 VGND VPWR sky130_fd_sc_hd__tapvpwrvgnd_1
Xfanout355 _3902_/C1 VGND VGND VPWR VPWR _3928_/C1 sky130_fd_sc_hd__clkdlybuf4s25_1
XTAP_TAPCELL_ROW_6_368 VGND VPWR sky130_fd_sc_hd__tapvpwrvgnd_1
XFILLER_59_567 VGND VGND VPWR VPWR sky130_fd_sc_hd__decap_3
Xfanout377 _4750_/B2 VGND VGND VPWR VPWR _4773_/B2 sky130_fd_sc_hd__clkdlybuf4s25_1
XFILLER_8_1179 VGND VGND VPWR VPWR sky130_fd_sc_hd__decap_3
XFILLER_74_504 VGND VGND VPWR VPWR sky130_fd_sc_hd__decap_3
Xfanout388 _4735_/B2 VGND VGND VPWR VPWR _4861_/B2 sky130_fd_sc_hd__clkdlybuf4s25_1
XFILLER_28_910 VGND VGND VPWR VPWR sky130_fd_sc_hd__decap_3
Xfanout399 _4896_/C1 VGND VGND VPWR VPWR _4788_/A sky130_fd_sc_hd__clkdlybuf4s25_1
XFILLER_47_729 VGND VGND VPWR VPWR sky130_fd_sc_hd__decap_3
X_7069_ _7096_/CLK _7069_/D load_slew681/X VGND VGND VPWR VPWR _7069_/Q sky130_fd_sc_hd__dfrtp_2
XFILLER_41_1263 VGND VGND VPWR VPWR sky130_fd_sc_hd__decap_3
XFILLER_27_442 VGND VGND VPWR VPWR sky130_fd_sc_hd__decap_3
XFILLER_76_1315 VGND VGND VPWR VPWR sky130_fd_sc_hd__fill_1
XFILLER_15_604 VGND VGND VPWR VPWR sky130_fd_sc_hd__decap_3
XFILLER_76_1326 VGND VGND VPWR VPWR sky130_fd_sc_hd__decap_3
XFILLER_70_721 VGND VGND VPWR VPWR sky130_fd_sc_hd__decap_3
XFILLER_76_1359 VGND VGND VPWR VPWR sky130_fd_sc_hd__decap_3
XFILLER_27_497 VGND VGND VPWR VPWR sky130_fd_sc_hd__decap_3
XFILLER_54_283 VGND VGND VPWR VPWR sky130_fd_sc_hd__fill_1
XFILLER_15_659 VGND VGND VPWR VPWR sky130_fd_sc_hd__decap_3
XFILLER_43_968 VGND VGND VPWR VPWR sky130_fd_sc_hd__decap_3
XFILLER_14_147 VGND VGND VPWR VPWR sky130_fd_sc_hd__decap_3
XFILLER_42_456 VGND VGND VPWR VPWR sky130_fd_sc_hd__decap_3
XFILLER_30_618 VGND VGND VPWR VPWR sky130_fd_sc_hd__decap_3
XTAP_TAPCELL_ROW_46_1393 VGND VPWR sky130_fd_sc_hd__tapvpwrvgnd_1
XFILLER_7_803 VGND VGND VPWR VPWR sky130_fd_sc_hd__fill_2
Xwire712 wire712/A VGND VGND VPWR VPWR wire712/X sky130_fd_sc_hd__clkbuf_4
Xwire734 wire734/A VGND VGND VPWR VPWR wire734/X sky130_fd_sc_hd__clkbuf_4
XFILLER_13_1310 VGND VGND VPWR VPWR sky130_fd_sc_hd__decap_3
XFILLER_6_302 VGND VGND VPWR VPWR sky130_fd_sc_hd__decap_3
XFILLER_7_847 VGND VGND VPWR VPWR sky130_fd_sc_hd__decap_3
XFILLER_13_1343 VGND VGND VPWR VPWR sky130_fd_sc_hd__fill_1
XFILLER_13_1354 VGND VGND VPWR VPWR sky130_fd_sc_hd__decap_3
XFILLER_6_346 VGND VGND VPWR VPWR sky130_fd_sc_hd__decap_3
XTAP_TAPCELL_ROW_59_1732 VGND VPWR sky130_fd_sc_hd__tapvpwrvgnd_1
XFILLER_13_1387 VGND VGND VPWR VPWR sky130_fd_sc_hd__decap_3
XTAP_TAPCELL_ROW_59_1743 VGND VPWR sky130_fd_sc_hd__tapvpwrvgnd_1
XFILLER_48_1406 VGND VGND VPWR VPWR sky130_fd_sc_hd__decap_3
XTAP_TAPCELL_ROW_55_1618 VGND VPWR sky130_fd_sc_hd__tapvpwrvgnd_1
XTAP_TAPCELL_ROW_55_1629 VGND VPWR sky130_fd_sc_hd__tapvpwrvgnd_1
XFILLER_2_530 VGND VGND VPWR VPWR sky130_fd_sc_hd__fill_2
XFILLER_2_574 VGND VGND VPWR VPWR sky130_fd_sc_hd__decap_3
XFILLER_35_9 VGND VGND VPWR VPWR sky130_fd_sc_hd__fill_1
Xload_slew728 fanout727/X VGND VGND VPWR VPWR load_slew728/X sky130_fd_sc_hd__buf_2
XFILLER_46_1152 VGND VGND VPWR VPWR sky130_fd_sc_hd__fill_2
XFILLER_78_843 VGND VGND VPWR VPWR sky130_fd_sc_hd__fill_1
XFILLER_77_51 VGND VGND VPWR VPWR sky130_fd_sc_hd__decap_3
XFILLER_2_596 VGND VGND VPWR VPWR sky130_fd_sc_hd__fill_1
XFILLER_77_331 VGND VGND VPWR VPWR sky130_fd_sc_hd__decap_3
XFILLER_42_1016 VGND VGND VPWR VPWR sky130_fd_sc_hd__decap_3
XFILLER_77_84 VGND VGND VPWR VPWR sky130_fd_sc_hd__fill_1
XFILLER_37_206 VGND VGND VPWR VPWR sky130_fd_sc_hd__fill_2
XFILLER_24_1450 VGND VGND VPWR VPWR sky130_fd_sc_hd__decap_3
XFILLER_19_921 VGND VGND VPWR VPWR sky130_fd_sc_hd__decap_3
XFILLER_20_1303 VGND VGND VPWR VPWR sky130_fd_sc_hd__decap_3
XFILLER_37_228 VGND VGND VPWR VPWR sky130_fd_sc_hd__decap_3
XFILLER_65_559 VGND VGND VPWR VPWR sky130_fd_sc_hd__fill_1
XFILLER_0_1419 VGND VGND VPWR VPWR sky130_fd_sc_hd__decap_3
XFILLER_20_1347 VGND VGND VPWR VPWR sky130_fd_sc_hd__decap_3
XTAP_TAPCELL_ROW_29_960 VGND VPWR sky130_fd_sc_hd__tapvpwrvgnd_1
XFILLER_80_529 VGND VGND VPWR VPWR sky130_fd_sc_hd__decap_3
XFILLER_45_250 VGND VGND VPWR VPWR sky130_fd_sc_hd__decap_3
XFILLER_18_475 VGND VGND VPWR VPWR sky130_fd_sc_hd__fill_1
XFILLER_18_486 VGND VGND VPWR VPWR sky130_fd_sc_hd__decap_3
XTAP_TAPCELL_ROW_16_610 VGND VPWR sky130_fd_sc_hd__tapvpwrvgnd_1
XFILLER_61_732 VGND VGND VPWR VPWR sky130_fd_sc_hd__decap_3
XTAP_TAPCELL_ROW_16_621 VGND VPWR sky130_fd_sc_hd__tapvpwrvgnd_1
XFILLER_60_220 VGND VGND VPWR VPWR sky130_fd_sc_hd__decap_3
XFILLER_34_979 VGND VGND VPWR VPWR sky130_fd_sc_hd__fill_1
XFILLER_60_242 VGND VGND VPWR VPWR sky130_fd_sc_hd__fill_2
XFILLER_60_253 VGND VGND VPWR VPWR sky130_fd_sc_hd__fill_2
XFILLER_61_776 VGND VGND VPWR VPWR sky130_fd_sc_hd__decap_3
XFILLER_18_1232 VGND VGND VPWR VPWR sky130_fd_sc_hd__decap_3
XFILLER_57_1281 VGND VGND VPWR VPWR sky130_fd_sc_hd__decap_3
XFILLER_20_106 VGND VGND VPWR VPWR sky130_fd_sc_hd__decap_3
X_4770_ _6574_/Q _4770_/B VGND VGND VPWR VPWR _4770_/Y sky130_fd_sc_hd__nand2_2
XFILLER_57_1292 VGND VGND VPWR VPWR sky130_fd_sc_hd__decap_3
XFILLER_14_1107 VGND VGND VPWR VPWR sky130_fd_sc_hd__fill_1
XFILLER_18_1276 VGND VGND VPWR VPWR sky130_fd_sc_hd__decap_3
X_3721_ _3722_/A _6608_/Q VGND VGND VPWR VPWR _3721_/Y sky130_fd_sc_hd__nor2_2
XFILLER_14_1118 VGND VGND VPWR VPWR sky130_fd_sc_hd__decap_3
XFILLER_31_1410 VGND VGND VPWR VPWR sky130_fd_sc_hd__decap_3
X_6440_ _6970_/CLK _6440_/D load_slew674/X VGND VGND VPWR VPWR _6440_/Q sky130_fd_sc_hd__dfrtp_2
XFILLER_9_184 VGND VGND VPWR VPWR sky130_fd_sc_hd__decap_3
X_3652_ _3652_/A _3652_/B _3652_/C _3652_/D VGND VGND VPWR VPWR _3652_/X sky130_fd_sc_hd__and4_2
XFILLER_31_1443 VGND VGND VPWR VPWR sky130_fd_sc_hd__decap_3
X_6371_ _7092_/CLK _6371_/D load_slew690/X VGND VGND VPWR VPWR _6371_/Q sky130_fd_sc_hd__dfrtp_2
X_3583_ _3583_/A _3583_/B _3583_/C VGND VGND VPWR VPWR _3607_/C sky130_fd_sc_hd__nand3_2
X_5322_ _6792_/Q _5001_/B _5322_/S VGND VGND VPWR VPWR _5322_/X sky130_fd_sc_hd__mux2_1
X_5253_ _6764_/Q _5314_/S _5321_/S _5252_/Y VGND VGND VPWR VPWR _5253_/X sky130_fd_sc_hd__o211a_2
XFILLER_9_1422 VGND VGND VPWR VPWR sky130_fd_sc_hd__decap_3
XFILLER_64_1241 VGND VGND VPWR VPWR sky130_fd_sc_hd__decap_3
XFILLER_29_1372 VGND VGND VPWR VPWR sky130_fd_sc_hd__decap_3
XFILLER_69_832 VGND VGND VPWR VPWR sky130_fd_sc_hd__decap_3
X_4204_ _4283_/A _4617_/B _4199_/X _4793_/A VGND VGND VPWR VPWR _4204_/X sky130_fd_sc_hd__o2bb2a_2
X_5184_ _6739_/Q _5276_/A VGND VGND VPWR VPWR _5184_/Y sky130_fd_sc_hd__nor2_2
XFILLER_9_1455 VGND VGND VPWR VPWR sky130_fd_sc_hd__fill_1
XFILLER_9_1466 VGND VGND VPWR VPWR sky130_fd_sc_hd__decap_3
XFILLER_25_1236 VGND VGND VPWR VPWR sky130_fd_sc_hd__decap_3
XFILLER_64_1285 VGND VGND VPWR VPWR sky130_fd_sc_hd__decap_3
XFILLER_68_342 VGND VGND VPWR VPWR sky130_fd_sc_hd__decap_3
XFILLER_5_1319 VGND VGND VPWR VPWR sky130_fd_sc_hd__decap_3
XFILLER_29_707 VGND VGND VPWR VPWR sky130_fd_sc_hd__decap_3
XFILLER_3_81 VGND VGND VPWR VPWR sky130_fd_sc_hd__decap_3
X_4135_ _4756_/A1 _4128_/X _4134_/X VGND VGND VPWR VPWR _4135_/X sky130_fd_sc_hd__o21a_2
XFILLER_25_1269 VGND VGND VPWR VPWR sky130_fd_sc_hd__decap_3
XFILLER_29_729 VGND VGND VPWR VPWR sky130_fd_sc_hd__decap_3
XFILLER_60_1149 VGND VGND VPWR VPWR sky130_fd_sc_hd__decap_3
XFILLER_56_515 VGND VGND VPWR VPWR sky130_fd_sc_hd__decap_3
XFILLER_3_1021 VGND VGND VPWR VPWR sky130_fd_sc_hd__fill_1
X_4066_ _6593_/Q _4732_/A _3485_/B VGND VGND VPWR VPWR _4066_/X sky130_fd_sc_hd__a21bo_2
XTAP_TAPCELL_ROW_27_908 VGND VPWR sky130_fd_sc_hd__tapvpwrvgnd_1
XFILLER_3_1054 VGND VGND VPWR VPWR sky130_fd_sc_hd__decap_3
XFILLER_3_1065 VGND VGND VPWR VPWR sky130_fd_sc_hd__decap_3
XFILLER_71_529 VGND VGND VPWR VPWR sky130_fd_sc_hd__decap_3
XFILLER_52_710 VGND VGND VPWR VPWR sky130_fd_sc_hd__decap_3
XFILLER_24_412 VGND VGND VPWR VPWR sky130_fd_sc_hd__fill_1
Xwire54 wire54/A VGND VGND VPWR VPWR wire54/X sky130_fd_sc_hd__clkbuf_4
XFILLER_3_1098 VGND VGND VPWR VPWR sky130_fd_sc_hd__decap_3
XFILLER_25_946 VGND VGND VPWR VPWR sky130_fd_sc_hd__decap_3
XFILLER_36_283 VGND VGND VPWR VPWR sky130_fd_sc_hd__decap_3
XFILLER_25_968 VGND VGND VPWR VPWR sky130_fd_sc_hd__decap_3
XFILLER_51_231 VGND VGND VPWR VPWR sky130_fd_sc_hd__fill_2
XFILLER_24_456 VGND VGND VPWR VPWR sky130_fd_sc_hd__fill_2
XFILLER_12_607 VGND VGND VPWR VPWR sky130_fd_sc_hd__decap_3
XFILLER_71_1201 VGND VGND VPWR VPWR sky130_fd_sc_hd__decap_3
XFILLER_75_1381 VGND VGND VPWR VPWR sky130_fd_sc_hd__decap_3
XFILLER_11_106 VGND VGND VPWR VPWR sky130_fd_sc_hd__decap_3
XFILLER_36_1332 VGND VGND VPWR VPWR sky130_fd_sc_hd__decap_3
XFILLER_40_949 VGND VGND VPWR VPWR sky130_fd_sc_hd__decap_3
X_4968_ _6385_/Q _5225_/B _5031_/B1 VGND VGND VPWR VPWR _4968_/Y sky130_fd_sc_hd__a21oi_2
XFILLER_11_128 VGND VGND VPWR VPWR sky130_fd_sc_hd__decap_3
X_6707_ _6772_/CLK _6707_/D load_slew831/X VGND VGND VPWR VPWR _6707_/Q sky130_fd_sc_hd__dfrtp_2
XFILLER_71_1245 VGND VGND VPWR VPWR sky130_fd_sc_hd__decap_3
XFILLER_36_1365 VGND VGND VPWR VPWR sky130_fd_sc_hd__decap_3
XFILLER_20_640 VGND VGND VPWR VPWR sky130_fd_sc_hd__decap_3
XFILLER_36_1376 VGND VGND VPWR VPWR sky130_fd_sc_hd__decap_3
X_3919_ _6326_/Q _4786_/B _3917_/X _3918_/X VGND VGND VPWR VPWR _4249_/B sky130_fd_sc_hd__o22a_2
XFILLER_71_1278 VGND VGND VPWR VPWR sky130_fd_sc_hd__decap_3
X_4899_ _6343_/Q _4898_/X _4899_/S VGND VGND VPWR VPWR _6343_/D sky130_fd_sc_hd__mux2_1
XFILLER_32_1229 VGND VGND VPWR VPWR sky130_fd_sc_hd__decap_3
XFILLER_71_1289 VGND VGND VPWR VPWR sky130_fd_sc_hd__decap_3
XFILLER_20_684 VGND VGND VPWR VPWR sky130_fd_sc_hd__decap_3
X_6638_ _6819_/CLK _6638_/D fanout749/X VGND VGND VPWR VPWR _6638_/Q sky130_fd_sc_hd__dfrtp_2
XFILLER_22_68 VGND VGND VPWR VPWR sky130_fd_sc_hd__fill_1
XFILLER_4_806 VGND VGND VPWR VPWR sky130_fd_sc_hd__fill_1
X_6569_ _6910_/CLK _6569_/D fanout777/X VGND VGND VPWR VPWR _6569_/Q sky130_fd_sc_hd__dfrtp_2
XFILLER_3_305 VGND VGND VPWR VPWR sky130_fd_sc_hd__decap_3
XFILLER_69_1141 VGND VGND VPWR VPWR sky130_fd_sc_hd__decap_3
XFILLER_65_1005 VGND VGND VPWR VPWR sky130_fd_sc_hd__decap_3
XFILLER_69_1174 VGND VGND VPWR VPWR sky130_fd_sc_hd__fill_2
XFILLER_3_349 VGND VGND VPWR VPWR sky130_fd_sc_hd__decap_3
XFILLER_0_6 VGND VGND VPWR VPWR sky130_fd_sc_hd__decap_3
XFILLER_79_629 VGND VGND VPWR VPWR sky130_fd_sc_hd__decap_3
XFILLER_78_139 VGND VGND VPWR VPWR sky130_fd_sc_hd__fill_1
Xfanout130 _5353_/S VGND VGND VPWR VPWR _5345_/S sky130_fd_sc_hd__clkdlybuf4s25_1
XFILLER_43_1325 VGND VGND VPWR VPWR sky130_fd_sc_hd__decap_3
XTAP_TAPCELL_ROW_50_1504 VGND VPWR sky130_fd_sc_hd__tapvpwrvgnd_1
Xfanout174 _3435_/S VGND VGND VPWR VPWR _3377_/S sky130_fd_sc_hd__clkdlybuf4s25_1
XFILLER_19_206 VGND VGND VPWR VPWR sky130_fd_sc_hd__fill_1
XFILLER_43_1369 VGND VGND VPWR VPWR sky130_fd_sc_hd__decap_3
XFILLER_74_312 VGND VGND VPWR VPWR sky130_fd_sc_hd__fill_1
XFILLER_19_228 VGND VGND VPWR VPWR sky130_fd_sc_hd__decap_3
XFILLER_47_54 VGND VGND VPWR VPWR sky130_fd_sc_hd__fill_2
XFILLER_47_559 VGND VGND VPWR VPWR sky130_fd_sc_hd__fill_1
XFILLER_76_1123 VGND VGND VPWR VPWR sky130_fd_sc_hd__decap_3
XFILLER_55_570 VGND VGND VPWR VPWR sky130_fd_sc_hd__decap_3
XFILLER_15_412 VGND VGND VPWR VPWR sky130_fd_sc_hd__fill_1
XTAP_TAPCELL_ROW_48_1444 VGND VPWR sky130_fd_sc_hd__tapvpwrvgnd_1
XTAP_TAPCELL_ROW_48_1455 VGND VPWR sky130_fd_sc_hd__tapvpwrvgnd_1
XFILLER_63_42 VGND VGND VPWR VPWR sky130_fd_sc_hd__decap_3
XFILLER_76_1167 VGND VGND VPWR VPWR sky130_fd_sc_hd__decap_3
XFILLER_16_979 VGND VGND VPWR VPWR sky130_fd_sc_hd__fill_1
XFILLER_42_231 VGND VGND VPWR VPWR sky130_fd_sc_hd__decap_3
XPHY_EDGE_ROW_69_Right_69 VGND VGND VPWR VPWR sky130_fd_sc_hd__decap_3
XFILLER_42_253 VGND VGND VPWR VPWR sky130_fd_sc_hd__decap_3
XFILLER_43_776 VGND VGND VPWR VPWR sky130_fd_sc_hd__decap_3
XFILLER_15_478 VGND VGND VPWR VPWR sky130_fd_sc_hd__decap_3
XFILLER_30_404 VGND VGND VPWR VPWR sky130_fd_sc_hd__decap_3
XFILLER_31_938 VGND VGND VPWR VPWR sky130_fd_sc_hd__decap_3
XFILLER_54_1421 VGND VGND VPWR VPWR sky130_fd_sc_hd__decap_3
XFILLER_54_1432 VGND VGND VPWR VPWR sky130_fd_sc_hd__decap_3
XFILLER_24_990 VGND VGND VPWR VPWR sky130_fd_sc_hd__decap_3
XFILLER_8_15 VGND VGND VPWR VPWR sky130_fd_sc_hd__decap_3
XFILLER_30_448 VGND VGND VPWR VPWR sky130_fd_sc_hd__decap_3
XFILLER_15_1416 VGND VGND VPWR VPWR sky130_fd_sc_hd__decap_3
XFILLER_54_1465 VGND VGND VPWR VPWR sky130_fd_sc_hd__decap_3
XFILLER_11_640 VGND VGND VPWR VPWR sky130_fd_sc_hd__decap_3
XFILLER_11_662 VGND VGND VPWR VPWR sky130_fd_sc_hd__decap_3
XFILLER_15_1449 VGND VGND VPWR VPWR sky130_fd_sc_hd__decap_3
XFILLER_50_1329 VGND VGND VPWR VPWR sky130_fd_sc_hd__decap_3
XFILLER_10_150 VGND VGND VPWR VPWR sky130_fd_sc_hd__decap_3
XFILLER_11_684 VGND VGND VPWR VPWR sky130_fd_sc_hd__decap_3
XFILLER_6_110 VGND VGND VPWR VPWR sky130_fd_sc_hd__decap_3
XFILLER_7_655 VGND VGND VPWR VPWR sky130_fd_sc_hd__decap_3
Xwire564 _3203_/S VGND VGND VPWR VPWR _3211_/S sky130_fd_sc_hd__buf_4
XFILLER_6_187 VGND VGND VPWR VPWR sky130_fd_sc_hd__decap_3
XPHY_EDGE_ROW_78_Right_78 VGND VGND VPWR VPWR sky130_fd_sc_hd__decap_3
XFILLER_48_1236 VGND VGND VPWR VPWR sky130_fd_sc_hd__decap_3
XFILLER_3_850 VGND VGND VPWR VPWR sky130_fd_sc_hd__decap_3
XFILLER_3_883 VGND VGND VPWR VPWR sky130_fd_sc_hd__decap_3
XFILLER_2_360 VGND VGND VPWR VPWR sky130_fd_sc_hd__decap_3
XPHY_EDGE_ROW_0_Left_81 VGND VGND VPWR VPWR sky130_fd_sc_hd__decap_3
XFILLER_2_371 VGND VGND VPWR VPWR sky130_fd_sc_hd__decap_3
XFILLER_33_6 VGND VGND VPWR VPWR sky130_fd_sc_hd__decap_3
Xload_slew536 fanout535/X VGND VGND VPWR VPWR _5348_/S sky130_fd_sc_hd__clkbuf_4
XFILLER_69_139 VGND VGND VPWR VPWR sky130_fd_sc_hd__decap_3
XFILLER_61_1425 VGND VGND VPWR VPWR sky130_fd_sc_hd__decap_3
XFILLER_66_802 VGND VGND VPWR VPWR sky130_fd_sc_hd__decap_3
XFILLER_22_1409 VGND VGND VPWR VPWR sky130_fd_sc_hd__decap_3
XFILLER_65_301 VGND VGND VPWR VPWR sky130_fd_sc_hd__decap_3
XFILLER_66_857 VGND VGND VPWR VPWR sky130_fd_sc_hd__decap_3
XFILLER_4_1341 VGND VGND VPWR VPWR sky130_fd_sc_hd__decap_3
XFILLER_24_1291 VGND VGND VPWR VPWR sky130_fd_sc_hd__decap_3
XFILLER_0_1205 VGND VGND VPWR VPWR sky130_fd_sc_hd__decap_3
XFILLER_59_1310 VGND VGND VPWR VPWR sky130_fd_sc_hd__decap_3
XFILLER_65_378 VGND VGND VPWR VPWR sky130_fd_sc_hd__decap_3
XFILLER_4_1385 VGND VGND VPWR VPWR sky130_fd_sc_hd__decap_3
X_5940_ _5940_/A0 _6944_/Q _5998_/S VGND VGND VPWR VPWR _5940_/X sky130_fd_sc_hd__mux2_1
XFILLER_46_570 VGND VGND VPWR VPWR sky130_fd_sc_hd__decap_3
XFILLER_46_581 VGND VGND VPWR VPWR sky130_fd_sc_hd__decap_3
XFILLER_59_1343 VGND VGND VPWR VPWR sky130_fd_sc_hd__fill_1
XFILLER_80_337 VGND VGND VPWR VPWR sky130_fd_sc_hd__decap_3
XFILLER_59_1354 VGND VGND VPWR VPWR sky130_fd_sc_hd__decap_3
X_5871_ _5871_/A1 _5868_/Y _5915_/C _5784_/X VGND VGND VPWR VPWR _6882_/D sky130_fd_sc_hd__a22o_2
XFILLER_59_1387 VGND VGND VPWR VPWR sky130_fd_sc_hd__decap_3
XFILLER_22_916 VGND VGND VPWR VPWR sky130_fd_sc_hd__decap_3
X_4822_ _4822_/A wire31/X VGND VGND VPWR VPWR _4822_/Y sky130_fd_sc_hd__nor2_2
XFILLER_18_1040 VGND VGND VPWR VPWR sky130_fd_sc_hd__decap_3
X_4753_ _4738_/A _4394_/X _4723_/X _6572_/Q VGND VGND VPWR VPWR _4753_/X sky130_fd_sc_hd__a2bb2o_2
X_3704_ _3705_/A _3705_/B VGND VGND VPWR VPWR _3752_/A sky130_fd_sc_hd__xor2_2
XFILLER_30_993 VGND VGND VPWR VPWR sky130_fd_sc_hd__decap_3
X_4684_ _6290_/Q _4861_/A2 _3390_/X _4861_/B2 VGND VGND VPWR VPWR _4684_/X sky130_fd_sc_hd__a22o_2
X_6423_ _6889_/CLK _6423_/D load_slew748/X VGND VGND VPWR VPWR _6423_/Q sky130_fd_sc_hd__dfrtp_2
XFILLER_31_1251 VGND VGND VPWR VPWR sky130_fd_sc_hd__decap_3
X_3635_ _3635_/A _3671_/A VGND VGND VPWR VPWR _3635_/Y sky130_fd_sc_hd__nand2_2
XFILLER_31_1284 VGND VGND VPWR VPWR sky130_fd_sc_hd__decap_3
XFILLER_31_1295 VGND VGND VPWR VPWR sky130_fd_sc_hd__decap_3
XFILLER_66_1303 VGND VGND VPWR VPWR sky130_fd_sc_hd__decap_3
X_6354_ _6988_/CLK _6354_/D load_slew813/X VGND VGND VPWR VPWR _6354_/Q sky130_fd_sc_hd__dfrtp_2
XTAP_TAPCELL_ROW_8_408 VGND VPWR sky130_fd_sc_hd__tapvpwrvgnd_1
X_3566_ _3566_/A _3601_/B _6242_/Q VGND VGND VPWR VPWR _3566_/X sky130_fd_sc_hd__and3_2
XTAP_TAPCELL_ROW_8_419 VGND VPWR sky130_fd_sc_hd__tapvpwrvgnd_1
XFILLER_1_809 VGND VGND VPWR VPWR sky130_fd_sc_hd__decap_3
X_5305_ _6445_/Q _5304_/X _5305_/S VGND VGND VPWR VPWR _6445_/D sky130_fd_sc_hd__mux2_1
XFILLER_66_1347 VGND VGND VPWR VPWR sky130_fd_sc_hd__decap_3
X_6285_ _7055_/CLK _6285_/D wire796/A VGND VGND VPWR VPWR _6285_/Q sky130_fd_sc_hd__dfrtp_2
X_3497_ _5508_/A _4420_/B VGND VGND VPWR VPWR _4783_/C sky130_fd_sc_hd__nand2_2
X_5236_ _6420_/Q wire112/X _5235_/X VGND VGND VPWR VPWR _6420_/D sky130_fd_sc_hd__a21o_2
XFILLER_9_1263 VGND VGND VPWR VPWR sky130_fd_sc_hd__decap_3
XFILLER_5_1116 VGND VGND VPWR VPWR sky130_fd_sc_hd__decap_3
XFILLER_5_1127 VGND VGND VPWR VPWR sky130_fd_sc_hd__decap_3
X_5167_ _6392_/Q _5257_/A2 _5020_/S _5166_/X VGND VGND VPWR VPWR _6392_/D sky130_fd_sc_hd__a22o_2
XFILLER_56_312 VGND VGND VPWR VPWR sky130_fd_sc_hd__fill_2
XFILLER_29_559 VGND VGND VPWR VPWR sky130_fd_sc_hd__fill_1
X_4118_ _6473_/Q _4277_/B _4265_/B VGND VGND VPWR VPWR _4118_/X sky130_fd_sc_hd__mux2_1
XFILLER_56_345 VGND VGND VPWR VPWR sky130_fd_sc_hd__decap_3
X_5098_ _5342_/S _5099_/B _5281_/A2 VGND VGND VPWR VPWR _5098_/X sky130_fd_sc_hd__a21o_2
XFILLER_57_879 VGND VGND VPWR VPWR sky130_fd_sc_hd__decap_3
XFILLER_42_1391 VGND VGND VPWR VPWR sky130_fd_sc_hd__decap_3
XFILLER_72_827 VGND VGND VPWR VPWR sky130_fd_sc_hd__decap_3
XFILLER_77_1410 VGND VGND VPWR VPWR sky130_fd_sc_hd__decap_3
X_4049_ _4049_/A1 _4046_/X _4047_/Y _4048_/X _4013_/A VGND VGND VPWR VPWR _4049_/X
+ sky130_fd_sc_hd__o221a_2
XFILLER_17_57 VGND VGND VPWR VPWR sky130_fd_sc_hd__fill_2
XFILLER_77_1443 VGND VGND VPWR VPWR sky130_fd_sc_hd__decap_3
XFILLER_71_337 VGND VGND VPWR VPWR sky130_fd_sc_hd__decap_3
XFILLER_37_592 VGND VGND VPWR VPWR sky130_fd_sc_hd__decap_3
XFILLER_73_1307 VGND VGND VPWR VPWR sky130_fd_sc_hd__decap_3
XFILLER_38_1427 VGND VGND VPWR VPWR sky130_fd_sc_hd__fill_1
XFILLER_38_1438 VGND VGND VPWR VPWR sky130_fd_sc_hd__decap_3
XFILLER_80_893 VGND VGND VPWR VPWR sky130_fd_sc_hd__decap_3
XFILLER_13_938 VGND VGND VPWR VPWR sky130_fd_sc_hd__decap_3
XFILLER_33_12 VGND VGND VPWR VPWR sky130_fd_sc_hd__fill_1
XFILLER_52_584 VGND VGND VPWR VPWR sky130_fd_sc_hd__decap_3
XFILLER_9_909 VGND VGND VPWR VPWR sky130_fd_sc_hd__decap_3
XTAP_TAPCELL_ROW_43_1330 VGND VPWR sky130_fd_sc_hd__tapvpwrvgnd_1
XFILLER_12_448 VGND VGND VPWR VPWR sky130_fd_sc_hd__decap_3
XFILLER_40_757 VGND VGND VPWR VPWR sky130_fd_sc_hd__decap_3
XFILLER_8_419 VGND VGND VPWR VPWR sky130_fd_sc_hd__fill_1
XFILLER_36_1173 VGND VGND VPWR VPWR sky130_fd_sc_hd__decap_3
XFILLER_32_1037 VGND VGND VPWR VPWR sky130_fd_sc_hd__decap_3
XFILLER_10_1335 VGND VGND VPWR VPWR sky130_fd_sc_hd__decap_3
XFILLER_4_625 VGND VGND VPWR VPWR sky130_fd_sc_hd__decap_3
XFILLER_3_102 VGND VGND VPWR VPWR sky130_fd_sc_hd__decap_3
XFILLER_3_113 VGND VGND VPWR VPWR sky130_fd_sc_hd__decap_3
XFILLER_10_1368 VGND VGND VPWR VPWR sky130_fd_sc_hd__decap_3
XFILLER_4_658 VGND VGND VPWR VPWR sky130_fd_sc_hd__decap_3
XFILLER_10_1379 VGND VGND VPWR VPWR sky130_fd_sc_hd__decap_3
XTAP_TAPCELL_ROW_37_1156 VGND VPWR sky130_fd_sc_hd__tapvpwrvgnd_1
XTAP_TAPCELL_ROW_37_1167 VGND VPWR sky130_fd_sc_hd__tapvpwrvgnd_1
XFILLER_0_831 VGND VGND VPWR VPWR sky130_fd_sc_hd__decap_3
XFILLER_0_853 VGND VGND VPWR VPWR sky130_fd_sc_hd__decap_3
XFILLER_58_53 VGND VGND VPWR VPWR sky130_fd_sc_hd__decap_3
XFILLER_0_875 VGND VGND VPWR VPWR sky130_fd_sc_hd__decap_3
XFILLER_0_897 VGND VGND VPWR VPWR sky130_fd_sc_hd__decap_3
XFILLER_43_1177 VGND VGND VPWR VPWR sky130_fd_sc_hd__decap_3
XFILLER_74_120 VGND VGND VPWR VPWR sky130_fd_sc_hd__decap_3
XFILLER_21_1431 VGND VGND VPWR VPWR sky130_fd_sc_hd__decap_3
XFILLER_78_1229 VGND VGND VPWR VPWR sky130_fd_sc_hd__decap_3
XFILLER_74_41 VGND VGND VPWR VPWR sky130_fd_sc_hd__decap_3
XFILLER_47_389 VGND VGND VPWR VPWR sky130_fd_sc_hd__decap_3
XFILLER_16_721 VGND VGND VPWR VPWR sky130_fd_sc_hd__decap_3
XFILLER_74_74 VGND VGND VPWR VPWR sky130_fd_sc_hd__decap_3
XFILLER_74_85 VGND VGND VPWR VPWR sky130_fd_sc_hd__decap_3
XFILLER_43_540 VGND VGND VPWR VPWR sky130_fd_sc_hd__fill_1
XFILLER_15_264 VGND VGND VPWR VPWR sky130_fd_sc_hd__decap_3
XFILLER_16_787 VGND VGND VPWR VPWR sky130_fd_sc_hd__decap_3
XFILLER_19_1360 VGND VGND VPWR VPWR sky130_fd_sc_hd__decap_3
XFILLER_15_1213 VGND VGND VPWR VPWR sky130_fd_sc_hd__decap_3
XFILLER_54_1273 VGND VGND VPWR VPWR sky130_fd_sc_hd__decap_3
XFILLER_19_1393 VGND VGND VPWR VPWR sky130_fd_sc_hd__decap_3
XFILLER_15_1257 VGND VGND VPWR VPWR sky130_fd_sc_hd__decap_3
XFILLER_8_975 VGND VGND VPWR VPWR sky130_fd_sc_hd__decap_3
XFILLER_7_452 VGND VGND VPWR VPWR sky130_fd_sc_hd__decap_3
Xwire383 wire383/A VGND VGND VPWR VPWR wire383/X sky130_fd_sc_hd__clkbuf_4
XFILLER_7_485 VGND VGND VPWR VPWR sky130_fd_sc_hd__decap_3
X_3420_ _6321_/Q _6441_/Q VGND VGND VPWR VPWR _3420_/X sky130_fd_sc_hd__xor2_2
X_3351_ _5996_/A0 _3350_/X _3465_/S VGND VGND VPWR VPWR _6149_/D sky130_fd_sc_hd__mux2_1
XFILLER_3_691 VGND VGND VPWR VPWR sky130_fd_sc_hd__decap_3
XFILLER_31_3 VGND VGND VPWR VPWR sky130_fd_sc_hd__decap_3
Xload_slew333 _3864_/A2 VGND VGND VPWR VPWR _4829_/A sky130_fd_sc_hd__clkbuf_4
X_6070_ _5868_/A _5915_/B _5924_/B _6068_/X hold934/X VGND VGND VPWR VPWR _7071_/D
+ sky130_fd_sc_hd__a32o_2
X_3282_ _6220_/Q _6372_/Q VGND VGND VPWR VPWR _3282_/X sky130_fd_sc_hd__xor2_2
XFILLER_26_1320 VGND VGND VPWR VPWR sky130_fd_sc_hd__decap_3
XFILLER_6_1403 VGND VGND VPWR VPWR sky130_fd_sc_hd__decap_3
Xload_slew344 _4083_/A VGND VGND VPWR VPWR _4872_/A sky130_fd_sc_hd__buf_4
XFILLER_61_1222 VGND VGND VPWR VPWR sky130_fd_sc_hd__decap_3
Xhold1108 _6952_/Q VGND VGND VPWR VPWR _5948_/A1 sky130_fd_sc_hd__dlygate4sd3_1
XFILLER_26_1353 VGND VGND VPWR VPWR sky130_fd_sc_hd__decap_3
X_5021_ _6457_/Q _6675_/Q VGND VGND VPWR VPWR _5022_/B sky130_fd_sc_hd__xor2_2
Xload_slew366 _3551_/C1 VGND VGND VPWR VPWR _5574_/A2 sky130_fd_sc_hd__clkbuf_4
XFILLER_61_1233 VGND VGND VPWR VPWR sky130_fd_sc_hd__decap_3
Xhold1119 _6998_/Q VGND VGND VPWR VPWR _5994_/A1 sky130_fd_sc_hd__dlygate4sd3_1
XFILLER_38_301 VGND VGND VPWR VPWR sky130_fd_sc_hd__decap_3
XFILLER_6_1447 VGND VGND VPWR VPWR sky130_fd_sc_hd__decap_3
XFILLER_61_1266 VGND VGND VPWR VPWR sky130_fd_sc_hd__decap_3
XFILLER_26_1397 VGND VGND VPWR VPWR sky130_fd_sc_hd__decap_3
XFILLER_22_1239 VGND VGND VPWR VPWR sky130_fd_sc_hd__decap_3
XFILLER_65_131 VGND VGND VPWR VPWR sky130_fd_sc_hd__decap_3
XFILLER_54_816 VGND VGND VPWR VPWR sky130_fd_sc_hd__decap_3
XFILLER_53_304 VGND VGND VPWR VPWR sky130_fd_sc_hd__fill_2
XFILLER_65_164 VGND VGND VPWR VPWR sky130_fd_sc_hd__decap_3
XFILLER_0_1002 VGND VGND VPWR VPWR sky130_fd_sc_hd__decap_3
XFILLER_19_570 VGND VGND VPWR VPWR sky130_fd_sc_hd__decap_3
X_6972_ _7004_/CLK _6972_/D load_slew840/X VGND VGND VPWR VPWR _6972_/Q sky130_fd_sc_hd__dfrtp_2
XFILLER_4_1182 VGND VGND VPWR VPWR sky130_fd_sc_hd__decap_3
XFILLER_0_60 VGND VGND VPWR VPWR sky130_fd_sc_hd__decap_3
XFILLER_0_1024 VGND VGND VPWR VPWR sky130_fd_sc_hd__decap_3
XFILLER_53_348 VGND VGND VPWR VPWR sky130_fd_sc_hd__decap_3
XFILLER_0_1046 VGND VGND VPWR VPWR sky130_fd_sc_hd__decap_3
X_5923_ _5923_/A0 _5923_/A1 _5923_/S VGND VGND VPWR VPWR _6929_/D sky130_fd_sc_hd__mux2_1
XFILLER_0_1068 VGND VGND VPWR VPWR sky130_fd_sc_hd__decap_3
XFILLER_55_1004 VGND VGND VPWR VPWR sky130_fd_sc_hd__decap_3
XFILLER_62_860 VGND VGND VPWR VPWR sky130_fd_sc_hd__decap_3
XFILLER_80_167 VGND VGND VPWR VPWR sky130_fd_sc_hd__fill_1
XFILLER_62_893 VGND VGND VPWR VPWR sky130_fd_sc_hd__decap_3
X_5854_ _5854_/A0 _5901_/A0 wire97/X VGND VGND VPWR VPWR _6869_/D sky130_fd_sc_hd__mux2_1
XFILLER_21_212 VGND VGND VPWR VPWR sky130_fd_sc_hd__decap_3
XFILLER_22_757 VGND VGND VPWR VPWR sky130_fd_sc_hd__fill_2
X_4805_ _6916_/Q _4805_/A2 _4862_/B1 _4804_/X VGND VGND VPWR VPWR _4805_/X sky130_fd_sc_hd__a211o_2
XFILLER_37_1460 VGND VGND VPWR VPWR sky130_fd_sc_hd__decap_3
XFILLER_21_245 VGND VGND VPWR VPWR sky130_fd_sc_hd__decap_3
XFILLER_72_1362 VGND VGND VPWR VPWR sky130_fd_sc_hd__decap_3
XFILLER_33_1313 VGND VGND VPWR VPWR sky130_fd_sc_hd__decap_3
X_5785_ _7073_/Q _5859_/C VGND VGND VPWR VPWR _5868_/C sky130_fd_sc_hd__nor2_2
XFILLER_72_1373 VGND VGND VPWR VPWR sky130_fd_sc_hd__decap_3
X_4736_ _6907_/Q _4855_/A2 _4744_/B1 _4735_/X VGND VGND VPWR VPWR _4736_/X sky130_fd_sc_hd__a211o_2
XFILLER_33_1357 VGND VGND VPWR VPWR sky130_fd_sc_hd__decap_3
XFILLER_30_790 VGND VGND VPWR VPWR sky130_fd_sc_hd__decap_3
X_4667_ _4710_/A _4844_/B VGND VGND VPWR VPWR _4667_/Y sky130_fd_sc_hd__nor2_2
XFILLER_68_1409 VGND VGND VPWR VPWR sky130_fd_sc_hd__decap_3
X_6406_ _7095_/CLK _6406_/D load_slew696/X VGND VGND VPWR VPWR _6406_/Q sky130_fd_sc_hd__dfrtp_2
XFILLER_31_1081 VGND VGND VPWR VPWR sky130_fd_sc_hd__decap_3
XTAP_TAPCELL_ROW_77_2193 VGND VPWR sky130_fd_sc_hd__tapvpwrvgnd_1
X_3618_ _6336_/Q _5594_/A1 _5603_/A1 _6328_/Q VGND VGND VPWR VPWR _3618_/X sky130_fd_sc_hd__a22o_2
Xhold920 _5992_/X VGND VGND VPWR VPWR _6996_/D sky130_fd_sc_hd__dlygate4sd3_1
Xhold931 _5989_/X VGND VGND VPWR VPWR _6993_/D sky130_fd_sc_hd__dlygate4sd3_1
X_4598_ _6326_/Q _4773_/A2 _3366_/X _4773_/B2 VGND VGND VPWR VPWR _4598_/X sky130_fd_sc_hd__a22o_2
Xhold942 _6046_/X VGND VGND VPWR VPWR _7050_/D sky130_fd_sc_hd__dlygate4sd3_1
XFILLER_66_1122 VGND VGND VPWR VPWR sky130_fd_sc_hd__decap_3
Xhold953 _5978_/X VGND VGND VPWR VPWR _6982_/D sky130_fd_sc_hd__dlygate4sd3_1
XFILLER_1_617 VGND VGND VPWR VPWR sky130_fd_sc_hd__decap_3
X_6337_ _6959_/CLK _6337_/D fanout800/X VGND VGND VPWR VPWR _6337_/Q sky130_fd_sc_hd__dfrtp_2
Xhold964 _5993_/X VGND VGND VPWR VPWR _6997_/D sky130_fd_sc_hd__dlygate4sd3_1
X_3549_ _5606_/A1 _3538_/X _3539_/X _3548_/X _5506_/A VGND VGND VPWR VPWR _3583_/A
+ sky130_fd_sc_hd__a32o_2
Xhold975 _6114_/Q VGND VGND VPWR VPWR hold975/X sky130_fd_sc_hd__dlygate4sd3_1
XFILLER_1_639 VGND VGND VPWR VPWR sky130_fd_sc_hd__decap_3
Xhold986 _5974_/X VGND VGND VPWR VPWR _6978_/D sky130_fd_sc_hd__dlygate4sd3_1
XFILLER_0_116 VGND VGND VPWR VPWR sky130_fd_sc_hd__decap_3
Xhold997 _6162_/Q VGND VGND VPWR VPWR hold997/X sky130_fd_sc_hd__dlygate4sd3_1
XFILLER_66_1177 VGND VGND VPWR VPWR sky130_fd_sc_hd__decap_3
X_6268_ _7022_/CLK _6268_/D fanout750/X VGND VGND VPWR VPWR _6268_/Q sky130_fd_sc_hd__dfrtp_2
XFILLER_76_407 VGND VGND VPWR VPWR sky130_fd_sc_hd__decap_3
XFILLER_48_109 VGND VGND VPWR VPWR sky130_fd_sc_hd__fill_1
XTAP_TAPCELL_ROW_32_1020 VGND VPWR sky130_fd_sc_hd__tapvpwrvgnd_1
XFILLER_44_1453 VGND VGND VPWR VPWR sky130_fd_sc_hd__decap_3
X_5219_ _5219_/A _5219_/B VGND VGND VPWR VPWR _5219_/Y sky130_fd_sc_hd__nand2_2
X_6199_ _7050_/CLK _6199_/D load_slew645/X VGND VGND VPWR VPWR _6199_/Q sky130_fd_sc_hd__dfrtp_2
XTAP_TAPCELL_ROW_32_1031 VGND VPWR sky130_fd_sc_hd__tapvpwrvgnd_1
XFILLER_40_1306 VGND VGND VPWR VPWR sky130_fd_sc_hd__decap_3
XFILLER_29_323 VGND VGND VPWR VPWR sky130_fd_sc_hd__decap_3
XTAP_TAPCELL_ROW_32_1042 VGND VPWR sky130_fd_sc_hd__tapvpwrvgnd_1
XFILLER_40_1317 VGND VGND VPWR VPWR sky130_fd_sc_hd__decap_3
XFILLER_57_654 VGND VGND VPWR VPWR sky130_fd_sc_hd__decap_3
XFILLER_29_356 VGND VGND VPWR VPWR sky130_fd_sc_hd__decap_3
XFILLER_56_153 VGND VGND VPWR VPWR sky130_fd_sc_hd__decap_3
XFILLER_57_698 VGND VGND VPWR VPWR sky130_fd_sc_hd__fill_1
XFILLER_44_348 VGND VGND VPWR VPWR sky130_fd_sc_hd__decap_3
XFILLER_77_1251 VGND VGND VPWR VPWR sky130_fd_sc_hd__decap_3
XFILLER_71_167 VGND VGND VPWR VPWR sky130_fd_sc_hd__fill_1
XFILLER_73_1115 VGND VGND VPWR VPWR sky130_fd_sc_hd__decap_3
XFILLER_77_1284 VGND VGND VPWR VPWR sky130_fd_sc_hd__decap_3
XFILLER_71_178 VGND VGND VPWR VPWR sky130_fd_sc_hd__decap_3
XFILLER_25_573 VGND VGND VPWR VPWR sky130_fd_sc_hd__decap_3
XFILLER_77_1295 VGND VGND VPWR VPWR sky130_fd_sc_hd__decap_3
XFILLER_40_510 VGND VGND VPWR VPWR sky130_fd_sc_hd__fill_1
XFILLER_53_893 VGND VGND VPWR VPWR sky130_fd_sc_hd__decap_3
XFILLER_38_1257 VGND VGND VPWR VPWR sky130_fd_sc_hd__decap_3
XFILLER_73_1148 VGND VGND VPWR VPWR sky130_fd_sc_hd__decap_3
XFILLER_38_1279 VGND VGND VPWR VPWR sky130_fd_sc_hd__decap_3
XFILLER_52_392 VGND VGND VPWR VPWR sky130_fd_sc_hd__decap_3
XFILLER_40_543 VGND VGND VPWR VPWR sky130_fd_sc_hd__fill_2
XFILLER_51_1413 VGND VGND VPWR VPWR sky130_fd_sc_hd__decap_3
XFILLER_12_278 VGND VGND VPWR VPWR sky130_fd_sc_hd__decap_3
XFILLER_8_227 VGND VGND VPWR VPWR sky130_fd_sc_hd__decap_3
XFILLER_51_1446 VGND VGND VPWR VPWR sky130_fd_sc_hd__decap_3
XTAP_TAPCELL_ROW_23_796 VGND VPWR sky130_fd_sc_hd__tapvpwrvgnd_1
XFILLER_51_1457 VGND VGND VPWR VPWR sky130_fd_sc_hd__decap_3
XFILLER_5_912 VGND VGND VPWR VPWR sky130_fd_sc_hd__decap_3
XTAP_TAPCELL_ROW_10_457 VGND VPWR sky130_fd_sc_hd__tapvpwrvgnd_1
XTAP_TAPCELL_ROW_10_468 VGND VPWR sky130_fd_sc_hd__tapvpwrvgnd_1
XFILLER_4_400 VGND VGND VPWR VPWR sky130_fd_sc_hd__decap_3
XTAP_TAPCELL_ROW_39_1207 VGND VPWR sky130_fd_sc_hd__tapvpwrvgnd_1
XFILLER_10_1132 VGND VGND VPWR VPWR sky130_fd_sc_hd__decap_3
XFILLER_5_27 VGND VGND VPWR VPWR sky130_fd_sc_hd__decap_3
XTAP_TAPCELL_ROW_39_1218 VGND VPWR sky130_fd_sc_hd__tapvpwrvgnd_1
XFILLER_4_455 VGND VGND VPWR VPWR sky130_fd_sc_hd__decap_3
XFILLER_49_1331 VGND VGND VPWR VPWR sky130_fd_sc_hd__decap_3
XFILLER_69_30 VGND VGND VPWR VPWR sky130_fd_sc_hd__decap_3
XFILLER_10_1176 VGND VGND VPWR VPWR sky130_fd_sc_hd__decap_3
XFILLER_4_488 VGND VGND VPWR VPWR sky130_fd_sc_hd__decap_3
XFILLER_49_1375 VGND VGND VPWR VPWR sky130_fd_sc_hd__decap_3
XFILLER_80_1108 VGND VGND VPWR VPWR sky130_fd_sc_hd__decap_3
XFILLER_45_1239 VGND VGND VPWR VPWR sky130_fd_sc_hd__decap_3
XFILLER_0_694 VGND VGND VPWR VPWR sky130_fd_sc_hd__decap_3
XFILLER_75_484 VGND VGND VPWR VPWR sky130_fd_sc_hd__decap_3
XFILLER_35_315 VGND VGND VPWR VPWR sky130_fd_sc_hd__fill_2
XFILLER_1_1322 VGND VGND VPWR VPWR sky130_fd_sc_hd__decap_3
XFILLER_35_337 VGND VGND VPWR VPWR sky130_fd_sc_hd__decap_3
XFILLER_21_1272 VGND VGND VPWR VPWR sky130_fd_sc_hd__decap_3
XFILLER_1_1366 VGND VGND VPWR VPWR sky130_fd_sc_hd__decap_3
XFILLER_1_1399 VGND VGND VPWR VPWR sky130_fd_sc_hd__fill_1
XFILLER_56_1335 VGND VGND VPWR VPWR sky130_fd_sc_hd__decap_3
XFILLER_17_1319 VGND VGND VPWR VPWR sky130_fd_sc_hd__decap_3
XFILLER_56_1368 VGND VGND VPWR VPWR sky130_fd_sc_hd__decap_3
XFILLER_56_1379 VGND VGND VPWR VPWR sky130_fd_sc_hd__decap_3
X_5570_ _5570_/A1 _5583_/A2 _5569_/Y _3712_/B VGND VGND VPWR VPWR _6650_/D sky130_fd_sc_hd__a22o_2
XFILLER_79_3 VGND VGND VPWR VPWR sky130_fd_sc_hd__decap_3
XFILLER_15_1065 VGND VGND VPWR VPWR sky130_fd_sc_hd__decap_3
X_4521_ _6268_/Q wire507/X _3330_/X _4875_/B2 VGND VGND VPWR VPWR _4521_/X sky130_fd_sc_hd__a22o_2
XFILLER_8_783 VGND VGND VPWR VPWR sky130_fd_sc_hd__decap_3
XFILLER_7_293 VGND VGND VPWR VPWR sky130_fd_sc_hd__fill_2
X_4452_ _4300_/B _6515_/Q _4480_/S VGND VGND VPWR VPWR _4452_/X sky130_fd_sc_hd__mux2_1
XFILLER_67_1431 VGND VGND VPWR VPWR sky130_fd_sc_hd__decap_3
X_3403_ hold871/X _3402_/X _3425_/S VGND VGND VPWR VPWR _6175_/D sky130_fd_sc_hd__mux2_1
XFILLER_28_1415 VGND VGND VPWR VPWR sky130_fd_sc_hd__decap_3
X_4383_ _6298_/Q _4743_/A2 _3294_/X _4743_/B2 VGND VGND VPWR VPWR _4383_/X sky130_fd_sc_hd__a22o_2
X_6122_ _6970_/CLK _6122_/D load_slew671/X VGND VGND VPWR VPWR _6122_/Q sky130_fd_sc_hd__dfrtp_2
X_3334_ _6294_/Q _6398_/Q VGND VGND VPWR VPWR _3334_/X sky130_fd_sc_hd__xor2_2
XFILLER_63_1328 VGND VGND VPWR VPWR sky130_fd_sc_hd__decap_3
XFILLER_28_1459 VGND VGND VPWR VPWR sky130_fd_sc_hd__decap_3
Xfanout729 fanout730/X VGND VGND VPWR VPWR fanout729/X sky130_fd_sc_hd__clkdlybuf4s25_1
XFILLER_58_407 VGND VGND VPWR VPWR sky130_fd_sc_hd__decap_3
XFILLER_6_1200 VGND VGND VPWR VPWR sky130_fd_sc_hd__decap_3
XFILLER_6_1211 VGND VGND VPWR VPWR sky130_fd_sc_hd__decap_3
X_6053_ _6206_/Q _6053_/A1 _6053_/S VGND VGND VPWR VPWR _6053_/X sky130_fd_sc_hd__mux2_1
X_3265_ _5953_/A0 _3264_/X _3457_/S VGND VGND VPWR VPWR _6106_/D sky130_fd_sc_hd__mux2_1
XFILLER_61_1041 VGND VGND VPWR VPWR sky130_fd_sc_hd__decap_3
Xload_slew185 _3465_/S VGND VGND VPWR VPWR _3463_/S sky130_fd_sc_hd__buf_4
XFILLER_6_1244 VGND VGND VPWR VPWR sky130_fd_sc_hd__decap_3
X_5004_ _5002_/X _5003_/Y _5248_/A2 VGND VGND VPWR VPWR _5006_/S sky130_fd_sc_hd__a21oi_2
Xload_slew196 _3261_/S VGND VGND VPWR VPWR _3455_/S sky130_fd_sc_hd__clkbuf_4
X_3196_ _7063_/Q _3195_/X _3225_/S VGND VGND VPWR VPWR wire29/A sky130_fd_sc_hd__mux2_1
XFILLER_26_1194 VGND VGND VPWR VPWR sky130_fd_sc_hd__decap_3
XFILLER_2_1108 VGND VGND VPWR VPWR sky130_fd_sc_hd__decap_3
XFILLER_6_1288 VGND VGND VPWR VPWR sky130_fd_sc_hd__decap_3
XFILLER_26_304 VGND VGND VPWR VPWR sky130_fd_sc_hd__decap_3
XFILLER_67_996 VGND VGND VPWR VPWR sky130_fd_sc_hd__decap_3
XFILLER_38_175 VGND VGND VPWR VPWR sky130_fd_sc_hd__decap_3
XFILLER_38_197 VGND VGND VPWR VPWR sky130_fd_sc_hd__decap_3
XFILLER_53_134 VGND VGND VPWR VPWR sky130_fd_sc_hd__fill_1
XFILLER_42_808 VGND VGND VPWR VPWR sky130_fd_sc_hd__decap_3
XFILLER_42_819 VGND VGND VPWR VPWR sky130_fd_sc_hd__decap_3
X_6955_ _6987_/CLK _6955_/D load_slew834/X VGND VGND VPWR VPWR _6955_/Q sky130_fd_sc_hd__dfrtp_2
XFILLER_53_167 VGND VGND VPWR VPWR sky130_fd_sc_hd__fill_1
XFILLER_74_1424 VGND VGND VPWR VPWR sky130_fd_sc_hd__decap_3
XFILLER_74_1435 VGND VGND VPWR VPWR sky130_fd_sc_hd__decap_3
X_5906_ _5915_/D _5906_/B _5924_/C _5879_/A VGND VGND VPWR VPWR _5913_/S sky130_fd_sc_hd__or4b_2
X_6886_ _6990_/CLK _6886_/D load_slew751/X VGND VGND VPWR VPWR _6886_/Q sky130_fd_sc_hd__dfrtp_2
XFILLER_74_1468 VGND VGND VPWR VPWR sky130_fd_sc_hd__fill_1
XFILLER_34_392 VGND VGND VPWR VPWR sky130_fd_sc_hd__decap_3
XFILLER_35_1419 VGND VGND VPWR VPWR sky130_fd_sc_hd__decap_3
X_5837_ _5911_/A0 _5837_/A1 _5840_/S VGND VGND VPWR VPWR _6854_/D sky130_fd_sc_hd__mux2_1
XFILLER_14_47 VGND VGND VPWR VPWR sky130_fd_sc_hd__decap_3
XFILLER_22_587 VGND VGND VPWR VPWR sky130_fd_sc_hd__fill_1
XFILLER_72_1170 VGND VGND VPWR VPWR sky130_fd_sc_hd__decap_3
XFILLER_33_1121 VGND VGND VPWR VPWR sky130_fd_sc_hd__fill_1
XTAP_TAPCELL_ROW_20_711 VGND VPWR sky130_fd_sc_hd__tapvpwrvgnd_1
XTAP_TAPCELL_ROW_79_2244 VGND VPWR sky130_fd_sc_hd__tapvpwrvgnd_1
XTAP_TAPCELL_ROW_20_722 VGND VPWR sky130_fd_sc_hd__tapvpwrvgnd_1
X_5768_ _5769_/A _6085_/C VGND VGND VPWR VPWR _5868_/A sky130_fd_sc_hd__nor2_2
XTAP_TAPCELL_ROW_79_2255 VGND VPWR sky130_fd_sc_hd__tapvpwrvgnd_1
XTAP_TAPCELL_ROW_20_733 VGND VPWR sky130_fd_sc_hd__tapvpwrvgnd_1
XTAP_TAPCELL_ROW_79_2266 VGND VPWR sky130_fd_sc_hd__tapvpwrvgnd_1
X_4719_ _4896_/A1 _4716_/X _4717_/Y _4718_/X _4896_/C1 VGND VGND VPWR VPWR _4719_/X
+ sky130_fd_sc_hd__o221a_2
XFILLER_33_1198 VGND VGND VPWR VPWR sky130_fd_sc_hd__fill_1
X_5699_ _5699_/A0 _5902_/A0 _5702_/S VGND VGND VPWR VPWR _6750_/D sky130_fd_sc_hd__mux2_1
XFILLER_68_1217 VGND VGND VPWR VPWR sky130_fd_sc_hd__decap_3
XFILLER_11_1452 VGND VGND VPWR VPWR sky130_fd_sc_hd__decap_3
XFILLER_11_1463 VGND VGND VPWR VPWR sky130_fd_sc_hd__decap_3
XFILLER_2_937 VGND VGND VPWR VPWR sky130_fd_sc_hd__decap_3
XFILLER_1_414 VGND VGND VPWR VPWR sky130_fd_sc_hd__decap_3
XFILLER_1_458 VGND VGND VPWR VPWR sky130_fd_sc_hd__fill_2
XFILLER_77_749 VGND VGND VPWR VPWR sky130_fd_sc_hd__decap_3
XFILLER_44_1261 VGND VGND VPWR VPWR sky130_fd_sc_hd__decap_3
XFILLER_40_1125 VGND VGND VPWR VPWR sky130_fd_sc_hd__decap_3
XFILLER_44_1294 VGND VGND VPWR VPWR sky130_fd_sc_hd__decap_3
XFILLER_79_1313 VGND VGND VPWR VPWR sky130_fd_sc_hd__decap_3
XFILLER_18_816 VGND VGND VPWR VPWR sky130_fd_sc_hd__fill_1
Xhold1450 _6649_/Q VGND VGND VPWR VPWR _5566_/B1 sky130_fd_sc_hd__dlygate4sd3_1
XFILLER_73_922 VGND VGND VPWR VPWR sky130_fd_sc_hd__decap_3
XFILLER_17_304 VGND VGND VPWR VPWR sky130_fd_sc_hd__decap_3
XFILLER_18_827 VGND VGND VPWR VPWR sky130_fd_sc_hd__decap_3
Xhold1461 _6550_/Q VGND VGND VPWR VPWR _5438_/A1 sky130_fd_sc_hd__dlygate4sd3_1
Xhold1472 _6770_/Q VGND VGND VPWR VPWR _5723_/A1 sky130_fd_sc_hd__dlygate4sd3_1
Xhold1483 _6588_/Q VGND VGND VPWR VPWR _5476_/A1 sky130_fd_sc_hd__dlygate4sd3_1
XTAP_TAPCELL_ROW_4_296 VGND VPWR sky130_fd_sc_hd__tapvpwrvgnd_1
XFILLER_72_421 VGND VGND VPWR VPWR sky130_fd_sc_hd__decap_3
XFILLER_18_849 VGND VGND VPWR VPWR sky130_fd_sc_hd__decap_3
XFILLER_79_1357 VGND VGND VPWR VPWR sky130_fd_sc_hd__decap_3
Xhold1494 _6489_/Q VGND VGND VPWR VPWR _5377_/A1 sky130_fd_sc_hd__dlygate4sd3_1
XFILLER_55_54 VGND VGND VPWR VPWR sky130_fd_sc_hd__fill_2
XTAP_TAPCELL_ROW_68_1970 VGND VPWR sky130_fd_sc_hd__tapvpwrvgnd_1
XTAP_TAPCELL_ROW_68_1981 VGND VPWR sky130_fd_sc_hd__tapvpwrvgnd_1
XFILLER_25_370 VGND VGND VPWR VPWR sky130_fd_sc_hd__decap_3
XFILLER_77_1092 VGND VGND VPWR VPWR sky130_fd_sc_hd__decap_3
XFILLER_38_1043 VGND VGND VPWR VPWR sky130_fd_sc_hd__decap_3
XTAP_TAPCELL_ROW_64_1856 VGND VPWR sky130_fd_sc_hd__tapvpwrvgnd_1
XTAP_TAPCELL_ROW_64_1867 VGND VPWR sky130_fd_sc_hd__tapvpwrvgnd_1
XFILLER_38_1065 VGND VGND VPWR VPWR sky130_fd_sc_hd__fill_1
XFILLER_71_42 VGND VGND VPWR VPWR sky130_fd_sc_hd__decap_3
XFILLER_13_554 VGND VGND VPWR VPWR sky130_fd_sc_hd__decap_3
XFILLER_9_514 VGND VGND VPWR VPWR sky130_fd_sc_hd__decap_3
XFILLER_16_1341 VGND VGND VPWR VPWR sky130_fd_sc_hd__decap_3
XFILLER_55_1390 VGND VGND VPWR VPWR sky130_fd_sc_hd__decap_3
XFILLER_9_569 VGND VGND VPWR VPWR sky130_fd_sc_hd__decap_3
XFILLER_12_1205 VGND VGND VPWR VPWR sky130_fd_sc_hd__decap_3
XFILLER_51_1254 VGND VGND VPWR VPWR sky130_fd_sc_hd__decap_3
XFILLER_16_1385 VGND VGND VPWR VPWR sky130_fd_sc_hd__decap_3
XFILLER_12_1238 VGND VGND VPWR VPWR sky130_fd_sc_hd__decap_3
XFILLER_51_1287 VGND VGND VPWR VPWR sky130_fd_sc_hd__fill_1
XFILLER_51_1298 VGND VGND VPWR VPWR sky130_fd_sc_hd__decap_3
XFILLER_65_9 VGND VGND VPWR VPWR sky130_fd_sc_hd__decap_3
XFILLER_49_1161 VGND VGND VPWR VPWR sky130_fd_sc_hd__fill_2
XFILLER_45_1003 VGND VGND VPWR VPWR sky130_fd_sc_hd__decap_3
XFILLER_1_992 VGND VGND VPWR VPWR sky130_fd_sc_hd__decap_3
XFILLER_23_1301 VGND VGND VPWR VPWR sky130_fd_sc_hd__decap_3
XFILLER_62_1350 VGND VGND VPWR VPWR sky130_fd_sc_hd__decap_3
XFILLER_0_480 VGND VGND VPWR VPWR sky130_fd_sc_hd__decap_3
X_3050_ _6346_/Q VGND VGND VPWR VPWR _3050_/Y sky130_fd_sc_hd__inv_2
XFILLER_67_248 VGND VGND VPWR VPWR sky130_fd_sc_hd__fill_2
XFILLER_23_1334 VGND VGND VPWR VPWR sky130_fd_sc_hd__decap_3
XFILLER_23_1345 VGND VGND VPWR VPWR sky130_fd_sc_hd__decap_3
XFILLER_62_1394 VGND VGND VPWR VPWR sky130_fd_sc_hd__decap_3
XFILLER_3_1428 VGND VGND VPWR VPWR sky130_fd_sc_hd__decap_3
XFILLER_48_462 VGND VGND VPWR VPWR sky130_fd_sc_hd__decap_3
XFILLER_23_1378 VGND VGND VPWR VPWR sky130_fd_sc_hd__decap_3
XFILLER_75_270 VGND VGND VPWR VPWR sky130_fd_sc_hd__fill_1
XFILLER_1_1130 VGND VGND VPWR VPWR sky130_fd_sc_hd__decap_3
XFILLER_35_134 VGND VGND VPWR VPWR sky130_fd_sc_hd__decap_3
XFILLER_51_605 VGND VGND VPWR VPWR sky130_fd_sc_hd__decap_3
XFILLER_1_1163 VGND VGND VPWR VPWR sky130_fd_sc_hd__decap_3
X_6740_ _6772_/CLK _6740_/D fanout832/X VGND VGND VPWR VPWR _6740_/Q sky130_fd_sc_hd__dfrtp_2
XFILLER_35_189 VGND VGND VPWR VPWR sky130_fd_sc_hd__decap_3
X_3952_ _4303_/A _3952_/B VGND VGND VPWR VPWR _4101_/B sky130_fd_sc_hd__xnor2_2
XFILLER_56_1143 VGND VGND VPWR VPWR sky130_fd_sc_hd__decap_3
XFILLER_16_392 VGND VGND VPWR VPWR sky130_fd_sc_hd__fill_2
X_6671_ _6991_/CLK _6671_/D wire796/X VGND VGND VPWR VPWR _6671_/Q sky130_fd_sc_hd__dfrtp_2
XFILLER_52_1007 VGND VGND VPWR VPWR sky130_fd_sc_hd__decap_3
XFILLER_56_1176 VGND VGND VPWR VPWR sky130_fd_sc_hd__decap_3
X_3883_ _3883_/A _3883_/B VGND VGND VPWR VPWR _3938_/B sky130_fd_sc_hd__xnor2_2
XFILLER_32_885 VGND VGND VPWR VPWR sky130_fd_sc_hd__fill_1
XTAP_TAPCELL_ROW_14_560 VGND VPWR sky130_fd_sc_hd__tapvpwrvgnd_1
XTAP_TAPCELL_ROW_14_571 VGND VPWR sky130_fd_sc_hd__tapvpwrvgnd_1
X_5622_ hold889/X _5900_/A0 _5627_/S VGND VGND VPWR VPWR _6684_/D sky130_fd_sc_hd__mux2_1
XFILLER_34_1441 VGND VGND VPWR VPWR sky130_fd_sc_hd__decap_3
Xclkbuf_3_7_0_clk clkbuf_0_clk/X VGND VGND VPWR VPWR clkbuf_3_7_0_clk/X sky130_fd_sc_hd__clkbuf_8
X_5553_ _6354_/Q _5564_/A2 _5553_/B1 _5564_/B2 VGND VGND VPWR VPWR _6636_/D sky130_fd_sc_hd__a22o_2
XFILLER_30_1338 VGND VGND VPWR VPWR sky130_fd_sc_hd__decap_3
X_4504_ _6522_/Q _4526_/B VGND VGND VPWR VPWR _4504_/Y sky130_fd_sc_hd__nand2_2
XTAP_TAPCELL_ROW_74_2130 VGND VPWR sky130_fd_sc_hd__tapvpwrvgnd_1
X_5484_ _5484_/A1 _5484_/A2 _4085_/X VGND VGND VPWR VPWR _6596_/D sky130_fd_sc_hd__a21o_2
X_4435_ _6850_/Q _4790_/A2 _4869_/B1 _4434_/X VGND VGND VPWR VPWR _4435_/X sky130_fd_sc_hd__a211o_2
XTAP_TAPCELL_ROW_70_2016 VGND VPWR sky130_fd_sc_hd__tapvpwrvgnd_1
XTAP_TAPCELL_ROW_70_2027 VGND VPWR sky130_fd_sc_hd__tapvpwrvgnd_1
XFILLER_67_1272 VGND VGND VPWR VPWR sky130_fd_sc_hd__decap_3
XFILLER_28_1234 VGND VGND VPWR VPWR sky130_fd_sc_hd__decap_3
Xfanout504 _4773_/A2 VGND VGND VPWR VPWR _5358_/D sky130_fd_sc_hd__clkdlybuf4s25_1
XFILLER_8_1306 VGND VGND VPWR VPWR sky130_fd_sc_hd__decap_3
X_4366_ _6842_/Q _4751_/A2 wire36/X _4365_/X VGND VGND VPWR VPWR _4366_/X sky130_fd_sc_hd__a211o_2
XFILLER_8_1317 VGND VGND VPWR VPWR sky130_fd_sc_hd__decap_3
Xfanout526 _5348_/S VGND VGND VPWR VPWR _5182_/B sky130_fd_sc_hd__clkdlybuf4s25_1
X_6105_ _7012_/CLK _6105_/D load_slew810/X VGND VGND VPWR VPWR _6105_/Q sky130_fd_sc_hd__dfrtp_2
XFILLER_28_1267 VGND VGND VPWR VPWR sky130_fd_sc_hd__decap_3
Xfanout537 wire540/A VGND VGND VPWR VPWR _5164_/B sky130_fd_sc_hd__clkdlybuf4s25_1
X_3317_ _5979_/A0 _3316_/X _3461_/S VGND VGND VPWR VPWR _6132_/D sky130_fd_sc_hd__mux2_1
Xfanout559 _3172_/S VGND VGND VPWR VPWR _3191_/S sky130_fd_sc_hd__clkdlybuf4s25_1
X_7085_ _7090_/CLK _7085_/D fanout740/X VGND VGND VPWR VPWR _7085_/Q sky130_fd_sc_hd__dfrtp_2
XFILLER_80_1450 VGND VGND VPWR VPWR sky130_fd_sc_hd__decap_3
X_4297_ _6338_/Q _4861_/A2 _3262_/X _4861_/B2 VGND VGND VPWR VPWR _4297_/X sky130_fd_sc_hd__a22o_2
XFILLER_41_1401 VGND VGND VPWR VPWR sky130_fd_sc_hd__decap_3
X_6036_ _6036_/A0 _6036_/A1 _6052_/S VGND VGND VPWR VPWR _7040_/D sky130_fd_sc_hd__mux2_1
X_3248_ _6259_/Q _6355_/Q VGND VGND VPWR VPWR _3248_/X sky130_fd_sc_hd__xor2_2
XFILLER_41_1434 VGND VGND VPWR VPWR sky130_fd_sc_hd__decap_3
XFILLER_55_900 VGND VGND VPWR VPWR sky130_fd_sc_hd__decap_3
XFILLER_67_771 VGND VGND VPWR VPWR sky130_fd_sc_hd__decap_3
XFILLER_55_922 VGND VGND VPWR VPWR sky130_fd_sc_hd__decap_3
XFILLER_6_1096 VGND VGND VPWR VPWR sky130_fd_sc_hd__decap_3
XTAP_TAPCELL_ROW_1_222 VGND VPWR sky130_fd_sc_hd__tapvpwrvgnd_1
XTAP_TAPCELL_ROW_1_233 VGND VPWR sky130_fd_sc_hd__tapvpwrvgnd_1
XFILLER_54_421 VGND VGND VPWR VPWR sky130_fd_sc_hd__decap_3
X_3179_ _3212_/A1 _6966_/Q _6974_/Q _3219_/B2 VGND VGND VPWR VPWR _3179_/X sky130_fd_sc_hd__a22o_2
XFILLER_14_318 VGND VGND VPWR VPWR sky130_fd_sc_hd__decap_3
X_6938_ _7073_/CLK _6938_/D load_slew674/X VGND VGND VPWR VPWR _6938_/Q sky130_fd_sc_hd__dfrtp_2
XFILLER_74_1232 VGND VGND VPWR VPWR sky130_fd_sc_hd__decap_3
XFILLER_23_830 VGND VGND VPWR VPWR sky130_fd_sc_hd__fill_1
XFILLER_25_57 VGND VGND VPWR VPWR sky130_fd_sc_hd__decap_3
XTAP_TAPCELL_ROW_25_847 VGND VPWR sky130_fd_sc_hd__tapvpwrvgnd_1
XFILLER_39_1363 VGND VGND VPWR VPWR sky130_fd_sc_hd__decap_3
XTAP_TAPCELL_ROW_25_858 VGND VPWR sky130_fd_sc_hd__tapvpwrvgnd_1
XFILLER_74_1276 VGND VGND VPWR VPWR sky130_fd_sc_hd__decap_3
XTAP_TAPCELL_ROW_12_508 VGND VPWR sky130_fd_sc_hd__tapvpwrvgnd_1
XFILLER_23_874 VGND VGND VPWR VPWR sky130_fd_sc_hd__decap_3
XFILLER_35_1227 VGND VGND VPWR VPWR sky130_fd_sc_hd__decap_3
XFILLER_39_1396 VGND VGND VPWR VPWR sky130_fd_sc_hd__decap_3
X_6869_ _7032_/CLK _6869_/D load_slew694/X VGND VGND VPWR VPWR _6869_/Q sky130_fd_sc_hd__dfrtp_2
XFILLER_70_1129 VGND VGND VPWR VPWR sky130_fd_sc_hd__decap_3
XTAP_TAPCELL_ROW_12_519 VGND VPWR sky130_fd_sc_hd__tapvpwrvgnd_1
XFILLER_10_513 VGND VGND VPWR VPWR sky130_fd_sc_hd__decap_3
XFILLER_22_373 VGND VGND VPWR VPWR sky130_fd_sc_hd__decap_3
XFILLER_41_12 VGND VGND VPWR VPWR sky130_fd_sc_hd__decap_3
XFILLER_10_546 VGND VGND VPWR VPWR sky130_fd_sc_hd__decap_3
XFILLER_10_579 VGND VGND VPWR VPWR sky130_fd_sc_hd__decap_3
XFILLER_6_528 VGND VGND VPWR VPWR sky130_fd_sc_hd__decap_3
XFILLER_6_539 VGND VGND VPWR VPWR sky130_fd_sc_hd__decap_3
XFILLER_11_1260 VGND VGND VPWR VPWR sky130_fd_sc_hd__decap_3
XFILLER_2_701 VGND VGND VPWR VPWR sky130_fd_sc_hd__decap_3
XFILLER_9_3 VGND VGND VPWR VPWR sky130_fd_sc_hd__decap_3
XFILLER_1_211 VGND VGND VPWR VPWR sky130_fd_sc_hd__decap_3
XFILLER_2_734 VGND VGND VPWR VPWR sky130_fd_sc_hd__decap_3
XFILLER_46_1312 VGND VGND VPWR VPWR sky130_fd_sc_hd__decap_3
XTAP_TAPCELL_ROW_57_1671 VGND VPWR sky130_fd_sc_hd__tapvpwrvgnd_1
XFILLER_46_1323 VGND VGND VPWR VPWR sky130_fd_sc_hd__decap_3
XTAP_TAPCELL_ROW_57_1682 VGND VPWR sky130_fd_sc_hd__tapvpwrvgnd_1
XTAP_TAPCELL_ROW_57_1693 VGND VPWR sky130_fd_sc_hd__tapvpwrvgnd_1
XFILLER_1_255 VGND VGND VPWR VPWR sky130_fd_sc_hd__decap_3
XFILLER_46_1356 VGND VGND VPWR VPWR sky130_fd_sc_hd__decap_3
XTAP_TAPCELL_ROW_53_1568 VGND VPWR sky130_fd_sc_hd__tapvpwrvgnd_1
XFILLER_77_535 VGND VGND VPWR VPWR sky130_fd_sc_hd__decap_3
XTAP_TAPCELL_ROW_53_1579 VGND VPWR sky130_fd_sc_hd__tapvpwrvgnd_1
XFILLER_1_299 VGND VGND VPWR VPWR sky130_fd_sc_hd__decap_3
XFILLER_44_1091 VGND VGND VPWR VPWR sky130_fd_sc_hd__fill_1
XFILLER_79_1121 VGND VGND VPWR VPWR sky130_fd_sc_hd__decap_3
XFILLER_46_944 VGND VGND VPWR VPWR sky130_fd_sc_hd__fill_1
Xhold1280 _6647_/Q VGND VGND VPWR VPWR _5564_/B1 sky130_fd_sc_hd__dlygate4sd3_1
XFILLER_79_1154 VGND VGND VPWR VPWR sky130_fd_sc_hd__decap_3
XFILLER_46_966 VGND VGND VPWR VPWR sky130_fd_sc_hd__decap_3
Xhold1291 _6877_/Q VGND VGND VPWR VPWR _5863_/A0 sky130_fd_sc_hd__dlygate4sd3_1
XTAP_TAPCELL_ROW_66_1907 VGND VPWR sky130_fd_sc_hd__tapvpwrvgnd_1
XTAP_TAPCELL_ROW_66_1918 VGND VPWR sky130_fd_sc_hd__tapvpwrvgnd_1
XFILLER_2_1450 VGND VGND VPWR VPWR sky130_fd_sc_hd__decap_3
XFILLER_61_903 VGND VGND VPWR VPWR sky130_fd_sc_hd__decap_3
XTAP_TAPCELL_ROW_66_1929 VGND VPWR sky130_fd_sc_hd__tapvpwrvgnd_1
XFILLER_72_251 VGND VGND VPWR VPWR sky130_fd_sc_hd__fill_1
XFILLER_79_1198 VGND VGND VPWR VPWR sky130_fd_sc_hd__decap_3
XFILLER_75_1029 VGND VGND VPWR VPWR sky130_fd_sc_hd__decap_3
XFILLER_72_262 VGND VGND VPWR VPWR sky130_fd_sc_hd__decap_3
XFILLER_14_830 VGND VGND VPWR VPWR sky130_fd_sc_hd__fill_1
XFILLER_18_1403 VGND VGND VPWR VPWR sky130_fd_sc_hd__decap_3
XFILLER_32_137 VGND VGND VPWR VPWR sky130_fd_sc_hd__decap_3
XFILLER_57_1452 VGND VGND VPWR VPWR sky130_fd_sc_hd__decap_3
XFILLER_57_1463 VGND VGND VPWR VPWR sky130_fd_sc_hd__decap_3
XFILLER_60_457 VGND VGND VPWR VPWR sky130_fd_sc_hd__decap_3
XFILLER_53_1316 VGND VGND VPWR VPWR sky130_fd_sc_hd__decap_3
XFILLER_18_1447 VGND VGND VPWR VPWR sky130_fd_sc_hd__decap_3
XFILLER_41_671 VGND VGND VPWR VPWR sky130_fd_sc_hd__fill_1
XFILLER_14_896 VGND VGND VPWR VPWR sky130_fd_sc_hd__decap_3
XFILLER_41_693 VGND VGND VPWR VPWR sky130_fd_sc_hd__decap_3
XFILLER_16_1160 VGND VGND VPWR VPWR sky130_fd_sc_hd__decap_3
XFILLER_51_1073 VGND VGND VPWR VPWR sky130_fd_sc_hd__decap_3
XFILLER_9_399 VGND VGND VPWR VPWR sky130_fd_sc_hd__decap_3
XFILLER_63_6 VGND VGND VPWR VPWR sky130_fd_sc_hd__decap_3
XFILLER_12_1079 VGND VGND VPWR VPWR sky130_fd_sc_hd__decap_3
XFILLER_5_561 VGND VGND VPWR VPWR sky130_fd_sc_hd__decap_3
XFILLER_5_594 VGND VGND VPWR VPWR sky130_fd_sc_hd__decap_3
XFILLER_64_1412 VGND VGND VPWR VPWR sky130_fd_sc_hd__decap_3
X_4220_ _4222_/A _4220_/B VGND VGND VPWR VPWR _4304_/A sky130_fd_sc_hd__xnor2_2
XFILLER_25_1407 VGND VGND VPWR VPWR sky130_fd_sc_hd__decap_3
XFILLER_64_1456 VGND VGND VPWR VPWR sky130_fd_sc_hd__decap_3
X_4151_ _4232_/B _4231_/A VGND VGND VPWR VPWR _4153_/A sky130_fd_sc_hd__xor2_2
XFILLER_60_1309 VGND VGND VPWR VPWR sky130_fd_sc_hd__decap_3
X_3102_ _3206_/S _7075_/Q VGND VGND VPWR VPWR _3108_/A sky130_fd_sc_hd__nor2_4
XFILLER_37_900 VGND VGND VPWR VPWR sky130_fd_sc_hd__decap_3
X_4082_ _4088_/A1 _4768_/A _4312_/B _5515_/A1 _6596_/Q VGND VGND VPWR VPWR _4082_/X
+ sky130_fd_sc_hd__a32o_2
XFILLER_7_1372 VGND VGND VPWR VPWR sky130_fd_sc_hd__decap_3
XFILLER_49_771 VGND VGND VPWR VPWR sky130_fd_sc_hd__decap_3
XFILLER_3_1225 VGND VGND VPWR VPWR sky130_fd_sc_hd__decap_3
XFILLER_55_218 VGND VGND VPWR VPWR sky130_fd_sc_hd__decap_3
XFILLER_49_793 VGND VGND VPWR VPWR sky130_fd_sc_hd__decap_3
XFILLER_3_1236 VGND VGND VPWR VPWR sky130_fd_sc_hd__decap_3
XFILLER_36_421 VGND VGND VPWR VPWR sky130_fd_sc_hd__fill_1
XFILLER_64_730 VGND VGND VPWR VPWR sky130_fd_sc_hd__decap_3
XFILLER_3_1269 VGND VGND VPWR VPWR sky130_fd_sc_hd__decap_3
XFILLER_23_1197 VGND VGND VPWR VPWR sky130_fd_sc_hd__fill_2
XFILLER_64_774 VGND VGND VPWR VPWR sky130_fd_sc_hd__decap_3
XFILLER_52_925 VGND VGND VPWR VPWR sky130_fd_sc_hd__fill_2
XFILLER_58_1249 VGND VGND VPWR VPWR sky130_fd_sc_hd__decap_3
XTAP_TAPCELL_ROW_19_685 VGND VPWR sky130_fd_sc_hd__tapvpwrvgnd_1
XFILLER_63_284 VGND VGND VPWR VPWR sky130_fd_sc_hd__fill_2
XTAP_TAPCELL_ROW_19_696 VGND VPWR sky130_fd_sc_hd__tapvpwrvgnd_1
XFILLER_23_126 VGND VGND VPWR VPWR sky130_fd_sc_hd__decap_3
X_4984_ _6693_/Q _3059_/Y _5332_/S VGND VGND VPWR VPWR _4984_/X sky130_fd_sc_hd__mux2_1
XFILLER_17_690 VGND VGND VPWR VPWR sky130_fd_sc_hd__fill_2
XFILLER_23_159 VGND VGND VPWR VPWR sky130_fd_sc_hd__decap_3
X_6723_ _7019_/CLK _6723_/D fanout838/X VGND VGND VPWR VPWR _6723_/Q sky130_fd_sc_hd__dfrtp_2
XFILLER_71_1416 VGND VGND VPWR VPWR sky130_fd_sc_hd__decap_3
X_3935_ _4049_/A1 _3916_/X _3934_/X VGND VGND VPWR VPWR _3935_/X sky130_fd_sc_hd__o21a_2
XFILLER_71_1449 VGND VGND VPWR VPWR sky130_fd_sc_hd__decap_3
X_6654_ _7065_/CLK _6654_/D fanout768/A VGND VGND VPWR VPWR _6654_/Q sky130_fd_sc_hd__dfrtp_2
X_3866_ _4010_/A _6300_/Q VGND VGND VPWR VPWR _3866_/X sky130_fd_sc_hd__and2b_2
X_5605_ _5581_/A _5607_/A2 _5605_/A3 _5602_/Y _5605_/B2 VGND VGND VPWR VPWR _6676_/D
+ sky130_fd_sc_hd__a32o_2
X_6585_ _6958_/CLK _6585_/D fanout759/X VGND VGND VPWR VPWR _6585_/Q sky130_fd_sc_hd__dfrtp_2
XFILLER_34_1282 VGND VGND VPWR VPWR sky130_fd_sc_hd__decap_3
X_3797_ _4008_/B wire154/X _5605_/A3 _3089_/B _6498_/Q VGND VGND VPWR VPWR _3797_/X
+ sky130_fd_sc_hd__a32o_2
XFILLER_69_1301 VGND VGND VPWR VPWR sky130_fd_sc_hd__decap_3
XFILLER_11_15 VGND VGND VPWR VPWR sky130_fd_sc_hd__decap_3
X_5536_ _6369_/Q _5564_/A2 _5536_/B1 _5552_/B2 VGND VGND VPWR VPWR _6619_/D sky130_fd_sc_hd__a22o_2
XFILLER_69_1334 VGND VGND VPWR VPWR sky130_fd_sc_hd__decap_3
XFILLER_69_1345 VGND VGND VPWR VPWR sky130_fd_sc_hd__decap_3
X_5467_ _5467_/A1 _5470_/A2 _4810_/X VGND VGND VPWR VPWR _6579_/D sky130_fd_sc_hd__a21o_2
XFILLER_69_1378 VGND VGND VPWR VPWR sky130_fd_sc_hd__decap_3
X_4418_ _6278_/Q wire54/X _4415_/X _4417_/X VGND VGND VPWR VPWR _6278_/D sky130_fd_sc_hd__o22a_2
X_5398_ _5398_/A1 _5456_/A2 _4415_/X VGND VGND VPWR VPWR _6510_/D sky130_fd_sc_hd__a21o_2
Xfanout301 fanout302/X VGND VGND VPWR VPWR _4766_/A2 sky130_fd_sc_hd__clkdlybuf4s25_1
XFILLER_8_1114 VGND VGND VPWR VPWR sky130_fd_sc_hd__decap_3
Xfanout312 _3106_/Y VGND VGND VPWR VPWR _3220_/C1 sky130_fd_sc_hd__clkdlybuf4s25_1
Xfanout323 _3084_/Y VGND VGND VPWR VPWR _4088_/A1 sky130_fd_sc_hd__clkdlybuf4s25_1
Xfanout334 _4771_/A1 VGND VGND VPWR VPWR _4887_/B sky130_fd_sc_hd__clkdlybuf4s25_1
XTAP_TAPCELL_ROW_6_347 VGND VPWR sky130_fd_sc_hd__tapvpwrvgnd_1
X_4349_ _4349_/A _4349_/B VGND VGND VPWR VPWR _4894_/B sky130_fd_sc_hd__xnor2_2
XFILLER_8_1147 VGND VGND VPWR VPWR sky130_fd_sc_hd__fill_1
XTAP_TAPCELL_ROW_6_358 VGND VPWR sky130_fd_sc_hd__tapvpwrvgnd_1
Xfanout345 _3722_/X VGND VGND VPWR VPWR _4762_/B sky130_fd_sc_hd__clkdlybuf4s25_1
XFILLER_8_1158 VGND VGND VPWR VPWR sky130_fd_sc_hd__decap_3
XFILLER_28_1086 VGND VGND VPWR VPWR sky130_fd_sc_hd__decap_3
Xfanout356 _3721_/Y VGND VGND VPWR VPWR _3902_/C1 sky130_fd_sc_hd__clkdlybuf4s25_1
XTAP_TAPCELL_ROW_6_369 VGND VPWR sky130_fd_sc_hd__tapvpwrvgnd_1
XFILLER_59_557 VGND VGND VPWR VPWR sky130_fd_sc_hd__decap_3
Xfanout378 fanout395/X VGND VGND VPWR VPWR _4750_/B2 sky130_fd_sc_hd__clkdlybuf4s25_1
Xfanout389 fanout390/X VGND VGND VPWR VPWR _4854_/B2 sky130_fd_sc_hd__clkdlybuf4s25_1
XFILLER_47_719 VGND VGND VPWR VPWR sky130_fd_sc_hd__fill_1
X_7068_ _7096_/CLK _7068_/D load_slew677/X VGND VGND VPWR VPWR _7068_/Q sky130_fd_sc_hd__dfrtp_2
XFILLER_41_1242 VGND VGND VPWR VPWR sky130_fd_sc_hd__decap_3
XFILLER_46_218 VGND VGND VPWR VPWR sky130_fd_sc_hd__decap_3
X_6019_ hold989/X _6019_/A1 _6051_/S VGND VGND VPWR VPWR _7023_/D sky130_fd_sc_hd__mux2_1
XFILLER_39_281 VGND VGND VPWR VPWR sky130_fd_sc_hd__decap_3
XFILLER_41_1275 VGND VGND VPWR VPWR sky130_fd_sc_hd__decap_3
XFILLER_54_240 VGND VGND VPWR VPWR sky130_fd_sc_hd__decap_3
XFILLER_36_78 VGND VGND VPWR VPWR sky130_fd_sc_hd__decap_3
XFILLER_43_925 VGND VGND VPWR VPWR sky130_fd_sc_hd__fill_1
XFILLER_55_785 VGND VGND VPWR VPWR sky130_fd_sc_hd__decap_3
XFILLER_76_1338 VGND VGND VPWR VPWR sky130_fd_sc_hd__decap_3
XFILLER_36_89 VGND VGND VPWR VPWR sky130_fd_sc_hd__decap_3
XFILLER_70_733 VGND VGND VPWR VPWR sky130_fd_sc_hd__fill_2
XFILLER_42_424 VGND VGND VPWR VPWR sky130_fd_sc_hd__decap_3
XFILLER_54_295 VGND VGND VPWR VPWR sky130_fd_sc_hd__decap_3
XFILLER_74_1040 VGND VGND VPWR VPWR sky130_fd_sc_hd__decap_3
XFILLER_70_766 VGND VGND VPWR VPWR sky130_fd_sc_hd__decap_3
XFILLER_14_159 VGND VGND VPWR VPWR sky130_fd_sc_hd__fill_2
XFILLER_42_468 VGND VGND VPWR VPWR sky130_fd_sc_hd__decap_3
XFILLER_35_1002 VGND VGND VPWR VPWR sky130_fd_sc_hd__decap_3
XFILLER_23_660 VGND VGND VPWR VPWR sky130_fd_sc_hd__decap_3
XTAP_TAPCELL_ROW_46_1394 VGND VPWR sky130_fd_sc_hd__tapvpwrvgnd_1
XFILLER_52_55 VGND VGND VPWR VPWR sky130_fd_sc_hd__fill_1
XFILLER_10_332 VGND VGND VPWR VPWR sky130_fd_sc_hd__decap_3
XFILLER_35_1068 VGND VGND VPWR VPWR sky130_fd_sc_hd__fill_1
XFILLER_52_88 VGND VGND VPWR VPWR sky130_fd_sc_hd__fill_1
XFILLER_13_1322 VGND VGND VPWR VPWR sky130_fd_sc_hd__decap_3
XFILLER_10_365 VGND VGND VPWR VPWR sky130_fd_sc_hd__decap_3
XFILLER_52_1371 VGND VGND VPWR VPWR sky130_fd_sc_hd__fill_1
XFILLER_52_1382 VGND VGND VPWR VPWR sky130_fd_sc_hd__decap_3
XFILLER_13_1366 VGND VGND VPWR VPWR sky130_fd_sc_hd__decap_3
XTAP_TAPCELL_ROW_59_1722 VGND VPWR sky130_fd_sc_hd__tapvpwrvgnd_1
XTAP_TAPCELL_ROW_59_1733 VGND VPWR sky130_fd_sc_hd__tapvpwrvgnd_1
XTAP_TAPCELL_ROW_59_1744 VGND VPWR sky130_fd_sc_hd__tapvpwrvgnd_1
XFILLER_13_1399 VGND VGND VPWR VPWR sky130_fd_sc_hd__fill_1
XFILLER_48_1418 VGND VGND VPWR VPWR sky130_fd_sc_hd__decap_3
XFILLER_48_1429 VGND VGND VPWR VPWR sky130_fd_sc_hd__decap_3
XTAP_TAPCELL_ROW_55_1619 VGND VPWR sky130_fd_sc_hd__tapvpwrvgnd_1
XFILLER_11_1090 VGND VGND VPWR VPWR sky130_fd_sc_hd__decap_3
Xload_slew707 fanout706/X VGND VGND VPWR VPWR load_slew707/X sky130_fd_sc_hd__buf_2
Xload_slew718 fanout717/X VGND VGND VPWR VPWR load_slew718/X sky130_fd_sc_hd__clkbuf_4
XFILLER_78_822 VGND VGND VPWR VPWR sky130_fd_sc_hd__fill_1
XFILLER_77_30 VGND VGND VPWR VPWR sky130_fd_sc_hd__decap_3
XFILLER_46_1175 VGND VGND VPWR VPWR sky130_fd_sc_hd__decap_3
XFILLER_77_63 VGND VGND VPWR VPWR sky130_fd_sc_hd__decap_3
XFILLER_28_9 VGND VGND VPWR VPWR sky130_fd_sc_hd__fill_1
XFILLER_77_96 VGND VGND VPWR VPWR sky130_fd_sc_hd__fill_1
XFILLER_65_505 VGND VGND VPWR VPWR sky130_fd_sc_hd__decap_3
XFILLER_24_1462 VGND VGND VPWR VPWR sky130_fd_sc_hd__decap_3
XFILLER_18_421 VGND VGND VPWR VPWR sky130_fd_sc_hd__decap_3
XFILLER_20_1315 VGND VGND VPWR VPWR sky130_fd_sc_hd__fill_1
XFILLER_20_1326 VGND VGND VPWR VPWR sky130_fd_sc_hd__decap_3
XFILLER_80_508 VGND VGND VPWR VPWR sky130_fd_sc_hd__decap_3
XTAP_TAPCELL_ROW_29_950 VGND VPWR sky130_fd_sc_hd__tapvpwrvgnd_1
XFILLER_46_763 VGND VGND VPWR VPWR sky130_fd_sc_hd__decap_3
XFILLER_20_1359 VGND VGND VPWR VPWR sky130_fd_sc_hd__decap_3
XTAP_TAPCELL_ROW_29_961 VGND VPWR sky130_fd_sc_hd__tapvpwrvgnd_1
XFILLER_33_402 VGND VGND VPWR VPWR sky130_fd_sc_hd__decap_3
XFILLER_46_796 VGND VGND VPWR VPWR sky130_fd_sc_hd__decap_3
XFILLER_73_582 VGND VGND VPWR VPWR sky130_fd_sc_hd__decap_3
XFILLER_61_722 VGND VGND VPWR VPWR sky130_fd_sc_hd__decap_3
XTAP_TAPCELL_ROW_16_611 VGND VPWR sky130_fd_sc_hd__tapvpwrvgnd_1
XFILLER_18_498 VGND VGND VPWR VPWR sky130_fd_sc_hd__decap_3
XFILLER_2_1291 VGND VGND VPWR VPWR sky130_fd_sc_hd__decap_3
XTAP_TAPCELL_ROW_16_622 VGND VPWR sky130_fd_sc_hd__tapvpwrvgnd_1
XFILLER_45_295 VGND VGND VPWR VPWR sky130_fd_sc_hd__decap_3
XFILLER_33_446 VGND VGND VPWR VPWR sky130_fd_sc_hd__fill_2
XFILLER_34_969 VGND VGND VPWR VPWR sky130_fd_sc_hd__decap_3
XFILLER_18_1211 VGND VGND VPWR VPWR sky130_fd_sc_hd__decap_3
XFILLER_57_1260 VGND VGND VPWR VPWR sky130_fd_sc_hd__decap_3
XFILLER_61_788 VGND VGND VPWR VPWR sky130_fd_sc_hd__fill_1
XFILLER_14_660 VGND VGND VPWR VPWR sky130_fd_sc_hd__decap_3
XFILLER_18_1244 VGND VGND VPWR VPWR sky130_fd_sc_hd__decap_3
XFILLER_20_118 VGND VGND VPWR VPWR sky130_fd_sc_hd__decap_3
X_3720_ _3960_/A _6296_/Q VGND VGND VPWR VPWR _3720_/X sky130_fd_sc_hd__and2b_2
XFILLER_60_298 VGND VGND VPWR VPWR sky130_fd_sc_hd__decap_3
Xclkbuf_leaf_40_clk clkload6/A VGND VGND VPWR VPWR _7063_/CLK sky130_fd_sc_hd__clkbuf_8
XFILLER_13_181 VGND VGND VPWR VPWR sky130_fd_sc_hd__decap_3
XFILLER_9_130 VGND VGND VPWR VPWR sky130_fd_sc_hd__fill_1
XFILLER_18_1288 VGND VGND VPWR VPWR sky130_fd_sc_hd__decap_3
XFILLER_9_163 VGND VGND VPWR VPWR sky130_fd_sc_hd__decap_3
X_3651_ _3663_/A _3652_/C _3652_/D VGND VGND VPWR VPWR _3660_/A sky130_fd_sc_hd__nand3b_2
XFILLER_31_1422 VGND VGND VPWR VPWR sky130_fd_sc_hd__decap_3
XFILLER_31_1455 VGND VGND VPWR VPWR sky130_fd_sc_hd__fill_1
X_6370_ _6772_/CLK _6370_/D load_slew831/X VGND VGND VPWR VPWR _6370_/Q sky130_fd_sc_hd__dfrtp_2
XFILLER_31_1466 VGND VGND VPWR VPWR sky130_fd_sc_hd__decap_3
XFILLER_61_3 VGND VGND VPWR VPWR sky130_fd_sc_hd__decap_3
X_3582_ _3583_/B _3583_/C _3583_/A VGND VGND VPWR VPWR _3607_/B sky130_fd_sc_hd__a21o_2
X_5321_ _6453_/Q _5320_/X _5321_/S VGND VGND VPWR VPWR _6453_/D sky130_fd_sc_hd__mux2_1
X_5252_ _5314_/S _5252_/B VGND VGND VPWR VPWR _5252_/Y sky130_fd_sc_hd__nand2_2
XFILLER_9_1401 VGND VGND VPWR VPWR sky130_fd_sc_hd__decap_3
XFILLER_29_1340 VGND VGND VPWR VPWR sky130_fd_sc_hd__decap_3
XFILLER_64_1220 VGND VGND VPWR VPWR sky130_fd_sc_hd__decap_3
XFILLER_29_1351 VGND VGND VPWR VPWR sky130_fd_sc_hd__decap_3
XFILLER_9_1434 VGND VGND VPWR VPWR sky130_fd_sc_hd__decap_3
X_4203_ _4203_/A _4203_/B VGND VGND VPWR VPWR _4617_/B sky130_fd_sc_hd__xnor2_2
XFILLER_64_1253 VGND VGND VPWR VPWR sky130_fd_sc_hd__decap_3
XFILLER_29_1384 VGND VGND VPWR VPWR sky130_fd_sc_hd__decap_3
XFILLER_64_1264 VGND VGND VPWR VPWR sky130_fd_sc_hd__decap_3
X_5183_ _5182_/Y _5074_/X _5281_/A2 _6400_/Q VGND VGND VPWR VPWR _6400_/D sky130_fd_sc_hd__a2bb2o_2
XFILLER_25_1226 VGND VGND VPWR VPWR sky130_fd_sc_hd__decap_3
XFILLER_69_855 VGND VGND VPWR VPWR sky130_fd_sc_hd__decap_3
XFILLER_3_60 VGND VGND VPWR VPWR sky130_fd_sc_hd__decap_3
XFILLER_25_1248 VGND VGND VPWR VPWR sky130_fd_sc_hd__decap_3
X_4134_ _6474_/Q _4319_/A2 _4558_/A _4133_/Y VGND VGND VPWR VPWR _4134_/X sky130_fd_sc_hd__o211a_2
XFILLER_64_1297 VGND VGND VPWR VPWR sky130_fd_sc_hd__decap_3
XFILLER_29_719 VGND VGND VPWR VPWR sky130_fd_sc_hd__fill_1
XFILLER_68_365 VGND VGND VPWR VPWR sky130_fd_sc_hd__decap_3
XFILLER_3_93 VGND VGND VPWR VPWR sky130_fd_sc_hd__decap_3
XFILLER_68_387 VGND VGND VPWR VPWR sky130_fd_sc_hd__decap_3
XFILLER_7_1180 VGND VGND VPWR VPWR sky130_fd_sc_hd__decap_3
X_4065_ _4732_/A _4065_/B VGND VGND VPWR VPWR _4065_/Y sky130_fd_sc_hd__nor2_2
XFILLER_3_1033 VGND VGND VPWR VPWR sky130_fd_sc_hd__decap_3
XTAP_TAPCELL_ROW_27_909 VGND VPWR sky130_fd_sc_hd__tapvpwrvgnd_1
XFILLER_3_1077 VGND VGND VPWR VPWR sky130_fd_sc_hd__decap_3
XFILLER_36_262 VGND VGND VPWR VPWR sky130_fd_sc_hd__decap_3
XFILLER_58_1035 VGND VGND VPWR VPWR sky130_fd_sc_hd__fill_1
XFILLER_24_424 VGND VGND VPWR VPWR sky130_fd_sc_hd__fill_1
Xwire77 wire77/A VGND VGND VPWR VPWR wire77/X sky130_fd_sc_hd__clkbuf_4
XFILLER_52_744 VGND VGND VPWR VPWR sky130_fd_sc_hd__decap_3
XFILLER_36_295 VGND VGND VPWR VPWR sky130_fd_sc_hd__decap_3
Xwire88 wire88/A VGND VGND VPWR VPWR wire88/X sky130_fd_sc_hd__buf_6
XFILLER_36_1300 VGND VGND VPWR VPWR sky130_fd_sc_hd__decap_3
XFILLER_75_1360 VGND VGND VPWR VPWR sky130_fd_sc_hd__decap_3
X_4967_ _6385_/Q _5225_/B VGND VGND VPWR VPWR _4967_/X sky130_fd_sc_hd__or2_2
XFILLER_51_265 VGND VGND VPWR VPWR sky130_fd_sc_hd__decap_3
XFILLER_71_1213 VGND VGND VPWR VPWR sky130_fd_sc_hd__decap_3
XFILLER_75_1393 VGND VGND VPWR VPWR sky130_fd_sc_hd__decap_3
XFILLER_36_1344 VGND VGND VPWR VPWR sky130_fd_sc_hd__decap_3
XFILLER_51_298 VGND VGND VPWR VPWR sky130_fd_sc_hd__decap_3
X_3918_ _6278_/Q _3960_/B _3921_/B1 _6254_/Q _3921_/C1 VGND VGND VPWR VPWR _3918_/X
+ sky130_fd_sc_hd__a221o_2
X_6706_ _7077_/CLK _6706_/D load_slew679/X VGND VGND VPWR VPWR _6706_/Q sky130_fd_sc_hd__dfrtp_2
XFILLER_71_1257 VGND VGND VPWR VPWR sky130_fd_sc_hd__decap_3
XFILLER_32_1208 VGND VGND VPWR VPWR sky130_fd_sc_hd__fill_1
Xclkbuf_leaf_31_clk clkbuf_4_6__f_clk/X VGND VGND VPWR VPWR _7090_/CLK sky130_fd_sc_hd__clkbuf_8
X_4898_ _6929_/Q _4898_/A2 _4896_/X _4897_/X VGND VGND VPWR VPWR _4898_/X sky130_fd_sc_hd__a211o_2
XFILLER_36_1388 VGND VGND VPWR VPWR sky130_fd_sc_hd__decap_3
X_6637_ _7016_/CLK _6637_/D load_slew662/X VGND VGND VPWR VPWR _6637_/Q sky130_fd_sc_hd__dfrtp_2
X_3849_ _4143_/A _3849_/B VGND VGND VPWR VPWR _4077_/B sky130_fd_sc_hd__xnor2_2
X_6568_ _7040_/CLK _6568_/D load_slew718/X VGND VGND VPWR VPWR _6568_/Q sky130_fd_sc_hd__dfrtp_2
X_5519_ _3078_/A _5519_/A2 _5518_/X _5534_/B1 _6610_/Q VGND VGND VPWR VPWR _6610_/D
+ sky130_fd_sc_hd__a32o_2
XFILLER_69_1153 VGND VGND VPWR VPWR sky130_fd_sc_hd__decap_3
X_6499_ _7000_/CLK _6499_/D fanout721/X VGND VGND VPWR VPWR _6499_/Q sky130_fd_sc_hd__dfrtp_2
XFILLER_69_1186 VGND VGND VPWR VPWR sky130_fd_sc_hd__decap_3
XFILLER_47_1440 VGND VGND VPWR VPWR sky130_fd_sc_hd__decap_3
XFILLER_43_1304 VGND VGND VPWR VPWR sky130_fd_sc_hd__decap_3
Xfanout120 fanout121/X VGND VGND VPWR VPWR _5215_/A2 sky130_fd_sc_hd__clkdlybuf4s25_1
XTAP_TAPCELL_ROW_50_1505 VGND VPWR sky130_fd_sc_hd__tapvpwrvgnd_1
XFILLER_43_1337 VGND VGND VPWR VPWR sky130_fd_sc_hd__decap_3
Xfanout153 _3717_/Y VGND VGND VPWR VPWR wire154/A sky130_fd_sc_hd__clkdlybuf4s25_1
XFILLER_59_354 VGND VGND VPWR VPWR sky130_fd_sc_hd__decap_3
XFILLER_43_1348 VGND VGND VPWR VPWR sky130_fd_sc_hd__decap_3
XFILLER_47_505 VGND VGND VPWR VPWR sky130_fd_sc_hd__fill_2
XFILLER_74_302 VGND VGND VPWR VPWR sky130_fd_sc_hd__decap_3
Xfanout197 _3461_/S VGND VGND VPWR VPWR _3453_/S sky130_fd_sc_hd__clkdlybuf4s25_1
XFILLER_75_847 VGND VGND VPWR VPWR sky130_fd_sc_hd__decap_3
XFILLER_47_538 VGND VGND VPWR VPWR sky130_fd_sc_hd__decap_3
XFILLER_41_1050 VGND VGND VPWR VPWR sky130_fd_sc_hd__fill_1
XFILLER_47_66 VGND VGND VPWR VPWR sky130_fd_sc_hd__fill_2
XFILLER_76_1102 VGND VGND VPWR VPWR sky130_fd_sc_hd__decap_3
XFILLER_15_402 VGND VGND VPWR VPWR sky130_fd_sc_hd__decap_3
XFILLER_16_925 VGND VGND VPWR VPWR sky130_fd_sc_hd__decap_3
XFILLER_43_722 VGND VGND VPWR VPWR sky130_fd_sc_hd__decap_3
XFILLER_76_1135 VGND VGND VPWR VPWR sky130_fd_sc_hd__decap_3
XFILLER_16_958 VGND VGND VPWR VPWR sky130_fd_sc_hd__decap_3
XTAP_TAPCELL_ROW_48_1445 VGND VPWR sky130_fd_sc_hd__tapvpwrvgnd_1
XTAP_TAPCELL_ROW_48_1456 VGND VPWR sky130_fd_sc_hd__tapvpwrvgnd_1
XFILLER_15_457 VGND VGND VPWR VPWR sky130_fd_sc_hd__decap_3
XFILLER_37_1119 VGND VGND VPWR VPWR sky130_fd_sc_hd__fill_1
XFILLER_76_1179 VGND VGND VPWR VPWR sky130_fd_sc_hd__decap_3
XFILLER_42_243 VGND VGND VPWR VPWR sky130_fd_sc_hd__decap_3
XFILLER_54_1400 VGND VGND VPWR VPWR sky130_fd_sc_hd__decap_3
XFILLER_54_1444 VGND VGND VPWR VPWR sky130_fd_sc_hd__decap_3
XFILLER_8_27 VGND VGND VPWR VPWR sky130_fd_sc_hd__fill_1
Xclkbuf_leaf_22_clk clkload2/A VGND VGND VPWR VPWR _7092_/CLK sky130_fd_sc_hd__clkbuf_8
XFILLER_8_38 VGND VGND VPWR VPWR sky130_fd_sc_hd__decap_3
XFILLER_15_1428 VGND VGND VPWR VPWR sky130_fd_sc_hd__decap_3
XFILLER_11_652 VGND VGND VPWR VPWR sky130_fd_sc_hd__fill_2
XFILLER_7_612 VGND VGND VPWR VPWR sky130_fd_sc_hd__decap_3
Xwire521 _4963_/S VGND VGND VPWR VPWR _5332_/S sky130_fd_sc_hd__clkbuf_4
XFILLER_13_1130 VGND VGND VPWR VPWR sky130_fd_sc_hd__decap_3
XFILLER_10_184 VGND VGND VPWR VPWR sky130_fd_sc_hd__decap_3
XFILLER_7_667 VGND VGND VPWR VPWR sky130_fd_sc_hd__decap_3
XFILLER_6_144 VGND VGND VPWR VPWR sky130_fd_sc_hd__fill_1
XFILLER_48_1248 VGND VGND VPWR VPWR sky130_fd_sc_hd__decap_3
XFILLER_3_862 VGND VGND VPWR VPWR sky130_fd_sc_hd__decap_3
XFILLER_3_895 VGND VGND VPWR VPWR sky130_fd_sc_hd__fill_1
XFILLER_61_1404 VGND VGND VPWR VPWR sky130_fd_sc_hd__decap_3
XFILLER_2_383 VGND VGND VPWR VPWR sky130_fd_sc_hd__decap_3
XFILLER_78_641 VGND VGND VPWR VPWR sky130_fd_sc_hd__decap_3
Xload_slew548 _5336_/S VGND VGND VPWR VPWR _5261_/A sky130_fd_sc_hd__clkbuf_4
XFILLER_26_6 VGND VGND VPWR VPWR sky130_fd_sc_hd__decap_3
XFILLER_61_1437 VGND VGND VPWR VPWR sky130_fd_sc_hd__decap_3
XFILLER_4_1320 VGND VGND VPWR VPWR sky130_fd_sc_hd__decap_3
XFILLER_24_1270 VGND VGND VPWR VPWR sky130_fd_sc_hd__decap_3
XFILLER_4_1353 VGND VGND VPWR VPWR sky130_fd_sc_hd__decap_3
XFILLER_0_1217 VGND VGND VPWR VPWR sky130_fd_sc_hd__decap_3
XFILLER_59_1322 VGND VGND VPWR VPWR sky130_fd_sc_hd__decap_3
XFILLER_4_1397 VGND VGND VPWR VPWR sky130_fd_sc_hd__decap_3
XFILLER_0_1239 VGND VGND VPWR VPWR sky130_fd_sc_hd__decap_3
XFILLER_18_273 VGND VGND VPWR VPWR sky130_fd_sc_hd__decap_3
XFILLER_20_1178 VGND VGND VPWR VPWR sky130_fd_sc_hd__decap_3
XFILLER_33_210 VGND VGND VPWR VPWR sky130_fd_sc_hd__decap_3
X_5870_ _5868_/A _5868_/C _5781_/S VGND VGND VPWR VPWR _5915_/C sky130_fd_sc_hd__a21o_2
XFILLER_59_1366 VGND VGND VPWR VPWR sky130_fd_sc_hd__decap_3
X_4821_ _4586_/B _6581_/Q _4835_/S VGND VGND VPWR VPWR _4821_/X sky130_fd_sc_hd__mux2_1
XFILLER_59_1399 VGND VGND VPWR VPWR sky130_fd_sc_hd__fill_1
XFILLER_22_928 VGND VGND VPWR VPWR sky130_fd_sc_hd__decap_3
XFILLER_34_799 VGND VGND VPWR VPWR sky130_fd_sc_hd__decap_3
XFILLER_57_1090 VGND VGND VPWR VPWR sky130_fd_sc_hd__decap_3
XFILLER_21_449 VGND VGND VPWR VPWR sky130_fd_sc_hd__decap_3
X_4752_ _6323_/Q _4775_/A2 _4749_/X _4751_/X VGND VGND VPWR VPWR _6323_/D sky130_fd_sc_hd__o22a_2
Xclkbuf_leaf_13_clk clkbuf_4_4__f_clk/X VGND VGND VPWR VPWR _7072_/CLK sky130_fd_sc_hd__clkbuf_8
XFILLER_30_950 VGND VGND VPWR VPWR sky130_fd_sc_hd__decap_3
X_3703_ _3648_/X wire26/X _3687_/B VGND VGND VPWR VPWR _3705_/B sky130_fd_sc_hd__a21o_2
X_4683_ _4683_/A _4683_/B _4683_/C VGND VGND VPWR VPWR _4683_/X sky130_fd_sc_hd__and3_2
X_6422_ _7048_/CLK _6422_/D wire655/X VGND VGND VPWR VPWR _6422_/Q sky130_fd_sc_hd__dfrtp_2
X_3634_ _3635_/A _3671_/A VGND VGND VPWR VPWR _3634_/X sky130_fd_sc_hd__or2_2
XFILLER_31_1263 VGND VGND VPWR VPWR sky130_fd_sc_hd__decap_3
X_6353_ _7019_/CLK _6353_/D fanout836/X VGND VGND VPWR VPWR _6353_/Q sky130_fd_sc_hd__dfrtp_2
X_3565_ _6298_/Q _6306_/Q _6314_/Q _6234_/Q _3496_/B _3566_/A VGND VGND VPWR VPWR
+ _3565_/X sky130_fd_sc_hd__mux4_2
XFILLER_66_1315 VGND VGND VPWR VPWR sky130_fd_sc_hd__fill_1
XTAP_TAPCELL_ROW_8_409 VGND VPWR sky130_fd_sc_hd__tapvpwrvgnd_1
XFILLER_66_1326 VGND VGND VPWR VPWR sky130_fd_sc_hd__decap_3
X_5304_ _6783_/Q _4938_/B _5304_/S VGND VGND VPWR VPWR _5304_/X sky130_fd_sc_hd__mux2_1
X_6284_ _6918_/CLK _6284_/D fanout745/X VGND VGND VPWR VPWR _6284_/Q sky130_fd_sc_hd__dfrtp_2
XFILLER_0_309 VGND VGND VPWR VPWR sky130_fd_sc_hd__decap_3
X_3496_ _3566_/A _3496_/B VGND VGND VPWR VPWR _3496_/X sky130_fd_sc_hd__and2b_2
XFILLER_66_1359 VGND VGND VPWR VPWR sky130_fd_sc_hd__decap_3
X_5235_ _6758_/Q _5318_/S _5335_/S _5234_/Y VGND VGND VPWR VPWR _5235_/X sky130_fd_sc_hd__o211a_2
XFILLER_9_1231 VGND VGND VPWR VPWR sky130_fd_sc_hd__fill_1
XFILLER_25_1001 VGND VGND VPWR VPWR sky130_fd_sc_hd__decap_3
XFILLER_9_1242 VGND VGND VPWR VPWR sky130_fd_sc_hd__decap_3
XFILLER_25_1012 VGND VGND VPWR VPWR sky130_fd_sc_hd__decap_3
XFILLER_9_1275 VGND VGND VPWR VPWR sky130_fd_sc_hd__decap_3
X_5166_ _6730_/Q _5326_/S VGND VGND VPWR VPWR _5166_/X sky130_fd_sc_hd__or2_2
XFILLER_57_814 VGND VGND VPWR VPWR sky130_fd_sc_hd__decap_3
XFILLER_69_685 VGND VGND VPWR VPWR sky130_fd_sc_hd__fill_1
XFILLER_5_1139 VGND VGND VPWR VPWR sky130_fd_sc_hd__decap_3
X_4117_ _6248_/Q wire54/X _4114_/X _4116_/X VGND VGND VPWR VPWR _6248_/D sky130_fd_sc_hd__o22a_2
XFILLER_68_195 VGND VGND VPWR VPWR sky130_fd_sc_hd__fill_1
X_5097_ _6403_/Q _5279_/B VGND VGND VPWR VPWR _5099_/B sky130_fd_sc_hd__xor2_2
XFILLER_72_806 VGND VGND VPWR VPWR sky130_fd_sc_hd__decap_3
X_4048_ _6566_/Q _4572_/B _4049_/A1 VGND VGND VPWR VPWR _4048_/X sky130_fd_sc_hd__a21bo_2
XFILLER_77_1422 VGND VGND VPWR VPWR sky130_fd_sc_hd__decap_3
XFILLER_72_839 VGND VGND VPWR VPWR sky130_fd_sc_hd__decap_3
XFILLER_37_571 VGND VGND VPWR VPWR sky130_fd_sc_hd__decap_3
XFILLER_65_891 VGND VGND VPWR VPWR sky130_fd_sc_hd__decap_3
XFILLER_77_1455 VGND VGND VPWR VPWR sky130_fd_sc_hd__fill_1
XFILLER_38_1406 VGND VGND VPWR VPWR sky130_fd_sc_hd__decap_3
XFILLER_77_1466 VGND VGND VPWR VPWR sky130_fd_sc_hd__decap_3
XFILLER_64_390 VGND VGND VPWR VPWR sky130_fd_sc_hd__fill_1
XFILLER_80_850 VGND VGND VPWR VPWR sky130_fd_sc_hd__fill_1
XFILLER_73_1319 VGND VGND VPWR VPWR sky130_fd_sc_hd__decap_3
XFILLER_24_243 VGND VGND VPWR VPWR sky130_fd_sc_hd__fill_1
XFILLER_25_788 VGND VGND VPWR VPWR sky130_fd_sc_hd__decap_3
XFILLER_40_714 VGND VGND VPWR VPWR sky130_fd_sc_hd__decap_3
XFILLER_80_883 VGND VGND VPWR VPWR sky130_fd_sc_hd__fill_1
X_5999_ hold960/X _5999_/A1 _6031_/S VGND VGND VPWR VPWR _7003_/D sky130_fd_sc_hd__mux2_1
XFILLER_12_427 VGND VGND VPWR VPWR sky130_fd_sc_hd__decap_3
XFILLER_40_736 VGND VGND VPWR VPWR sky130_fd_sc_hd__decap_3
XTAP_TAPCELL_ROW_43_1320 VGND VPWR sky130_fd_sc_hd__tapvpwrvgnd_1
XFILLER_33_46 VGND VGND VPWR VPWR sky130_fd_sc_hd__fill_2
XTAP_TAPCELL_ROW_43_1331 VGND VPWR sky130_fd_sc_hd__tapvpwrvgnd_1
XFILLER_33_57 VGND VGND VPWR VPWR sky130_fd_sc_hd__decap_3
XFILLER_40_769 VGND VGND VPWR VPWR sky130_fd_sc_hd__decap_3
XFILLER_71_1065 VGND VGND VPWR VPWR sky130_fd_sc_hd__decap_3
XFILLER_14_1450 VGND VGND VPWR VPWR sky130_fd_sc_hd__decap_3
XFILLER_20_493 VGND VGND VPWR VPWR sky130_fd_sc_hd__decap_3
XFILLER_10_1303 VGND VGND VPWR VPWR sky130_fd_sc_hd__decap_3
XFILLER_4_604 VGND VGND VPWR VPWR sky130_fd_sc_hd__decap_3
XFILLER_10_1347 VGND VGND VPWR VPWR sky130_fd_sc_hd__decap_3
XFILLER_3_125 VGND VGND VPWR VPWR sky130_fd_sc_hd__decap_3
XFILLER_3_169 VGND VGND VPWR VPWR sky130_fd_sc_hd__decap_3
XTAP_TAPCELL_ROW_37_1157 VGND VPWR sky130_fd_sc_hd__tapvpwrvgnd_1
XTAP_TAPCELL_ROW_37_1168 VGND VPWR sky130_fd_sc_hd__tapvpwrvgnd_1
XFILLER_79_449 VGND VGND VPWR VPWR sky130_fd_sc_hd__decap_3
XFILLER_47_1281 VGND VGND VPWR VPWR sky130_fd_sc_hd__decap_3
XFILLER_0_865 VGND VGND VPWR VPWR sky130_fd_sc_hd__decap_3
XFILLER_47_1292 VGND VGND VPWR VPWR sky130_fd_sc_hd__decap_3
XFILLER_48_803 VGND VGND VPWR VPWR sky130_fd_sc_hd__decap_3
XFILLER_0_887 VGND VGND VPWR VPWR sky130_fd_sc_hd__decap_3
XFILLER_75_644 VGND VGND VPWR VPWR sky130_fd_sc_hd__fill_1
XFILLER_21_1410 VGND VGND VPWR VPWR sky130_fd_sc_hd__decap_3
XFILLER_48_869 VGND VGND VPWR VPWR sky130_fd_sc_hd__decap_3
XFILLER_78_1208 VGND VGND VPWR VPWR sky130_fd_sc_hd__decap_3
XFILLER_47_357 VGND VGND VPWR VPWR sky130_fd_sc_hd__fill_1
XFILLER_21_1443 VGND VGND VPWR VPWR sky130_fd_sc_hd__decap_3
XFILLER_35_508 VGND VGND VPWR VPWR sky130_fd_sc_hd__decap_3
XFILLER_75_688 VGND VGND VPWR VPWR sky130_fd_sc_hd__decap_3
XFILLER_62_305 VGND VGND VPWR VPWR sky130_fd_sc_hd__decap_3
XFILLER_74_53 VGND VGND VPWR VPWR sky130_fd_sc_hd__decap_3
XFILLER_16_733 VGND VGND VPWR VPWR sky130_fd_sc_hd__decap_3
XFILLER_15_210 VGND VGND VPWR VPWR sky130_fd_sc_hd__decap_3
XFILLER_71_861 VGND VGND VPWR VPWR sky130_fd_sc_hd__decap_3
XFILLER_16_766 VGND VGND VPWR VPWR sky130_fd_sc_hd__decap_3
XFILLER_15_276 VGND VGND VPWR VPWR sky130_fd_sc_hd__decap_3
XFILLER_70_382 VGND VGND VPWR VPWR sky130_fd_sc_hd__decap_3
XFILLER_54_1241 VGND VGND VPWR VPWR sky130_fd_sc_hd__decap_3
XFILLER_31_758 VGND VGND VPWR VPWR sky130_fd_sc_hd__decap_3
XFILLER_19_1372 VGND VGND VPWR VPWR sky130_fd_sc_hd__decap_3
XFILLER_12_961 VGND VGND VPWR VPWR sky130_fd_sc_hd__decap_3
XFILLER_8_910 VGND VGND VPWR VPWR sky130_fd_sc_hd__decap_3
XFILLER_15_1225 VGND VGND VPWR VPWR sky130_fd_sc_hd__decap_3
XFILLER_15_1236 VGND VGND VPWR VPWR sky130_fd_sc_hd__decap_3
XFILLER_50_1116 VGND VGND VPWR VPWR sky130_fd_sc_hd__decap_3
XFILLER_54_1285 VGND VGND VPWR VPWR sky130_fd_sc_hd__decap_3
XFILLER_11_471 VGND VGND VPWR VPWR sky130_fd_sc_hd__decap_3
XFILLER_7_420 VGND VGND VPWR VPWR sky130_fd_sc_hd__decap_3
XFILLER_15_1269 VGND VGND VPWR VPWR sky130_fd_sc_hd__decap_3
XFILLER_8_987 VGND VGND VPWR VPWR sky130_fd_sc_hd__fill_1
XFILLER_7_464 VGND VGND VPWR VPWR sky130_fd_sc_hd__decap_3
XFILLER_48_1034 VGND VGND VPWR VPWR sky130_fd_sc_hd__fill_2
X_3350_ _6230_/Q _6406_/Q VGND VGND VPWR VPWR _3350_/X sky130_fd_sc_hd__xor2_2
XFILLER_3_670 VGND VGND VPWR VPWR sky130_fd_sc_hd__fill_2
X_3281_ hold975/X _3280_/X _7087_/D VGND VGND VPWR VPWR _6114_/D sky130_fd_sc_hd__mux2_1
XFILLER_2_180 VGND VGND VPWR VPWR sky130_fd_sc_hd__decap_3
XFILLER_26_1332 VGND VGND VPWR VPWR sky130_fd_sc_hd__decap_3
XFILLER_65_1381 VGND VGND VPWR VPWR sky130_fd_sc_hd__decap_3
X_5020_ _6360_/Q _5019_/X _5020_/S VGND VGND VPWR VPWR _6360_/D sky130_fd_sc_hd__mux2_1
XFILLER_6_1415 VGND VGND VPWR VPWR sky130_fd_sc_hd__decap_3
XFILLER_78_460 VGND VGND VPWR VPWR sky130_fd_sc_hd__decap_3
Xclkbuf_leaf_2_clk clkbuf_leaf_2_clk/A VGND VGND VPWR VPWR clkload9/A sky130_fd_sc_hd__clkbuf_8
XFILLER_24_3 VGND VGND VPWR VPWR sky130_fd_sc_hd__decap_3
XFILLER_39_814 VGND VGND VPWR VPWR sky130_fd_sc_hd__decap_3
XFILLER_66_600 VGND VGND VPWR VPWR sky130_fd_sc_hd__decap_3
Xhold1109 _6872_/Q VGND VGND VPWR VPWR _5857_/A0 sky130_fd_sc_hd__dlygate4sd3_1
XFILLER_26_1365 VGND VGND VPWR VPWR sky130_fd_sc_hd__decap_3
XFILLER_61_1245 VGND VGND VPWR VPWR sky130_fd_sc_hd__decap_3
XFILLER_26_1376 VGND VGND VPWR VPWR sky130_fd_sc_hd__decap_3
XFILLER_66_622 VGND VGND VPWR VPWR sky130_fd_sc_hd__decap_3
XFILLER_22_1218 VGND VGND VPWR VPWR sky130_fd_sc_hd__decap_3
XFILLER_6_1459 VGND VGND VPWR VPWR sky130_fd_sc_hd__decap_3
XFILLER_61_1278 VGND VGND VPWR VPWR sky130_fd_sc_hd__decap_3
XFILLER_61_1289 VGND VGND VPWR VPWR sky130_fd_sc_hd__decap_3
XFILLER_66_655 VGND VGND VPWR VPWR sky130_fd_sc_hd__fill_2
XFILLER_38_357 VGND VGND VPWR VPWR sky130_fd_sc_hd__decap_3
XFILLER_4_1161 VGND VGND VPWR VPWR sky130_fd_sc_hd__decap_3
X_6971_ _7027_/CLK _6971_/D load_slew845/X VGND VGND VPWR VPWR _6971_/Q sky130_fd_sc_hd__dfrtp_2
XFILLER_0_50 VGND VGND VPWR VPWR sky130_fd_sc_hd__decap_3
XFILLER_80_113 VGND VGND VPWR VPWR sky130_fd_sc_hd__decap_3
XFILLER_4_1194 VGND VGND VPWR VPWR sky130_fd_sc_hd__decap_3
XFILLER_59_1130 VGND VGND VPWR VPWR sky130_fd_sc_hd__decap_3
XFILLER_65_198 VGND VGND VPWR VPWR sky130_fd_sc_hd__decap_3
X_5922_ _5922_/A0 _5799_/C _5923_/S VGND VGND VPWR VPWR _6928_/D sky130_fd_sc_hd__mux2_1
XFILLER_0_72 VGND VGND VPWR VPWR sky130_fd_sc_hd__decap_3
XFILLER_0_94 VGND VGND VPWR VPWR sky130_fd_sc_hd__decap_3
XFILLER_0_1058 VGND VGND VPWR VPWR sky130_fd_sc_hd__decap_3
XFILLER_34_563 VGND VGND VPWR VPWR sky130_fd_sc_hd__decap_3
X_5853_ _5853_/A0 _5900_/A0 _5856_/S VGND VGND VPWR VPWR _6868_/D sky130_fd_sc_hd__mux2_1
XFILLER_22_736 VGND VGND VPWR VPWR sky130_fd_sc_hd__decap_3
X_4804_ _6282_/Q _4861_/A2 _3438_/X _4861_/B2 VGND VGND VPWR VPWR _4804_/X sky130_fd_sc_hd__a22o_2
XFILLER_61_393 VGND VGND VPWR VPWR sky130_fd_sc_hd__decap_3
XFILLER_72_1341 VGND VGND VPWR VPWR sky130_fd_sc_hd__decap_3
X_5784_ _5915_/D _5868_/B _5784_/C VGND VGND VPWR VPWR _5784_/X sky130_fd_sc_hd__and3b_2
XFILLER_9_70 VGND VGND VPWR VPWR sky130_fd_sc_hd__decap_3
XFILLER_33_1325 VGND VGND VPWR VPWR sky130_fd_sc_hd__decap_3
XFILLER_72_1385 VGND VGND VPWR VPWR sky130_fd_sc_hd__decap_3
X_4735_ _6249_/Q _4743_/A2 _3420_/X _4735_/B2 VGND VGND VPWR VPWR _4735_/X sky130_fd_sc_hd__a22o_2
XFILLER_33_1369 VGND VGND VPWR VPWR sky130_fd_sc_hd__decap_3
X_4666_ _4783_/B _3717_/A _4266_/Y _4665_/X _6552_/Q VGND VGND VPWR VPWR _4666_/X
+ sky130_fd_sc_hd__a32o_2
XFILLER_31_1060 VGND VGND VPWR VPWR sky130_fd_sc_hd__decap_3
X_6405_ _6772_/CLK _6405_/D load_slew825/X VGND VGND VPWR VPWR _6405_/Q sky130_fd_sc_hd__dfrtp_2
X_3617_ _3617_/A _3617_/B VGND VGND VPWR VPWR _3648_/A sky130_fd_sc_hd__nand2_2
Xhold910 _6628_/Q VGND VGND VPWR VPWR hold910/X sky130_fd_sc_hd__dlygate4sd3_1
XTAP_TAPCELL_ROW_77_2194 VGND VPWR sky130_fd_sc_hd__tapvpwrvgnd_1
Xhold921 _6197_/Q VGND VGND VPWR VPWR hold921/X sky130_fd_sc_hd__dlygate4sd3_1
X_4597_ _4597_/A _4597_/B _4597_/C VGND VGND VPWR VPWR _4597_/X sky130_fd_sc_hd__and3_2
Xhold932 _6195_/Q VGND VGND VPWR VPWR hold932/X sky130_fd_sc_hd__dlygate4sd3_1
Xhold943 _6972_/Q VGND VGND VPWR VPWR hold943/X sky130_fd_sc_hd__dlygate4sd3_1
XFILLER_1_607 VGND VGND VPWR VPWR sky130_fd_sc_hd__decap_3
X_6336_ _7016_/CLK _6336_/D load_slew662/X VGND VGND VPWR VPWR _6336_/Q sky130_fd_sc_hd__dfrtp_2
Xhold954 _6635_/Q VGND VGND VPWR VPWR hold954/X sky130_fd_sc_hd__dlygate4sd3_1
X_3548_ _3541_/X _3543_/X _3545_/X _3547_/X _4532_/B _4886_/A1 VGND VGND VPWR VPWR
+ _3548_/X sky130_fd_sc_hd__mux4_2
XFILLER_66_1134 VGND VGND VPWR VPWR sky130_fd_sc_hd__decap_3
Xhold965 _6097_/Q VGND VGND VPWR VPWR hold965/X sky130_fd_sc_hd__dlygate4sd3_1
XFILLER_0_106 VGND VGND VPWR VPWR sky130_fd_sc_hd__decap_3
XFILLER_1_629 VGND VGND VPWR VPWR sky130_fd_sc_hd__decap_3
Xhold976 _5961_/X VGND VGND VPWR VPWR _6965_/D sky130_fd_sc_hd__dlygate4sd3_1
Xhold987 _6105_/Q VGND VGND VPWR VPWR hold987/X sky130_fd_sc_hd__dlygate4sd3_1
Xhold998 _6009_/X VGND VGND VPWR VPWR _7013_/D sky130_fd_sc_hd__dlygate4sd3_1
XFILLER_0_128 VGND VGND VPWR VPWR sky130_fd_sc_hd__decap_3
X_6267_ clkload9/A _6267_/D fanout656/X VGND VGND VPWR VPWR _6267_/Q sky130_fd_sc_hd__dfrtp_2
XFILLER_27_1129 VGND VGND VPWR VPWR sky130_fd_sc_hd__decap_3
X_3479_ _6060_/A0 _3478_/X _3481_/S VGND VGND VPWR VPWR _6213_/D sky130_fd_sc_hd__mux2_1
XFILLER_77_909 VGND VGND VPWR VPWR sky130_fd_sc_hd__decap_3
XFILLER_66_1189 VGND VGND VPWR VPWR sky130_fd_sc_hd__decap_3
XFILLER_44_1421 VGND VGND VPWR VPWR sky130_fd_sc_hd__decap_3
XFILLER_44_1432 VGND VGND VPWR VPWR sky130_fd_sc_hd__decap_3
X_5218_ _6414_/Q wire105/X _5217_/X VGND VGND VPWR VPWR _6414_/D sky130_fd_sc_hd__a21o_2
XFILLER_76_419 VGND VGND VPWR VPWR sky130_fd_sc_hd__fill_1
XFILLER_9_1061 VGND VGND VPWR VPWR sky130_fd_sc_hd__decap_3
XTAP_TAPCELL_ROW_32_1021 VGND VPWR sky130_fd_sc_hd__tapvpwrvgnd_1
X_6198_ _7057_/CLK _6198_/D fanout708/X VGND VGND VPWR VPWR _6198_/Q sky130_fd_sc_hd__dfrtp_2
XTAP_TAPCELL_ROW_32_1032 VGND VPWR sky130_fd_sc_hd__tapvpwrvgnd_1
XFILLER_44_1465 VGND VGND VPWR VPWR sky130_fd_sc_hd__decap_3
XTAP_TAPCELL_ROW_32_1043 VGND VPWR sky130_fd_sc_hd__tapvpwrvgnd_1
XFILLER_29_335 VGND VGND VPWR VPWR sky130_fd_sc_hd__fill_1
XFILLER_40_1329 VGND VGND VPWR VPWR sky130_fd_sc_hd__decap_3
X_5149_ _6383_/Q _5221_/A2 _4957_/S _5148_/X VGND VGND VPWR VPWR _6383_/D sky130_fd_sc_hd__a22o_2
XFILLER_17_508 VGND VGND VPWR VPWR sky130_fd_sc_hd__decap_3
XFILLER_29_368 VGND VGND VPWR VPWR sky130_fd_sc_hd__decap_3
XFILLER_45_828 VGND VGND VPWR VPWR sky130_fd_sc_hd__decap_3
XFILLER_71_113 VGND VGND VPWR VPWR sky130_fd_sc_hd__decap_3
XFILLER_44_12 VGND VGND VPWR VPWR sky130_fd_sc_hd__decap_3
XFILLER_71_146 VGND VGND VPWR VPWR sky130_fd_sc_hd__decap_3
XFILLER_53_850 VGND VGND VPWR VPWR sky130_fd_sc_hd__fill_1
XFILLER_77_1263 VGND VGND VPWR VPWR sky130_fd_sc_hd__decap_3
XFILLER_44_45 VGND VGND VPWR VPWR sky130_fd_sc_hd__fill_1
XFILLER_53_872 VGND VGND VPWR VPWR sky130_fd_sc_hd__decap_3
XFILLER_38_1236 VGND VGND VPWR VPWR sky130_fd_sc_hd__decap_3
XFILLER_53_883 VGND VGND VPWR VPWR sky130_fd_sc_hd__decap_3
XFILLER_73_1127 VGND VGND VPWR VPWR sky130_fd_sc_hd__decap_3
XFILLER_25_585 VGND VGND VPWR VPWR sky130_fd_sc_hd__fill_1
XFILLER_40_533 VGND VGND VPWR VPWR sky130_fd_sc_hd__fill_1
XFILLER_13_769 VGND VGND VPWR VPWR sky130_fd_sc_hd__decap_3
XFILLER_40_577 VGND VGND VPWR VPWR sky130_fd_sc_hd__decap_3
XFILLER_51_1425 VGND VGND VPWR VPWR sky130_fd_sc_hd__decap_3
XTAP_TAPCELL_ROW_23_786 VGND VPWR sky130_fd_sc_hd__tapvpwrvgnd_1
XFILLER_40_599 VGND VGND VPWR VPWR sky130_fd_sc_hd__decap_3
XFILLER_12_1409 VGND VGND VPWR VPWR sky130_fd_sc_hd__decap_3
XTAP_TAPCELL_ROW_23_797 VGND VPWR sky130_fd_sc_hd__tapvpwrvgnd_1
XFILLER_60_55 VGND VGND VPWR VPWR sky130_fd_sc_hd__decap_3
XTAP_TAPCELL_ROW_10_458 VGND VPWR sky130_fd_sc_hd__tapvpwrvgnd_1
XTAP_TAPCELL_ROW_10_469 VGND VPWR sky130_fd_sc_hd__tapvpwrvgnd_1
XFILLER_14_1291 VGND VGND VPWR VPWR sky130_fd_sc_hd__decap_3
XFILLER_4_412 VGND VGND VPWR VPWR sky130_fd_sc_hd__decap_3
XTAP_TAPCELL_ROW_39_1208 VGND VPWR sky130_fd_sc_hd__tapvpwrvgnd_1
XTAP_TAPCELL_ROW_39_1219 VGND VPWR sky130_fd_sc_hd__tapvpwrvgnd_1
XFILLER_49_1310 VGND VGND VPWR VPWR sky130_fd_sc_hd__decap_3
XFILLER_10_1144 VGND VGND VPWR VPWR sky130_fd_sc_hd__decap_3
XFILLER_5_39 VGND VGND VPWR VPWR sky130_fd_sc_hd__decap_3
XFILLER_10_1155 VGND VGND VPWR VPWR sky130_fd_sc_hd__decap_3
XFILLER_4_467 VGND VGND VPWR VPWR sky130_fd_sc_hd__decap_3
XFILLER_49_1343 VGND VGND VPWR VPWR sky130_fd_sc_hd__fill_1
XFILLER_49_1354 VGND VGND VPWR VPWR sky130_fd_sc_hd__decap_3
XFILLER_69_42 VGND VGND VPWR VPWR sky130_fd_sc_hd__decap_3
XFILLER_79_202 VGND VGND VPWR VPWR sky130_fd_sc_hd__decap_3
XFILLER_10_1188 VGND VGND VPWR VPWR sky130_fd_sc_hd__decap_3
XFILLER_49_1387 VGND VGND VPWR VPWR sky130_fd_sc_hd__decap_3
XFILLER_0_640 VGND VGND VPWR VPWR sky130_fd_sc_hd__decap_3
XFILLER_0_651 VGND VGND VPWR VPWR sky130_fd_sc_hd__decap_3
XFILLER_0_673 VGND VGND VPWR VPWR sky130_fd_sc_hd__decap_3
XFILLER_48_633 VGND VGND VPWR VPWR sky130_fd_sc_hd__decap_3
XFILLER_10_9 VGND VGND VPWR VPWR sky130_fd_sc_hd__decap_3
XFILLER_75_441 VGND VGND VPWR VPWR sky130_fd_sc_hd__fill_1
XFILLER_75_452 VGND VGND VPWR VPWR sky130_fd_sc_hd__decap_3
XFILLER_47_143 VGND VGND VPWR VPWR sky130_fd_sc_hd__decap_3
XFILLER_78_1016 VGND VGND VPWR VPWR sky130_fd_sc_hd__fill_2
XFILLER_1_1301 VGND VGND VPWR VPWR sky130_fd_sc_hd__decap_3
XFILLER_21_1251 VGND VGND VPWR VPWR sky130_fd_sc_hd__decap_3
XFILLER_1_1334 VGND VGND VPWR VPWR sky130_fd_sc_hd__decap_3
XFILLER_1_1345 VGND VGND VPWR VPWR sky130_fd_sc_hd__decap_3
XFILLER_35_349 VGND VGND VPWR VPWR sky130_fd_sc_hd__decap_3
XFILLER_16_530 VGND VGND VPWR VPWR sky130_fd_sc_hd__fill_2
XFILLER_21_1284 VGND VGND VPWR VPWR sky130_fd_sc_hd__decap_3
XFILLER_21_1295 VGND VGND VPWR VPWR sky130_fd_sc_hd__decap_3
XFILLER_56_1303 VGND VGND VPWR VPWR sky130_fd_sc_hd__decap_3
XFILLER_1_1378 VGND VGND VPWR VPWR sky130_fd_sc_hd__decap_3
XFILLER_50_319 VGND VGND VPWR VPWR sky130_fd_sc_hd__decap_3
XFILLER_31_500 VGND VGND VPWR VPWR sky130_fd_sc_hd__decap_3
XFILLER_16_585 VGND VGND VPWR VPWR sky130_fd_sc_hd__decap_3
XFILLER_56_1347 VGND VGND VPWR VPWR sky130_fd_sc_hd__decap_3
XPHY_EDGE_ROW_28_Left_109 VGND VGND VPWR VPWR sky130_fd_sc_hd__decap_3
XFILLER_54_1093 VGND VGND VPWR VPWR sky130_fd_sc_hd__decap_3
X_4520_ _4817_/A1 _4517_/X _4518_/Y _4519_/X _4874_/C1 VGND VGND VPWR VPWR _4520_/X
+ sky130_fd_sc_hd__o221a_2
X_4451_ _6282_/Q _4863_/A2 _4448_/X _4450_/X VGND VGND VPWR VPWR _6282_/D sky130_fd_sc_hd__o22a_2
XFILLER_32_1391 VGND VGND VPWR VPWR sky130_fd_sc_hd__decap_3
XFILLER_67_1410 VGND VGND VPWR VPWR sky130_fd_sc_hd__decap_3
X_3402_ _6232_/Q _6432_/Q VGND VGND VPWR VPWR _3402_/X sky130_fd_sc_hd__xor2_2
XFILLER_67_1443 VGND VGND VPWR VPWR sky130_fd_sc_hd__decap_3
X_4382_ _4378_/Y _4379_/X _4381_/Y _4382_/C1 VGND VGND VPWR VPWR _4382_/X sky130_fd_sc_hd__o211a_2
XFILLER_28_1427 VGND VGND VPWR VPWR sky130_fd_sc_hd__fill_1
X_6121_ _7004_/CLK _6121_/D load_slew840/X VGND VGND VPWR VPWR _6121_/Q sky130_fd_sc_hd__dfrtp_2
XFILLER_63_1307 VGND VGND VPWR VPWR sky130_fd_sc_hd__decap_3
X_3333_ _5987_/A0 _3332_/X _3461_/S VGND VGND VPWR VPWR _6140_/D sky130_fd_sc_hd__mux2_1
XFILLER_28_1438 VGND VGND VPWR VPWR sky130_fd_sc_hd__decap_3
Xfanout708 fanout713/X VGND VGND VPWR VPWR fanout708/X sky130_fd_sc_hd__clkdlybuf4s25_1
Xfanout719 fanout721/X VGND VGND VPWR VPWR fanout719/X sky130_fd_sc_hd__clkdlybuf4s25_1
XTAP_TAPCELL_ROW_72_2080 VGND VPWR sky130_fd_sc_hd__tapvpwrvgnd_1
XPHY_EDGE_ROW_37_Left_118 VGND VGND VPWR VPWR sky130_fd_sc_hd__decap_3
Xload_slew131 _5345_/S VGND VGND VPWR VPWR _5335_/S sky130_fd_sc_hd__buf_4
X_6052_ _6052_/A0 _7056_/Q _6052_/S VGND VGND VPWR VPWR _6052_/X sky130_fd_sc_hd__mux2_1
XPHY_EDGE_ROW_7_Right_7 VGND VGND VPWR VPWR sky130_fd_sc_hd__decap_3
X_3264_ _6267_/Q _6363_/Q VGND VGND VPWR VPWR _3264_/X sky130_fd_sc_hd__xor2_2
XFILLER_26_1140 VGND VGND VPWR VPWR sky130_fd_sc_hd__decap_3
XFILLER_6_1223 VGND VGND VPWR VPWR sky130_fd_sc_hd__decap_3
Xload_slew175 _3377_/S VGND VGND VPWR VPWR _3457_/S sky130_fd_sc_hd__clkbuf_4
X_5003_ _6390_/Q _5240_/B wire434/X VGND VGND VPWR VPWR _5003_/Y sky130_fd_sc_hd__a21oi_2
Xload_slew186 _3415_/S VGND VGND VPWR VPWR _3465_/S sky130_fd_sc_hd__clkbuf_4
XFILLER_61_1053 VGND VGND VPWR VPWR sky130_fd_sc_hd__decap_3
XFILLER_6_1256 VGND VGND VPWR VPWR sky130_fd_sc_hd__decap_3
X_3195_ _3202_/A _3185_/X _3187_/X _3194_/X VGND VGND VPWR VPWR _3195_/X sky130_fd_sc_hd__a31o_2
XFILLER_67_964 VGND VGND VPWR VPWR sky130_fd_sc_hd__fill_2
XFILLER_6_1267 VGND VGND VPWR VPWR sky130_fd_sc_hd__decap_3
XFILLER_22_1037 VGND VGND VPWR VPWR sky130_fd_sc_hd__decap_3
XFILLER_54_614 VGND VGND VPWR VPWR sky130_fd_sc_hd__decap_3
XFILLER_53_102 VGND VGND VPWR VPWR sky130_fd_sc_hd__fill_2
XFILLER_53_113 VGND VGND VPWR VPWR sky130_fd_sc_hd__decap_3
X_6954_ _6954_/CLK _6954_/D load_slew650/X VGND VGND VPWR VPWR _6954_/Q sky130_fd_sc_hd__dfrtp_2
XFILLER_74_1403 VGND VGND VPWR VPWR sky130_fd_sc_hd__decap_3
XFILLER_53_179 VGND VGND VPWR VPWR sky130_fd_sc_hd__decap_3
X_5905_ _5932_/A0 _5905_/A1 _5905_/S VGND VGND VPWR VPWR _6913_/D sky130_fd_sc_hd__mux2_1
XFILLER_74_1447 VGND VGND VPWR VPWR sky130_fd_sc_hd__decap_3
X_6885_ _7016_/CLK _6885_/D load_slew664/X VGND VGND VPWR VPWR _6885_/Q sky130_fd_sc_hd__dfrtp_2
XFILLER_34_371 VGND VGND VPWR VPWR sky130_fd_sc_hd__decap_3
XFILLER_14_15 VGND VGND VPWR VPWR sky130_fd_sc_hd__decap_3
XFILLER_22_533 VGND VGND VPWR VPWR sky130_fd_sc_hd__decap_3
XPHY_EDGE_ROW_46_Left_127 VGND VGND VPWR VPWR sky130_fd_sc_hd__decap_3
X_5836_ _5910_/A0 _5836_/A1 _5839_/S VGND VGND VPWR VPWR _6853_/D sky130_fd_sc_hd__mux2_1
XFILLER_50_864 VGND VGND VPWR VPWR sky130_fd_sc_hd__decap_3
XFILLER_10_717 VGND VGND VPWR VPWR sky130_fd_sc_hd__decap_3
X_5767_ _7110_/A _7092_/Q _7092_/D VGND VGND VPWR VPWR _6085_/C sky130_fd_sc_hd__or3b_2
XTAP_TAPCELL_ROW_20_712 VGND VPWR sky130_fd_sc_hd__tapvpwrvgnd_1
XFILLER_72_1182 VGND VGND VPWR VPWR sky130_fd_sc_hd__decap_3
XTAP_TAPCELL_ROW_20_723 VGND VPWR sky130_fd_sc_hd__tapvpwrvgnd_1
XFILLER_33_1133 VGND VGND VPWR VPWR sky130_fd_sc_hd__decap_3
XTAP_TAPCELL_ROW_79_2245 VGND VPWR sky130_fd_sc_hd__tapvpwrvgnd_1
XTAP_TAPCELL_ROW_79_2256 VGND VPWR sky130_fd_sc_hd__tapvpwrvgnd_1
XTAP_TAPCELL_ROW_79_2267 VGND VPWR sky130_fd_sc_hd__tapvpwrvgnd_1
X_4718_ _6559_/Q _4602_/B _4896_/A1 VGND VGND VPWR VPWR _4718_/X sky130_fd_sc_hd__a21bo_2
XFILLER_33_1177 VGND VGND VPWR VPWR sky130_fd_sc_hd__fill_1
X_5698_ _5698_/A0 _5928_/A0 _5701_/S VGND VGND VPWR VPWR _6749_/D sky130_fd_sc_hd__mux2_1
XFILLER_11_1431 VGND VGND VPWR VPWR sky130_fd_sc_hd__decap_3
X_4649_ _6887_/Q _4883_/A2 _4855_/B1 _4648_/X VGND VGND VPWR VPWR _4649_/X sky130_fd_sc_hd__a211o_2
XFILLER_68_1229 VGND VGND VPWR VPWR sky130_fd_sc_hd__decap_3
XFILLER_2_905 VGND VGND VPWR VPWR sky130_fd_sc_hd__decap_3
XFILLER_2_949 VGND VGND VPWR VPWR sky130_fd_sc_hd__decap_3
XPHY_EDGE_ROW_55_Left_136 VGND VGND VPWR VPWR sky130_fd_sc_hd__decap_3
XFILLER_1_437 VGND VGND VPWR VPWR sky130_fd_sc_hd__decap_3
X_6319_ _6929_/CLK _6319_/D fanout706/X VGND VGND VPWR VPWR _6319_/Q sky130_fd_sc_hd__dfrtp_2
XFILLER_39_12 VGND VGND VPWR VPWR sky130_fd_sc_hd__fill_1
XFILLER_7_1009 VGND VGND VPWR VPWR sky130_fd_sc_hd__decap_3
XFILLER_49_419 VGND VGND VPWR VPWR sky130_fd_sc_hd__decap_3
XFILLER_44_1240 VGND VGND VPWR VPWR sky130_fd_sc_hd__decap_3
XFILLER_44_1273 VGND VGND VPWR VPWR sky130_fd_sc_hd__decap_3
XFILLER_18_806 VGND VGND VPWR VPWR sky130_fd_sc_hd__decap_3
Xhold1440 _6642_/Q VGND VGND VPWR VPWR _5559_/B1 sky130_fd_sc_hd__dlygate4sd3_1
Xhold1451 _6517_/Q VGND VGND VPWR VPWR _5405_/A1 sky130_fd_sc_hd__dlygate4sd3_1
XFILLER_79_1325 VGND VGND VPWR VPWR sky130_fd_sc_hd__decap_3
Xhold1462 _6566_/Q VGND VGND VPWR VPWR _5454_/A1 sky130_fd_sc_hd__dlygate4sd3_1
XFILLER_45_614 VGND VGND VPWR VPWR sky130_fd_sc_hd__fill_2
XFILLER_58_997 VGND VGND VPWR VPWR sky130_fd_sc_hd__fill_1
XTAP_TAPCELL_ROW_4_297 VGND VPWR sky130_fd_sc_hd__tapvpwrvgnd_1
XFILLER_17_316 VGND VGND VPWR VPWR sky130_fd_sc_hd__decap_3
XFILLER_18_839 VGND VGND VPWR VPWR sky130_fd_sc_hd__fill_1
Xhold1473 _6552_/Q VGND VGND VPWR VPWR _5440_/A1 sky130_fd_sc_hd__dlygate4sd3_1
Xhold1484 _6510_/Q VGND VGND VPWR VPWR _5398_/A1 sky130_fd_sc_hd__dlygate4sd3_1
Xhold1495 _6744_/Q VGND VGND VPWR VPWR _5692_/A0 sky130_fd_sc_hd__dlygate4sd3_1
XFILLER_72_433 VGND VGND VPWR VPWR sky130_fd_sc_hd__decap_3
XFILLER_79_1369 VGND VGND VPWR VPWR sky130_fd_sc_hd__decap_3
XFILLER_45_669 VGND VGND VPWR VPWR sky130_fd_sc_hd__decap_3
XTAP_TAPCELL_ROW_68_1960 VGND VPWR sky130_fd_sc_hd__tapvpwrvgnd_1
XTAP_TAPCELL_ROW_68_1971 VGND VPWR sky130_fd_sc_hd__tapvpwrvgnd_1
XFILLER_72_477 VGND VGND VPWR VPWR sky130_fd_sc_hd__decap_3
XPHY_EDGE_ROW_64_Left_145 VGND VGND VPWR VPWR sky130_fd_sc_hd__decap_3
XFILLER_26_883 VGND VGND VPWR VPWR sky130_fd_sc_hd__decap_3
XFILLER_77_1071 VGND VGND VPWR VPWR sky130_fd_sc_hd__decap_3
XFILLER_60_639 VGND VGND VPWR VPWR sky130_fd_sc_hd__decap_3
XFILLER_13_511 VGND VGND VPWR VPWR sky130_fd_sc_hd__decap_3
XFILLER_25_382 VGND VGND VPWR VPWR sky130_fd_sc_hd__decap_3
XTAP_TAPCELL_ROW_64_1857 VGND VPWR sky130_fd_sc_hd__tapvpwrvgnd_1
XFILLER_71_21 VGND VGND VPWR VPWR sky130_fd_sc_hd__decap_3
XFILLER_25_393 VGND VGND VPWR VPWR sky130_fd_sc_hd__decap_3
XFILLER_38_1055 VGND VGND VPWR VPWR sky130_fd_sc_hd__fill_2
XTAP_TAPCELL_ROW_64_1868 VGND VPWR sky130_fd_sc_hd__tapvpwrvgnd_1
XFILLER_52_190 VGND VGND VPWR VPWR sky130_fd_sc_hd__decap_3
XFILLER_41_864 VGND VGND VPWR VPWR sky130_fd_sc_hd__decap_3
XFILLER_71_54 VGND VGND VPWR VPWR sky130_fd_sc_hd__fill_2
XFILLER_9_526 VGND VGND VPWR VPWR sky130_fd_sc_hd__decap_3
XFILLER_16_1320 VGND VGND VPWR VPWR sky130_fd_sc_hd__decap_3
XFILLER_41_897 VGND VGND VPWR VPWR sky130_fd_sc_hd__decap_3
XFILLER_40_385 VGND VGND VPWR VPWR sky130_fd_sc_hd__decap_3
XFILLER_51_1233 VGND VGND VPWR VPWR sky130_fd_sc_hd__decap_3
XFILLER_16_1353 VGND VGND VPWR VPWR sky130_fd_sc_hd__decap_3
XFILLER_12_1217 VGND VGND VPWR VPWR sky130_fd_sc_hd__decap_3
XFILLER_51_1266 VGND VGND VPWR VPWR sky130_fd_sc_hd__decap_3
XFILLER_16_1397 VGND VGND VPWR VPWR sky130_fd_sc_hd__decap_3
XPHY_EDGE_ROW_73_Left_154 VGND VGND VPWR VPWR sky130_fd_sc_hd__decap_3
XFILLER_45_1026 VGND VGND VPWR VPWR sky130_fd_sc_hd__decap_3
XFILLER_45_1048 VGND VGND VPWR VPWR sky130_fd_sc_hd__decap_3
XFILLER_1_971 VGND VGND VPWR VPWR sky130_fd_sc_hd__decap_3
XFILLER_68_728 VGND VGND VPWR VPWR sky130_fd_sc_hd__decap_3
XFILLER_27_1460 VGND VGND VPWR VPWR sky130_fd_sc_hd__decap_3
XFILLER_0_470 VGND VGND VPWR VPWR sky130_fd_sc_hd__decap_3
XFILLER_23_1313 VGND VGND VPWR VPWR sky130_fd_sc_hd__decap_3
XFILLER_62_1362 VGND VGND VPWR VPWR sky130_fd_sc_hd__decap_3
XFILLER_49_953 VGND VGND VPWR VPWR sky130_fd_sc_hd__decap_3
XFILLER_62_1373 VGND VGND VPWR VPWR sky130_fd_sc_hd__decap_3
XFILLER_0_492 VGND VGND VPWR VPWR sky130_fd_sc_hd__decap_3
XFILLER_48_430 VGND VGND VPWR VPWR sky130_fd_sc_hd__decap_3
XFILLER_3_1407 VGND VGND VPWR VPWR sky130_fd_sc_hd__decap_3
XFILLER_23_1357 VGND VGND VPWR VPWR sky130_fd_sc_hd__decap_3
XFILLER_64_923 VGND VGND VPWR VPWR sky130_fd_sc_hd__fill_1
XFILLER_48_474 VGND VGND VPWR VPWR sky130_fd_sc_hd__fill_2
XFILLER_63_411 VGND VGND VPWR VPWR sky130_fd_sc_hd__fill_2
XFILLER_35_113 VGND VGND VPWR VPWR sky130_fd_sc_hd__fill_1
XFILLER_48_496 VGND VGND VPWR VPWR sky130_fd_sc_hd__decap_3
XFILLER_58_1409 VGND VGND VPWR VPWR sky130_fd_sc_hd__decap_3
XFILLER_63_433 VGND VGND VPWR VPWR sky130_fd_sc_hd__decap_3
XFILLER_75_293 VGND VGND VPWR VPWR sky130_fd_sc_hd__fill_2
XFILLER_64_967 VGND VGND VPWR VPWR sky130_fd_sc_hd__decap_3
XFILLER_1_1142 VGND VGND VPWR VPWR sky130_fd_sc_hd__decap_3
XFILLER_51_617 VGND VGND VPWR VPWR sky130_fd_sc_hd__decap_3
XFILLER_1_1175 VGND VGND VPWR VPWR sky130_fd_sc_hd__fill_1
XFILLER_1_1186 VGND VGND VPWR VPWR sky130_fd_sc_hd__decap_3
XFILLER_16_360 VGND VGND VPWR VPWR sky130_fd_sc_hd__decap_3
X_3951_ _4172_/A _4349_/A VGND VGND VPWR VPWR _3952_/B sky130_fd_sc_hd__xor2_2
XFILLER_17_894 VGND VGND VPWR VPWR sky130_fd_sc_hd__fill_2
XFILLER_50_138 VGND VGND VPWR VPWR sky130_fd_sc_hd__fill_2
X_6670_ _6918_/CLK _6670_/D load_slew744/X VGND VGND VPWR VPWR _6670_/Q sky130_fd_sc_hd__dfrtp_2
XFILLER_17_1117 VGND VGND VPWR VPWR sky130_fd_sc_hd__decap_3
XFILLER_43_190 VGND VGND VPWR VPWR sky130_fd_sc_hd__decap_3
X_3882_ _3882_/A _3882_/B VGND VGND VPWR VPWR _3883_/B sky130_fd_sc_hd__xor2_2
XFILLER_32_875 VGND VGND VPWR VPWR sky130_fd_sc_hd__decap_3
XFILLER_52_1019 VGND VGND VPWR VPWR sky130_fd_sc_hd__decap_3
X_5621_ hold950/X _5825_/A0 _5627_/S VGND VGND VPWR VPWR _6683_/D sky130_fd_sc_hd__mux2_1
XTAP_TAPCELL_ROW_14_561 VGND VPWR sky130_fd_sc_hd__tapvpwrvgnd_1
XTAP_TAPCELL_ROW_14_572 VGND VPWR sky130_fd_sc_hd__tapvpwrvgnd_1
XFILLER_31_396 VGND VGND VPWR VPWR sky130_fd_sc_hd__decap_3
XFILLER_34_1453 VGND VGND VPWR VPWR sky130_fd_sc_hd__decap_3
XFILLER_30_1306 VGND VGND VPWR VPWR sky130_fd_sc_hd__decap_3
X_5552_ _6353_/Q _5564_/A2 hold954/X _5552_/B2 VGND VGND VPWR VPWR _6635_/D sky130_fd_sc_hd__a22o_2
XFILLER_30_1317 VGND VGND VPWR VPWR sky130_fd_sc_hd__decap_3
XFILLER_8_581 VGND VGND VPWR VPWR sky130_fd_sc_hd__decap_3
X_4503_ _6522_/Q _4487_/X _4502_/X _5514_/A _4647_/A1 VGND VGND VPWR VPWR _4506_/B
+ sky130_fd_sc_hd__a221o_2
XFILLER_8_592 VGND VGND VPWR VPWR sky130_fd_sc_hd__decap_3
X_5483_ _5483_/A1 _5486_/A2 _4079_/X VGND VGND VPWR VPWR _6595_/D sky130_fd_sc_hd__a21o_2
XTAP_TAPCELL_ROW_74_2120 VGND VPWR sky130_fd_sc_hd__tapvpwrvgnd_1
XTAP_TAPCELL_ROW_74_2131 VGND VPWR sky130_fd_sc_hd__tapvpwrvgnd_1
X_4434_ _6328_/Q _4847_/A2 _3306_/X _4789_/B2 VGND VGND VPWR VPWR _4434_/X sky130_fd_sc_hd__a22o_2
XFILLER_28_1202 VGND VGND VPWR VPWR sky130_fd_sc_hd__fill_2
XFILLER_67_1251 VGND VGND VPWR VPWR sky130_fd_sc_hd__decap_3
XTAP_TAPCELL_ROW_70_2017 VGND VPWR sky130_fd_sc_hd__tapvpwrvgnd_1
XTAP_TAPCELL_ROW_70_2028 VGND VPWR sky130_fd_sc_hd__tapvpwrvgnd_1
X_4365_ _6296_/Q _4750_/A2 _3290_/X _4750_/B2 VGND VGND VPWR VPWR _4365_/X sky130_fd_sc_hd__a22o_2
Xfanout505 _7085_/Q VGND VGND VPWR VPWR _4773_/A2 sky130_fd_sc_hd__clkdlybuf4s25_1
XFILLER_67_1284 VGND VGND VPWR VPWR sky130_fd_sc_hd__decap_3
XFILLER_28_1246 VGND VGND VPWR VPWR sky130_fd_sc_hd__decap_3
Xfanout516 _5565_/A2 VGND VGND VPWR VPWR _5501_/B sky130_fd_sc_hd__clkdlybuf4s25_1
XFILLER_67_1295 VGND VGND VPWR VPWR sky130_fd_sc_hd__decap_3
X_6104_ _6987_/CLK _6104_/D fanout811/X VGND VGND VPWR VPWR _6104_/Q sky130_fd_sc_hd__dfrtp_2
X_3316_ _6285_/Q _6389_/Q VGND VGND VPWR VPWR _3316_/X sky130_fd_sc_hd__xor2_2
XFILLER_8_1329 VGND VGND VPWR VPWR sky130_fd_sc_hd__decap_3
X_7084_ _7089_/CLK _7084_/D wire734/X VGND VGND VPWR VPWR _7084_/Q sky130_fd_sc_hd__dfrtp_2
Xfanout549 _5304_/S VGND VGND VPWR VPWR _5285_/A sky130_fd_sc_hd__clkdlybuf4s25_1
X_4296_ _6490_/Q _4330_/A2 _4290_/X _4295_/Y VGND VGND VPWR VPWR _4296_/X sky130_fd_sc_hd__o211a_2
XFILLER_28_1279 VGND VGND VPWR VPWR sky130_fd_sc_hd__decap_3
XFILLER_58_227 VGND VGND VPWR VPWR sky130_fd_sc_hd__decap_3
XFILLER_41_1413 VGND VGND VPWR VPWR sky130_fd_sc_hd__decap_3
X_6035_ _6035_/A0 _6035_/A1 _6035_/S VGND VGND VPWR VPWR _7039_/D sky130_fd_sc_hd__mux2_1
X_3247_ hold965/X _3246_/X _3261_/S VGND VGND VPWR VPWR _6097_/D sky130_fd_sc_hd__mux2_1
XFILLER_6_1042 VGND VGND VPWR VPWR sky130_fd_sc_hd__decap_3
XFILLER_39_452 VGND VGND VPWR VPWR sky130_fd_sc_hd__decap_3
XFILLER_41_1446 VGND VGND VPWR VPWR sky130_fd_sc_hd__decap_3
XFILLER_6_1075 VGND VGND VPWR VPWR sky130_fd_sc_hd__decap_3
XFILLER_41_1457 VGND VGND VPWR VPWR sky130_fd_sc_hd__decap_3
XFILLER_27_614 VGND VGND VPWR VPWR sky130_fd_sc_hd__fill_2
XTAP_TAPCELL_ROW_1_223 VGND VPWR sky130_fd_sc_hd__tapvpwrvgnd_1
X_3178_ _6982_/Q _6990_/Q _3222_/A VGND VGND VPWR VPWR _3178_/X sky130_fd_sc_hd__mux2_1
XTAP_TAPCELL_ROW_1_234 VGND VPWR sky130_fd_sc_hd__tapvpwrvgnd_1
XFILLER_39_496 VGND VGND VPWR VPWR sky130_fd_sc_hd__decap_3
XFILLER_55_945 VGND VGND VPWR VPWR sky130_fd_sc_hd__fill_1
XFILLER_66_293 VGND VGND VPWR VPWR sky130_fd_sc_hd__decap_3
XFILLER_27_658 VGND VGND VPWR VPWR sky130_fd_sc_hd__decap_3
XFILLER_70_904 VGND VGND VPWR VPWR sky130_fd_sc_hd__decap_3
XFILLER_15_809 VGND VGND VPWR VPWR sky130_fd_sc_hd__decap_3
XFILLER_74_1200 VGND VGND VPWR VPWR sky130_fd_sc_hd__decap_3
XFILLER_54_477 VGND VGND VPWR VPWR sky130_fd_sc_hd__decap_3
XFILLER_74_1211 VGND VGND VPWR VPWR sky130_fd_sc_hd__decap_3
XFILLER_39_1331 VGND VGND VPWR VPWR sky130_fd_sc_hd__decap_3
XFILLER_78_1391 VGND VGND VPWR VPWR sky130_fd_sc_hd__decap_3
X_6937_ _7065_/CLK _6937_/D load_slew736/X VGND VGND VPWR VPWR _6937_/Q sky130_fd_sc_hd__dfrtp_2
XFILLER_42_639 VGND VGND VPWR VPWR sky130_fd_sc_hd__decap_3
XTAP_TAPCELL_ROW_25_848 VGND VPWR sky130_fd_sc_hd__tapvpwrvgnd_1
XFILLER_35_691 VGND VGND VPWR VPWR sky130_fd_sc_hd__fill_1
XFILLER_74_1244 VGND VGND VPWR VPWR sky130_fd_sc_hd__decap_3
XTAP_TAPCELL_ROW_25_859 VGND VPWR sky130_fd_sc_hd__tapvpwrvgnd_1
XFILLER_22_330 VGND VGND VPWR VPWR sky130_fd_sc_hd__decap_3
XFILLER_35_1206 VGND VGND VPWR VPWR sky130_fd_sc_hd__decap_3
XFILLER_39_1375 VGND VGND VPWR VPWR sky130_fd_sc_hd__decap_3
XFILLER_34_190 VGND VGND VPWR VPWR sky130_fd_sc_hd__decap_3
X_6868_ _6999_/CLK _6868_/D load_slew829/X VGND VGND VPWR VPWR _6868_/Q sky130_fd_sc_hd__dfrtp_2
XFILLER_74_1288 VGND VGND VPWR VPWR sky130_fd_sc_hd__decap_3
XTAP_TAPCELL_ROW_12_509 VGND VPWR sky130_fd_sc_hd__tapvpwrvgnd_1
XFILLER_35_1239 VGND VGND VPWR VPWR sky130_fd_sc_hd__decap_3
XFILLER_10_525 VGND VGND VPWR VPWR sky130_fd_sc_hd__decap_3
X_5819_ _5819_/A0 _5929_/A0 _5822_/S VGND VGND VPWR VPWR _6838_/D sky130_fd_sc_hd__mux2_1
X_6799_ _7054_/CLK _6799_/D fanout791/X VGND VGND VPWR VPWR _6799_/Q sky130_fd_sc_hd__dfrtp_2
XFILLER_10_558 VGND VGND VPWR VPWR sky130_fd_sc_hd__decap_3
XFILLER_6_507 VGND VGND VPWR VPWR sky130_fd_sc_hd__decap_3
XFILLER_41_57 VGND VGND VPWR VPWR sky130_fd_sc_hd__decap_3
XFILLER_11_1272 VGND VGND VPWR VPWR sky130_fd_sc_hd__decap_3
XFILLER_2_713 VGND VGND VPWR VPWR sky130_fd_sc_hd__decap_3
XFILLER_68_1059 VGND VGND VPWR VPWR sky130_fd_sc_hd__decap_3
XFILLER_2_746 VGND VGND VPWR VPWR sky130_fd_sc_hd__decap_3
XFILLER_1_223 VGND VGND VPWR VPWR sky130_fd_sc_hd__fill_1
XTAP_TAPCELL_ROW_57_1672 VGND VPWR sky130_fd_sc_hd__tapvpwrvgnd_1
XFILLER_1_234 VGND VGND VPWR VPWR sky130_fd_sc_hd__decap_3
XFILLER_2_757 VGND VGND VPWR VPWR sky130_fd_sc_hd__decap_3
XTAP_TAPCELL_ROW_57_1683 VGND VPWR sky130_fd_sc_hd__tapvpwrvgnd_1
XFILLER_46_1335 VGND VGND VPWR VPWR sky130_fd_sc_hd__decap_3
XTAP_TAPCELL_ROW_57_1694 VGND VPWR sky130_fd_sc_hd__tapvpwrvgnd_1
XFILLER_2_779 VGND VGND VPWR VPWR sky130_fd_sc_hd__decap_3
XFILLER_1_267 VGND VGND VPWR VPWR sky130_fd_sc_hd__decap_3
XFILLER_46_1368 VGND VGND VPWR VPWR sky130_fd_sc_hd__decap_3
XFILLER_2_18 VGND VGND VPWR VPWR sky130_fd_sc_hd__decap_3
XFILLER_2_29 VGND VGND VPWR VPWR sky130_fd_sc_hd__decap_3
XFILLER_46_1379 VGND VGND VPWR VPWR sky130_fd_sc_hd__decap_3
XTAP_TAPCELL_ROW_53_1569 VGND VPWR sky130_fd_sc_hd__tapvpwrvgnd_1
XFILLER_66_21 VGND VGND VPWR VPWR sky130_fd_sc_hd__decap_3
XFILLER_65_709 VGND VGND VPWR VPWR sky130_fd_sc_hd__fill_1
XFILLER_66_32 VGND VGND VPWR VPWR sky130_fd_sc_hd__decap_3
XFILLER_79_1100 VGND VGND VPWR VPWR sky130_fd_sc_hd__decap_3
XFILLER_66_65 VGND VGND VPWR VPWR sky130_fd_sc_hd__decap_3
Xhold1270 _6575_/Q VGND VGND VPWR VPWR _5463_/A1 sky130_fd_sc_hd__dlygate4sd3_1
XFILLER_79_1133 VGND VGND VPWR VPWR sky130_fd_sc_hd__decap_3
Xhold1281 _6762_/Q VGND VGND VPWR VPWR _5714_/A1 sky130_fd_sc_hd__dlygate4sd3_1
XFILLER_45_433 VGND VGND VPWR VPWR sky130_fd_sc_hd__decap_3
XTAP_TAPCELL_ROW_66_1908 VGND VPWR sky130_fd_sc_hd__tapvpwrvgnd_1
Xhold1292 _6830_/Q VGND VGND VPWR VPWR _5810_/A1 sky130_fd_sc_hd__dlygate4sd3_1
XTAP_TAPCELL_ROW_66_1919 VGND VPWR sky130_fd_sc_hd__tapvpwrvgnd_1
XFILLER_79_1166 VGND VGND VPWR VPWR sky130_fd_sc_hd__decap_3
XFILLER_45_455 VGND VGND VPWR VPWR sky130_fd_sc_hd__decap_3
XFILLER_79_1177 VGND VGND VPWR VPWR sky130_fd_sc_hd__decap_3
XFILLER_2_1462 VGND VGND VPWR VPWR sky130_fd_sc_hd__decap_3
XFILLER_17_157 VGND VGND VPWR VPWR sky130_fd_sc_hd__fill_2
XFILLER_33_617 VGND VGND VPWR VPWR sky130_fd_sc_hd__decap_3
XFILLER_57_1431 VGND VGND VPWR VPWR sky130_fd_sc_hd__decap_3
XFILLER_14_842 VGND VGND VPWR VPWR sky130_fd_sc_hd__decap_3
XFILLER_60_447 VGND VGND VPWR VPWR sky130_fd_sc_hd__decap_3
XFILLER_18_1415 VGND VGND VPWR VPWR sky130_fd_sc_hd__decap_3
XFILLER_53_1328 VGND VGND VPWR VPWR sky130_fd_sc_hd__decap_3
XFILLER_18_1459 VGND VGND VPWR VPWR sky130_fd_sc_hd__decap_3
XFILLER_51_1041 VGND VGND VPWR VPWR sky130_fd_sc_hd__decap_3
XFILLER_12_1003 VGND VGND VPWR VPWR sky130_fd_sc_hd__fill_1
XFILLER_9_389 VGND VGND VPWR VPWR sky130_fd_sc_hd__decap_3
XFILLER_12_1025 VGND VGND VPWR VPWR sky130_fd_sc_hd__fill_2
XFILLER_31_90 VGND VGND VPWR VPWR sky130_fd_sc_hd__decap_3
XFILLER_56_6 VGND VGND VPWR VPWR sky130_fd_sc_hd__decap_3
XFILLER_5_573 VGND VGND VPWR VPWR sky130_fd_sc_hd__decap_3
XFILLER_64_1424 VGND VGND VPWR VPWR sky130_fd_sc_hd__decap_3
XFILLER_64_1435 VGND VGND VPWR VPWR sky130_fd_sc_hd__decap_3
X_4150_ _4222_/A _4258_/B VGND VGND VPWR VPWR _4231_/A sky130_fd_sc_hd__xnor2_2
XFILLER_25_1419 VGND VGND VPWR VPWR sky130_fd_sc_hd__decap_3
XFILLER_64_1468 VGND VGND VPWR VPWR sky130_fd_sc_hd__fill_1
X_3101_ _7081_/Q _3100_/B _7096_/D VGND VGND VPWR VPWR _7081_/D sky130_fd_sc_hd__a21o_2
XFILLER_7_1340 VGND VGND VPWR VPWR sky130_fd_sc_hd__decap_3
X_4081_ _6243_/Q _4081_/A2 _4079_/X _4080_/X VGND VGND VPWR VPWR _6243_/D sky130_fd_sc_hd__o22a_2
XFILLER_7_1351 VGND VGND VPWR VPWR sky130_fd_sc_hd__decap_3
XFILLER_56_709 VGND VGND VPWR VPWR sky130_fd_sc_hd__decap_3
XFILLER_49_750 VGND VGND VPWR VPWR sky130_fd_sc_hd__decap_3
XFILLER_23_1132 VGND VGND VPWR VPWR sky130_fd_sc_hd__decap_3
XFILLER_3_1204 VGND VGND VPWR VPWR sky130_fd_sc_hd__decap_3
XFILLER_37_912 VGND VGND VPWR VPWR sky130_fd_sc_hd__decap_3
XFILLER_7_1384 VGND VGND VPWR VPWR sky130_fd_sc_hd__decap_3
XFILLER_49_783 VGND VGND VPWR VPWR sky130_fd_sc_hd__fill_1
XFILLER_3_1248 VGND VGND VPWR VPWR sky130_fd_sc_hd__decap_3
XFILLER_37_956 VGND VGND VPWR VPWR sky130_fd_sc_hd__fill_1
XFILLER_36_477 VGND VGND VPWR VPWR sky130_fd_sc_hd__decap_3
XFILLER_64_786 VGND VGND VPWR VPWR sky130_fd_sc_hd__decap_3
XTAP_TAPCELL_ROW_19_686 VGND VPWR sky130_fd_sc_hd__tapvpwrvgnd_1
XFILLER_52_948 VGND VGND VPWR VPWR sky130_fd_sc_hd__decap_3
XFILLER_23_116 VGND VGND VPWR VPWR sky130_fd_sc_hd__fill_1
X_4983_ _4981_/X _4982_/Y _5257_/A2 VGND VGND VPWR VPWR _4985_/S sky130_fd_sc_hd__a21oi_2
XTAP_TAPCELL_ROW_19_697 VGND VPWR sky130_fd_sc_hd__tapvpwrvgnd_1
XFILLER_16_190 VGND VGND VPWR VPWR sky130_fd_sc_hd__decap_3
X_6722_ _6986_/CLK _6722_/D load_slew648/X VGND VGND VPWR VPWR _6722_/Q sky130_fd_sc_hd__dfrtp_2
XFILLER_51_469 VGND VGND VPWR VPWR sky130_fd_sc_hd__decap_3
X_3934_ _6502_/Q _4174_/A2 _4013_/A _3933_/Y VGND VGND VPWR VPWR _3934_/X sky130_fd_sc_hd__o211a_2
XFILLER_71_1428 VGND VGND VPWR VPWR sky130_fd_sc_hd__decap_3
XFILLER_60_981 VGND VGND VPWR VPWR sky130_fd_sc_hd__fill_1
X_6653_ _6905_/CLK _6653_/D fanout731/X VGND VGND VPWR VPWR _6653_/Q sky130_fd_sc_hd__dfrtp_2
X_3865_ _4347_/A _4220_/B VGND VGND VPWR VPWR _3865_/Y sky130_fd_sc_hd__xnor2_2
XFILLER_31_182 VGND VGND VPWR VPWR sky130_fd_sc_hd__decap_3
XFILLER_20_867 VGND VGND VPWR VPWR sky130_fd_sc_hd__fill_1
X_5604_ _5607_/A2 _5572_/Y _5602_/Y _5604_/B2 VGND VGND VPWR VPWR _6675_/D sky130_fd_sc_hd__a22o_2
XFILLER_34_1261 VGND VGND VPWR VPWR sky130_fd_sc_hd__decap_3
X_3796_ _3796_/A _3796_/B VGND VGND VPWR VPWR _4562_/B sky130_fd_sc_hd__or2_2
X_6584_ _6929_/CLK _6584_/D load_slew705/X VGND VGND VPWR VPWR _6584_/Q sky130_fd_sc_hd__dfrtp_2
XFILLER_34_1294 VGND VGND VPWR VPWR sky130_fd_sc_hd__decap_3
XFILLER_69_1313 VGND VGND VPWR VPWR sky130_fd_sc_hd__decap_3
XFILLER_30_1147 VGND VGND VPWR VPWR sky130_fd_sc_hd__fill_1
X_5535_ _6368_/Q _5501_/B _5535_/B1 _5562_/B2 VGND VGND VPWR VPWR _6618_/D sky130_fd_sc_hd__a22o_2
XFILLER_69_1357 VGND VGND VPWR VPWR sky130_fd_sc_hd__decap_3
X_5466_ _5466_/A1 _5474_/A2 _4803_/X VGND VGND VPWR VPWR _6578_/D sky130_fd_sc_hd__a21o_2
X_4417_ _6848_/Q _4774_/A2 wire36/X _4416_/X VGND VGND VPWR VPWR _4417_/X sky130_fd_sc_hd__a211o_2
X_5397_ _5397_/A1 _5461_/A2 _4407_/X VGND VGND VPWR VPWR _6509_/D sky130_fd_sc_hd__a21o_2
Xfanout302 _4758_/A2 VGND VGND VPWR VPWR fanout302/X sky130_fd_sc_hd__clkdlybuf4s25_1
Xfanout313 _3105_/X VGND VGND VPWR VPWR _3205_/B1 sky130_fd_sc_hd__clkdlybuf4s25_1
XFILLER_8_1126 VGND VGND VPWR VPWR sky130_fd_sc_hd__decap_3
X_4348_ _4348_/A _4348_/B VGND VGND VPWR VPWR _4349_/B sky130_fd_sc_hd__xnor2_2
Xfanout324 _5502_/D VGND VGND VPWR VPWR _5546_/B2 sky130_fd_sc_hd__clkdlybuf4s25_1
XFILLER_59_514 VGND VGND VPWR VPWR sky130_fd_sc_hd__decap_3
XTAP_TAPCELL_ROW_6_348 VGND VPWR sky130_fd_sc_hd__tapvpwrvgnd_1
Xfanout346 _3897_/A2 VGND VGND VPWR VPWR _3807_/A2 sky130_fd_sc_hd__clkdlybuf4s25_1
XTAP_TAPCELL_ROW_6_359 VGND VPWR sky130_fd_sc_hd__tapvpwrvgnd_1
Xfanout357 _5606_/A2 VGND VGND VPWR VPWR _5603_/A1 sky130_fd_sc_hd__clkdlybuf4s25_1
X_7067_ _7096_/CLK _7067_/D load_slew677/X VGND VGND VPWR VPWR _7067_/Q sky130_fd_sc_hd__dfrtp_2
Xfanout368 _5600_/A2 VGND VGND VPWR VPWR _5594_/A1 sky130_fd_sc_hd__clkdlybuf4s25_1
Xfanout379 wire383/A VGND VGND VPWR VPWR _4056_/A2 sky130_fd_sc_hd__clkdlybuf4s25_1
X_4279_ _4291_/A _4279_/B VGND VGND VPWR VPWR _4280_/B sky130_fd_sc_hd__xnor2_2
XFILLER_80_1270 VGND VGND VPWR VPWR sky130_fd_sc_hd__decap_3
XFILLER_28_901 VGND VGND VPWR VPWR sky130_fd_sc_hd__fill_1
XFILLER_45_1390 VGND VGND VPWR VPWR sky130_fd_sc_hd__decap_3
XFILLER_80_1292 VGND VGND VPWR VPWR sky130_fd_sc_hd__decap_3
X_6018_ hold957/X hold967/X _6050_/S VGND VGND VPWR VPWR _7022_/D sky130_fd_sc_hd__mux2_1
XFILLER_41_1254 VGND VGND VPWR VPWR sky130_fd_sc_hd__decap_3
XFILLER_28_934 VGND VGND VPWR VPWR sky130_fd_sc_hd__decap_3
XFILLER_39_293 VGND VGND VPWR VPWR sky130_fd_sc_hd__decap_3
XFILLER_41_1287 VGND VGND VPWR VPWR sky130_fd_sc_hd__fill_1
XFILLER_55_742 VGND VGND VPWR VPWR sky130_fd_sc_hd__decap_3
XFILLER_41_1298 VGND VGND VPWR VPWR sky130_fd_sc_hd__decap_3
XFILLER_76_1306 VGND VGND VPWR VPWR sky130_fd_sc_hd__decap_3
XFILLER_27_455 VGND VGND VPWR VPWR sky130_fd_sc_hd__fill_2
XFILLER_76_1317 VGND VGND VPWR VPWR sky130_fd_sc_hd__decap_3
XFILLER_15_617 VGND VGND VPWR VPWR sky130_fd_sc_hd__fill_1
XFILLER_54_274 VGND VGND VPWR VPWR sky130_fd_sc_hd__decap_3
XFILLER_43_948 VGND VGND VPWR VPWR sky130_fd_sc_hd__decap_3
XFILLER_43_959 VGND VGND VPWR VPWR sky130_fd_sc_hd__decap_3
XFILLER_30_609 VGND VGND VPWR VPWR sky130_fd_sc_hd__fill_1
XFILLER_11_801 VGND VGND VPWR VPWR sky130_fd_sc_hd__decap_3
XFILLER_39_1183 VGND VGND VPWR VPWR sky130_fd_sc_hd__decap_3
XTAP_TAPCELL_ROW_46_1384 VGND VPWR sky130_fd_sc_hd__tapvpwrvgnd_1
XFILLER_74_1085 VGND VGND VPWR VPWR sky130_fd_sc_hd__decap_3
XFILLER_51_992 VGND VGND VPWR VPWR sky130_fd_sc_hd__decap_3
XFILLER_74_1096 VGND VGND VPWR VPWR sky130_fd_sc_hd__decap_3
XFILLER_11_834 VGND VGND VPWR VPWR sky130_fd_sc_hd__decap_3
XFILLER_22_160 VGND VGND VPWR VPWR sky130_fd_sc_hd__decap_3
XFILLER_35_1047 VGND VGND VPWR VPWR sky130_fd_sc_hd__decap_3
XTAP_TAPCELL_ROW_46_1395 VGND VPWR sky130_fd_sc_hd__tapvpwrvgnd_1
XFILLER_50_480 VGND VGND VPWR VPWR sky130_fd_sc_hd__decap_3
XFILLER_13_1301 VGND VGND VPWR VPWR sky130_fd_sc_hd__decap_3
XFILLER_10_344 VGND VGND VPWR VPWR sky130_fd_sc_hd__decap_3
XFILLER_52_1350 VGND VGND VPWR VPWR sky130_fd_sc_hd__decap_3
XFILLER_13_1334 VGND VGND VPWR VPWR sky130_fd_sc_hd__decap_3
XFILLER_13_1345 VGND VGND VPWR VPWR sky130_fd_sc_hd__decap_3
XFILLER_10_388 VGND VGND VPWR VPWR sky130_fd_sc_hd__decap_3
XFILLER_52_1394 VGND VGND VPWR VPWR sky130_fd_sc_hd__decap_3
XTAP_TAPCELL_ROW_59_1723 VGND VPWR sky130_fd_sc_hd__tapvpwrvgnd_1
XFILLER_13_1378 VGND VGND VPWR VPWR sky130_fd_sc_hd__decap_3
XTAP_TAPCELL_ROW_59_1734 VGND VPWR sky130_fd_sc_hd__tapvpwrvgnd_1
XTAP_TAPCELL_ROW_59_1745 VGND VPWR sky130_fd_sc_hd__tapvpwrvgnd_1
XFILLER_2_521 VGND VGND VPWR VPWR sky130_fd_sc_hd__decap_3
XFILLER_2_565 VGND VGND VPWR VPWR sky130_fd_sc_hd__decap_3
XFILLER_77_42 VGND VGND VPWR VPWR sky130_fd_sc_hd__decap_3
XFILLER_77_75 VGND VGND VPWR VPWR sky130_fd_sc_hd__decap_3
XFILLER_38_709 VGND VGND VPWR VPWR sky130_fd_sc_hd__decap_3
XFILLER_24_1441 VGND VGND VPWR VPWR sky130_fd_sc_hd__decap_3
XFILLER_19_912 VGND VGND VPWR VPWR sky130_fd_sc_hd__decap_3
Xclkbuf_3_6_0_clk clkbuf_0_clk/X VGND VGND VPWR VPWR clkbuf_3_6_0_clk/X sky130_fd_sc_hd__clkbuf_8
XFILLER_46_731 VGND VGND VPWR VPWR sky130_fd_sc_hd__fill_2
XFILLER_20_1338 VGND VGND VPWR VPWR sky130_fd_sc_hd__decap_3
XTAP_TAPCELL_ROW_29_951 VGND VPWR sky130_fd_sc_hd__tapvpwrvgnd_1
XTAP_TAPCELL_ROW_29_962 VGND VPWR sky130_fd_sc_hd__tapvpwrvgnd_1
XFILLER_18_466 VGND VGND VPWR VPWR sky130_fd_sc_hd__decap_3
XFILLER_46_775 VGND VGND VPWR VPWR sky130_fd_sc_hd__fill_2
XFILLER_18_477 VGND VGND VPWR VPWR sky130_fd_sc_hd__fill_1
XFILLER_2_1270 VGND VGND VPWR VPWR sky130_fd_sc_hd__decap_3
XFILLER_33_414 VGND VGND VPWR VPWR sky130_fd_sc_hd__decap_3
XFILLER_34_937 VGND VGND VPWR VPWR sky130_fd_sc_hd__decap_3
XTAP_TAPCELL_ROW_16_612 VGND VPWR sky130_fd_sc_hd__tapvpwrvgnd_1
XFILLER_73_594 VGND VGND VPWR VPWR sky130_fd_sc_hd__decap_3
XTAP_TAPCELL_ROW_16_623 VGND VPWR sky130_fd_sc_hd__tapvpwrvgnd_1
XFILLER_33_458 VGND VGND VPWR VPWR sky130_fd_sc_hd__fill_2
XFILLER_61_767 VGND VGND VPWR VPWR sky130_fd_sc_hd__decap_3
XFILLER_21_609 VGND VGND VPWR VPWR sky130_fd_sc_hd__decap_3
XFILLER_18_1223 VGND VGND VPWR VPWR sky130_fd_sc_hd__decap_3
XFILLER_57_1272 VGND VGND VPWR VPWR sky130_fd_sc_hd__decap_3
XFILLER_42_970 VGND VGND VPWR VPWR sky130_fd_sc_hd__fill_2
XFILLER_14_672 VGND VGND VPWR VPWR sky130_fd_sc_hd__decap_3
XFILLER_60_277 VGND VGND VPWR VPWR sky130_fd_sc_hd__decap_3
XFILLER_18_1256 VGND VGND VPWR VPWR sky130_fd_sc_hd__decap_3
XFILLER_53_1136 VGND VGND VPWR VPWR sky130_fd_sc_hd__decap_3
XFILLER_18_1267 VGND VGND VPWR VPWR sky130_fd_sc_hd__decap_3
XFILLER_70_1450 VGND VGND VPWR VPWR sky130_fd_sc_hd__decap_3
X_3650_ _3661_/C _3661_/B _3636_/A VGND VGND VPWR VPWR _3652_/D sky130_fd_sc_hd__a21o_2
XFILLER_31_1401 VGND VGND VPWR VPWR sky130_fd_sc_hd__decap_3
XFILLER_9_175 VGND VGND VPWR VPWR sky130_fd_sc_hd__decap_3
XFILLER_31_1434 VGND VGND VPWR VPWR sky130_fd_sc_hd__decap_3
X_3581_ _3583_/B _3583_/C VGND VGND VPWR VPWR _3581_/Y sky130_fd_sc_hd__nand2_2
X_5320_ _6791_/Q _4994_/B _5330_/S VGND VGND VPWR VPWR _5320_/X sky130_fd_sc_hd__mux2_1
XFILLER_54_3 VGND VGND VPWR VPWR sky130_fd_sc_hd__decap_3
X_5251_ _6425_/Q _5263_/A2 _5250_/X VGND VGND VPWR VPWR _6425_/D sky130_fd_sc_hd__a21o_2
XFILLER_9_1413 VGND VGND VPWR VPWR sky130_fd_sc_hd__decap_3
X_4202_ _4281_/B _4202_/B VGND VGND VPWR VPWR _4203_/B sky130_fd_sc_hd__xor2_2
XFILLER_64_1232 VGND VGND VPWR VPWR sky130_fd_sc_hd__decap_3
XFILLER_29_1363 VGND VGND VPWR VPWR sky130_fd_sc_hd__decap_3
XFILLER_68_300 VGND VGND VPWR VPWR sky130_fd_sc_hd__decap_3
X_5182_ _6738_/Q _5182_/B VGND VGND VPWR VPWR _5182_/Y sky130_fd_sc_hd__nor2_2
XFILLER_9_1446 VGND VGND VPWR VPWR sky130_fd_sc_hd__decap_3
XFILLER_9_1457 VGND VGND VPWR VPWR sky130_fd_sc_hd__decap_3
XFILLER_29_1396 VGND VGND VPWR VPWR sky130_fd_sc_hd__decap_3
XFILLER_64_1276 VGND VGND VPWR VPWR sky130_fd_sc_hd__decap_3
X_4133_ _4318_/A _4133_/B VGND VGND VPWR VPWR _4133_/Y sky130_fd_sc_hd__nand2_2
XFILLER_3_72 VGND VGND VPWR VPWR sky130_fd_sc_hd__decap_3
XFILLER_56_506 VGND VGND VPWR VPWR sky130_fd_sc_hd__decap_3
XFILLER_3_1012 VGND VGND VPWR VPWR sky130_fd_sc_hd__decap_3
XFILLER_56_539 VGND VGND VPWR VPWR sky130_fd_sc_hd__fill_1
X_4064_ _4088_/A1 _4694_/B _4277_/B _5515_/A1 _6593_/Q VGND VGND VPWR VPWR _4064_/X
+ sky130_fd_sc_hd__a32o_2
XFILLER_7_1192 VGND VGND VPWR VPWR sky130_fd_sc_hd__decap_3
XFILLER_3_1045 VGND VGND VPWR VPWR sky130_fd_sc_hd__decap_3
Xwire23 wire23/A VGND VGND VPWR VPWR wire23/X sky130_fd_sc_hd__buf_2
XFILLER_36_241 VGND VGND VPWR VPWR sky130_fd_sc_hd__decap_3
XFILLER_52_701 VGND VGND VPWR VPWR sky130_fd_sc_hd__decap_3
XFILLER_24_403 VGND VGND VPWR VPWR sky130_fd_sc_hd__decap_3
XFILLER_3_1089 VGND VGND VPWR VPWR sky130_fd_sc_hd__decap_3
XFILLER_25_959 VGND VGND VPWR VPWR sky130_fd_sc_hd__decap_3
XFILLER_51_222 VGND VGND VPWR VPWR sky130_fd_sc_hd__fill_2
Xwire89 wire89/A VGND VGND VPWR VPWR wire89/X sky130_fd_sc_hd__buf_6
XFILLER_24_447 VGND VGND VPWR VPWR sky130_fd_sc_hd__decap_3
XFILLER_36_1312 VGND VGND VPWR VPWR sky130_fd_sc_hd__decap_3
XFILLER_75_1372 VGND VGND VPWR VPWR sky130_fd_sc_hd__decap_3
XFILLER_33_970 VGND VGND VPWR VPWR sky130_fd_sc_hd__fill_1
XFILLER_36_1323 VGND VGND VPWR VPWR sky130_fd_sc_hd__decap_3
X_4966_ _6417_/Q _4966_/B VGND VGND VPWR VPWR _5225_/B sky130_fd_sc_hd__xnor2_2
XFILLER_52_789 VGND VGND VPWR VPWR sky130_fd_sc_hd__decap_3
XFILLER_71_1225 VGND VGND VPWR VPWR sky130_fd_sc_hd__decap_3
XFILLER_11_119 VGND VGND VPWR VPWR sky130_fd_sc_hd__decap_3
XFILLER_33_981 VGND VGND VPWR VPWR sky130_fd_sc_hd__fill_1
X_6705_ _6982_/CLK _6705_/D fanout746/X VGND VGND VPWR VPWR _6705_/Q sky130_fd_sc_hd__dfrtp_2
XFILLER_71_1236 VGND VGND VPWR VPWR sky130_fd_sc_hd__decap_3
XFILLER_36_1356 VGND VGND VPWR VPWR sky130_fd_sc_hd__decap_3
X_3917_ _3960_/A _6302_/Q VGND VGND VPWR VPWR _3917_/X sky130_fd_sc_hd__and2b_2
X_4897_ _6319_/Q wire503/X _3464_/X wire383/X VGND VGND VPWR VPWR _4897_/X sky130_fd_sc_hd__a22o_2
XFILLER_71_1269 VGND VGND VPWR VPWR sky130_fd_sc_hd__decap_3
XFILLER_22_15 VGND VGND VPWR VPWR sky130_fd_sc_hd__decap_3
X_6636_ _7012_/CLK _6636_/D load_slew801/X VGND VGND VPWR VPWR _6636_/Q sky130_fd_sc_hd__dfrtp_2
X_3848_ _3848_/A _3848_/B VGND VGND VPWR VPWR _3849_/B sky130_fd_sc_hd__xnor2_2
XFILLER_22_59 VGND VGND VPWR VPWR sky130_fd_sc_hd__decap_3
XTAP_TAPCELL_ROW_41_1270 VGND VPWR sky130_fd_sc_hd__tapvpwrvgnd_1
XFILLER_34_1091 VGND VGND VPWR VPWR sky130_fd_sc_hd__fill_1
X_3779_ _6337_/Q _3807_/A2 _3777_/X _3778_/X VGND VGND VPWR VPWR _4291_/B sky130_fd_sc_hd__o22a_2
X_6567_ _6905_/CLK _6567_/D wire734/X VGND VGND VPWR VPWR _6567_/Q sky130_fd_sc_hd__dfrtp_2
XFILLER_69_1132 VGND VGND VPWR VPWR sky130_fd_sc_hd__decap_3
X_5518_ _7086_/Q _6617_/Q VGND VGND VPWR VPWR _5518_/X sky130_fd_sc_hd__or2_2
X_6498_ _6910_/CLK _6498_/D load_slew786/X VGND VGND VPWR VPWR _6498_/Q sky130_fd_sc_hd__dfrtp_2
XFILLER_69_1165 VGND VGND VPWR VPWR sky130_fd_sc_hd__decap_3
XFILLER_79_609 VGND VGND VPWR VPWR sky130_fd_sc_hd__decap_3
X_5449_ _5449_/A1 _5453_/A2 _4019_/X VGND VGND VPWR VPWR _6561_/D sky130_fd_sc_hd__a21o_2
XFILLER_69_1198 VGND VGND VPWR VPWR sky130_fd_sc_hd__decap_3
XFILLER_47_1452 VGND VGND VPWR VPWR sky130_fd_sc_hd__decap_3
XFILLER_47_1463 VGND VGND VPWR VPWR sky130_fd_sc_hd__decap_3
Xfanout121 _4901_/Y VGND VGND VPWR VPWR fanout121/X sky130_fd_sc_hd__clkdlybuf4s25_1
XFILLER_43_1316 VGND VGND VPWR VPWR sky130_fd_sc_hd__decap_3
Xfanout132 _5331_/S VGND VGND VPWR VPWR _5337_/S sky130_fd_sc_hd__clkdlybuf4s25_1
Xclkbuf_4_1__f_clk clkbuf_3_0_0_clk/X VGND VGND VPWR VPWR clkload0/A sky130_fd_sc_hd__clkbuf_16
XTAP_TAPCELL_ROW_50_1506 VGND VPWR sky130_fd_sc_hd__tapvpwrvgnd_1
XFILLER_47_12 VGND VGND VPWR VPWR sky130_fd_sc_hd__fill_1
Xfanout176 _3447_/S VGND VGND VPWR VPWR _3243_/S sky130_fd_sc_hd__clkdlybuf4s25_1
XFILLER_75_826 VGND VGND VPWR VPWR sky130_fd_sc_hd__decap_3
Xfanout187 _3078_/Y VGND VGND VPWR VPWR _3481_/S sky130_fd_sc_hd__clkdlybuf4s25_1
Xfanout198 _3078_/Y VGND VGND VPWR VPWR _3269_/S sky130_fd_sc_hd__clkdlybuf4s25_1
XFILLER_59_399 VGND VGND VPWR VPWR sky130_fd_sc_hd__decap_3
XFILLER_47_89 VGND VGND VPWR VPWR sky130_fd_sc_hd__decap_3
XFILLER_28_753 VGND VGND VPWR VPWR sky130_fd_sc_hd__decap_3
XFILLER_76_1114 VGND VGND VPWR VPWR sky130_fd_sc_hd__decap_3
XFILLER_27_252 VGND VGND VPWR VPWR sky130_fd_sc_hd__fill_2
XFILLER_28_797 VGND VGND VPWR VPWR sky130_fd_sc_hd__decap_3
XFILLER_42_200 VGND VGND VPWR VPWR sky130_fd_sc_hd__decap_3
XTAP_TAPCELL_ROW_48_1446 VGND VPWR sky130_fd_sc_hd__tapvpwrvgnd_1
XFILLER_76_1147 VGND VGND VPWR VPWR sky130_fd_sc_hd__fill_1
XFILLER_76_1158 VGND VGND VPWR VPWR sky130_fd_sc_hd__decap_3
XTAP_TAPCELL_ROW_48_1457 VGND VPWR sky130_fd_sc_hd__tapvpwrvgnd_1
XFILLER_43_767 VGND VGND VPWR VPWR sky130_fd_sc_hd__decap_3
XFILLER_15_469 VGND VGND VPWR VPWR sky130_fd_sc_hd__decap_3
XFILLER_54_1412 VGND VGND VPWR VPWR sky130_fd_sc_hd__decap_3
XFILLER_70_575 VGND VGND VPWR VPWR sky130_fd_sc_hd__decap_3
XFILLER_24_981 VGND VGND VPWR VPWR sky130_fd_sc_hd__decap_3
XFILLER_15_1407 VGND VGND VPWR VPWR sky130_fd_sc_hd__decap_3
XFILLER_54_1456 VGND VGND VPWR VPWR sky130_fd_sc_hd__decap_3
XFILLER_50_1309 VGND VGND VPWR VPWR sky130_fd_sc_hd__decap_3
XFILLER_7_646 VGND VGND VPWR VPWR sky130_fd_sc_hd__decap_3
XFILLER_48_1205 VGND VGND VPWR VPWR sky130_fd_sc_hd__fill_1
XFILLER_3_830 VGND VGND VPWR VPWR sky130_fd_sc_hd__decap_3
XFILLER_48_1227 VGND VGND VPWR VPWR sky130_fd_sc_hd__decap_3
XFILLER_3_841 VGND VGND VPWR VPWR sky130_fd_sc_hd__decap_3
XFILLER_40_9 VGND VGND VPWR VPWR sky130_fd_sc_hd__decap_3
XFILLER_3_874 VGND VGND VPWR VPWR sky130_fd_sc_hd__decap_3
XFILLER_69_108 VGND VGND VPWR VPWR sky130_fd_sc_hd__decap_3
XFILLER_2_351 VGND VGND VPWR VPWR sky130_fd_sc_hd__decap_3
Xload_slew538 _5164_/B VGND VGND VPWR VPWR _5318_/S sky130_fd_sc_hd__clkbuf_4
XFILLER_61_1416 VGND VGND VPWR VPWR sky130_fd_sc_hd__decap_3
XFILLER_2_395 VGND VGND VPWR VPWR sky130_fd_sc_hd__decap_3
XFILLER_77_130 VGND VGND VPWR VPWR sky130_fd_sc_hd__decap_3
XFILLER_38_506 VGND VGND VPWR VPWR sky130_fd_sc_hd__decap_3
XFILLER_61_1449 VGND VGND VPWR VPWR sky130_fd_sc_hd__decap_3
XFILLER_19_6 VGND VGND VPWR VPWR sky130_fd_sc_hd__decap_3
XFILLER_66_848 VGND VGND VPWR VPWR sky130_fd_sc_hd__decap_3
XFILLER_4_1332 VGND VGND VPWR VPWR sky130_fd_sc_hd__decap_3
XFILLER_24_1282 VGND VGND VPWR VPWR sky130_fd_sc_hd__decap_3
XFILLER_4_1365 VGND VGND VPWR VPWR sky130_fd_sc_hd__decap_3
XFILLER_18_230 VGND VGND VPWR VPWR sky130_fd_sc_hd__decap_3
XFILLER_59_1301 VGND VGND VPWR VPWR sky130_fd_sc_hd__decap_3
XFILLER_65_369 VGND VGND VPWR VPWR sky130_fd_sc_hd__decap_3
XFILLER_4_1376 VGND VGND VPWR VPWR sky130_fd_sc_hd__decap_3
XFILLER_20_1146 VGND VGND VPWR VPWR sky130_fd_sc_hd__fill_2
XFILLER_0_1229 VGND VGND VPWR VPWR sky130_fd_sc_hd__decap_3
XFILLER_59_1334 VGND VGND VPWR VPWR sky130_fd_sc_hd__decap_3
XFILLER_59_1345 VGND VGND VPWR VPWR sky130_fd_sc_hd__decap_3
XFILLER_33_222 VGND VGND VPWR VPWR sky130_fd_sc_hd__fill_2
XFILLER_34_745 VGND VGND VPWR VPWR sky130_fd_sc_hd__fill_1
XFILLER_59_1378 VGND VGND VPWR VPWR sky130_fd_sc_hd__decap_3
XFILLER_34_767 VGND VGND VPWR VPWR sky130_fd_sc_hd__decap_3
X_4820_ _6332_/Q _4819_/X wire60/X VGND VGND VPWR VPWR _6332_/D sky130_fd_sc_hd__mux2_1
XFILLER_61_575 VGND VGND VPWR VPWR sky130_fd_sc_hd__fill_1
XFILLER_21_417 VGND VGND VPWR VPWR sky130_fd_sc_hd__fill_2
XFILLER_33_277 VGND VGND VPWR VPWR sky130_fd_sc_hd__decap_3
XFILLER_57_1080 VGND VGND VPWR VPWR sky130_fd_sc_hd__fill_2
XFILLER_61_597 VGND VGND VPWR VPWR sky130_fd_sc_hd__decap_3
XFILLER_14_480 VGND VGND VPWR VPWR sky130_fd_sc_hd__decap_3
X_4751_ _6909_/Q _4751_/A2 wire36/X _4750_/X VGND VGND VPWR VPWR _4751_/X sky130_fd_sc_hd__a211o_2
XFILLER_18_1064 VGND VGND VPWR VPWR sky130_fd_sc_hd__fill_1
X_3702_ _3661_/X _3702_/B _3786_/B _3786_/C VGND VGND VPWR VPWR _3829_/B sky130_fd_sc_hd__and4b_2
X_4682_ _4703_/A _4294_/Y _4681_/Y _4880_/C1 VGND VGND VPWR VPWR _4683_/C sky130_fd_sc_hd__o211ai_2
XFILLER_30_984 VGND VGND VPWR VPWR sky130_fd_sc_hd__decap_3
X_6421_ _6991_/CLK _6421_/D wire796/X VGND VGND VPWR VPWR _6421_/Q sky130_fd_sc_hd__dfrtp_2
X_3633_ _5606_/A1 _3631_/X _3632_/X _3629_/X _5506_/A VGND VGND VPWR VPWR _3671_/A
+ sky130_fd_sc_hd__a32o_2
XFILLER_70_1291 VGND VGND VPWR VPWR sky130_fd_sc_hd__decap_3
XFILLER_31_1242 VGND VGND VPWR VPWR sky130_fd_sc_hd__decap_3
XFILLER_31_1275 VGND VGND VPWR VPWR sky130_fd_sc_hd__decap_3
X_3564_ _5577_/A _3564_/B VGND VGND VPWR VPWR _3576_/B sky130_fd_sc_hd__nand2_2
X_6352_ _6954_/CLK _6352_/D load_slew648/X VGND VGND VPWR VPWR _6352_/Q sky130_fd_sc_hd__dfrtp_2
X_5303_ _6444_/Q _5302_/X _5345_/S VGND VGND VPWR VPWR _6444_/D sky130_fd_sc_hd__mux2_1
X_6283_ clkload9/A _6283_/D load_slew643/X VGND VGND VPWR VPWR _6283_/Q sky130_fd_sc_hd__dfrtp_2
XFILLER_66_1338 VGND VGND VPWR VPWR sky130_fd_sc_hd__decap_3
X_3495_ _5508_/A _6641_/Q _4312_/A _6633_/Q _5576_/A2 VGND VGND VPWR VPWR _3495_/X
+ sky130_fd_sc_hd__a221o_2
XFILLER_9_1210 VGND VGND VPWR VPWR sky130_fd_sc_hd__decap_3
X_5234_ _5318_/S _5234_/B VGND VGND VPWR VPWR _5234_/Y sky130_fd_sc_hd__nand2_2
XFILLER_64_1040 VGND VGND VPWR VPWR sky130_fd_sc_hd__decap_3
XFILLER_29_1171 VGND VGND VPWR VPWR sky130_fd_sc_hd__decap_3
XFILLER_9_1254 VGND VGND VPWR VPWR sky130_fd_sc_hd__decap_3
X_5165_ _6391_/Q wire112/A _5013_/S _5164_/X VGND VGND VPWR VPWR _6391_/D sky130_fd_sc_hd__a22o_2
XFILLER_5_1107 VGND VGND VPWR VPWR sky130_fd_sc_hd__decap_3
XFILLER_68_141 VGND VGND VPWR VPWR sky130_fd_sc_hd__decap_3
XFILLER_9_1287 VGND VGND VPWR VPWR sky130_fd_sc_hd__fill_1
XFILLER_57_826 VGND VGND VPWR VPWR sky130_fd_sc_hd__decap_3
XFILLER_9_1298 VGND VGND VPWR VPWR sky130_fd_sc_hd__decap_3
X_4116_ _6810_/Q _4869_/A2 wire36/X _4115_/X VGND VGND VPWR VPWR _4116_/X sky130_fd_sc_hd__a211o_2
X_5096_ _6435_/Q _5096_/B VGND VGND VPWR VPWR _5279_/B sky130_fd_sc_hd__xnor2_2
XFILLER_56_336 VGND VGND VPWR VPWR sky130_fd_sc_hd__decap_3
XFILLER_42_1371 VGND VGND VPWR VPWR sky130_fd_sc_hd__fill_1
XFILLER_42_1382 VGND VGND VPWR VPWR sky130_fd_sc_hd__decap_3
X_4047_ _4095_/B _4572_/B VGND VGND VPWR VPWR _4047_/Y sky130_fd_sc_hd__nor2_2
XFILLER_77_1401 VGND VGND VPWR VPWR sky130_fd_sc_hd__decap_3
XFILLER_37_561 VGND VGND VPWR VPWR sky130_fd_sc_hd__fill_2
XFILLER_77_1434 VGND VGND VPWR VPWR sky130_fd_sc_hd__decap_3
XFILLER_25_723 VGND VGND VPWR VPWR sky130_fd_sc_hd__decap_3
XFILLER_52_531 VGND VGND VPWR VPWR sky130_fd_sc_hd__fill_1
XFILLER_38_1418 VGND VGND VPWR VPWR sky130_fd_sc_hd__decap_3
XFILLER_38_1429 VGND VGND VPWR VPWR sky130_fd_sc_hd__decap_3
XFILLER_40_704 VGND VGND VPWR VPWR sky130_fd_sc_hd__fill_1
X_5998_ _5998_/A0 _7002_/Q _5998_/S VGND VGND VPWR VPWR _5998_/X sky130_fd_sc_hd__mux2_1
XTAP_TAPCELL_ROW_43_1310 VGND VPWR sky130_fd_sc_hd__tapvpwrvgnd_1
XFILLER_75_1180 VGND VGND VPWR VPWR sky130_fd_sc_hd__decap_3
XTAP_TAPCELL_ROW_43_1321 VGND VPWR sky130_fd_sc_hd__tapvpwrvgnd_1
XFILLER_12_439 VGND VGND VPWR VPWR sky130_fd_sc_hd__decap_3
XFILLER_24_299 VGND VGND VPWR VPWR sky130_fd_sc_hd__decap_3
XFILLER_40_748 VGND VGND VPWR VPWR sky130_fd_sc_hd__decap_3
X_4949_ _6688_/Q _3054_/Y _5216_/A VGND VGND VPWR VPWR _4949_/X sky130_fd_sc_hd__mux2_1
XFILLER_21_962 VGND VGND VPWR VPWR sky130_fd_sc_hd__decap_3
XFILLER_20_472 VGND VGND VPWR VPWR sky130_fd_sc_hd__decap_3
X_6619_ _7035_/CLK _6619_/D load_slew829/X VGND VGND VPWR VPWR _6619_/Q sky130_fd_sc_hd__dfrtp_2
XFILLER_14_1462 VGND VGND VPWR VPWR sky130_fd_sc_hd__decap_3
XFILLER_10_1315 VGND VGND VPWR VPWR sky130_fd_sc_hd__fill_1
XFILLER_10_1326 VGND VGND VPWR VPWR sky130_fd_sc_hd__decap_3
XFILLER_4_616 VGND VGND VPWR VPWR sky130_fd_sc_hd__decap_3
XFILLER_10_1359 VGND VGND VPWR VPWR sky130_fd_sc_hd__decap_3
XFILLER_3_159 VGND VGND VPWR VPWR sky130_fd_sc_hd__decap_3
XFILLER_0_800 VGND VGND VPWR VPWR sky130_fd_sc_hd__decap_3
XTAP_TAPCELL_ROW_37_1158 VGND VPWR sky130_fd_sc_hd__tapvpwrvgnd_1
XFILLER_0_822 VGND VGND VPWR VPWR sky130_fd_sc_hd__decap_3
XTAP_TAPCELL_ROW_37_1169 VGND VPWR sky130_fd_sc_hd__tapvpwrvgnd_1
XFILLER_47_1260 VGND VGND VPWR VPWR sky130_fd_sc_hd__decap_3
XFILLER_0_844 VGND VGND VPWR VPWR sky130_fd_sc_hd__decap_3
XFILLER_43_1146 VGND VGND VPWR VPWR sky130_fd_sc_hd__decap_3
XFILLER_47_303 VGND VGND VPWR VPWR sky130_fd_sc_hd__decap_3
XFILLER_74_111 VGND VGND VPWR VPWR sky130_fd_sc_hd__decap_3
XFILLER_21_1422 VGND VGND VPWR VPWR sky130_fd_sc_hd__decap_3
XFILLER_75_667 VGND VGND VPWR VPWR sky130_fd_sc_hd__decap_3
XFILLER_74_21 VGND VGND VPWR VPWR sky130_fd_sc_hd__decap_3
XFILLER_74_32 VGND VGND VPWR VPWR sky130_fd_sc_hd__decap_3
XFILLER_28_550 VGND VGND VPWR VPWR sky130_fd_sc_hd__fill_2
XFILLER_47_369 VGND VGND VPWR VPWR sky130_fd_sc_hd__decap_3
XFILLER_16_701 VGND VGND VPWR VPWR sky130_fd_sc_hd__decap_3
XFILLER_21_1455 VGND VGND VPWR VPWR sky130_fd_sc_hd__fill_1
XFILLER_21_1466 VGND VGND VPWR VPWR sky130_fd_sc_hd__decap_3
XFILLER_74_65 VGND VGND VPWR VPWR sky130_fd_sc_hd__decap_3
XFILLER_15_222 VGND VGND VPWR VPWR sky130_fd_sc_hd__fill_2
XFILLER_43_531 VGND VGND VPWR VPWR sky130_fd_sc_hd__decap_3
XFILLER_71_873 VGND VGND VPWR VPWR sky130_fd_sc_hd__fill_2
XFILLER_16_778 VGND VGND VPWR VPWR sky130_fd_sc_hd__decap_3
XFILLER_43_575 VGND VGND VPWR VPWR sky130_fd_sc_hd__decap_3
XFILLER_31_726 VGND VGND VPWR VPWR sky130_fd_sc_hd__fill_2
XFILLER_30_203 VGND VGND VPWR VPWR sky130_fd_sc_hd__fill_1
XFILLER_19_1340 VGND VGND VPWR VPWR sky130_fd_sc_hd__decap_3
XFILLER_19_1351 VGND VGND VPWR VPWR sky130_fd_sc_hd__decap_3
XFILLER_12_940 VGND VGND VPWR VPWR sky130_fd_sc_hd__decap_3
XFILLER_54_1253 VGND VGND VPWR VPWR sky130_fd_sc_hd__decap_3
XFILLER_54_1264 VGND VGND VPWR VPWR sky130_fd_sc_hd__decap_3
XFILLER_19_1384 VGND VGND VPWR VPWR sky130_fd_sc_hd__decap_3
XFILLER_30_269 VGND VGND VPWR VPWR sky130_fd_sc_hd__decap_3
XFILLER_12_984 VGND VGND VPWR VPWR sky130_fd_sc_hd__fill_2
XFILLER_15_1248 VGND VGND VPWR VPWR sky130_fd_sc_hd__decap_3
XFILLER_54_1297 VGND VGND VPWR VPWR sky130_fd_sc_hd__decap_3
XFILLER_8_944 VGND VGND VPWR VPWR sky130_fd_sc_hd__fill_2
XFILLER_11_483 VGND VGND VPWR VPWR sky130_fd_sc_hd__decap_3
XFILLER_7_476 VGND VGND VPWR VPWR sky130_fd_sc_hd__decap_3
XFILLER_3_682 VGND VGND VPWR VPWR sky130_fd_sc_hd__decap_3
XFILLER_26_1300 VGND VGND VPWR VPWR sky130_fd_sc_hd__decap_3
X_3280_ _6219_/Q _6371_/Q VGND VGND VPWR VPWR _3280_/X sky130_fd_sc_hd__xor2_2
XFILLER_65_1360 VGND VGND VPWR VPWR sky130_fd_sc_hd__decap_3
Xload_slew335 _4887_/B VGND VGND VPWR VPWR _4786_/B sky130_fd_sc_hd__buf_2
XFILLER_2_192 VGND VGND VPWR VPWR sky130_fd_sc_hd__decap_3
XFILLER_26_1344 VGND VGND VPWR VPWR sky130_fd_sc_hd__decap_3
XFILLER_65_1393 VGND VGND VPWR VPWR sky130_fd_sc_hd__decap_3
XFILLER_6_1427 VGND VGND VPWR VPWR sky130_fd_sc_hd__fill_1
XFILLER_6_1438 VGND VGND VPWR VPWR sky130_fd_sc_hd__decap_3
XFILLER_66_612 VGND VGND VPWR VPWR sky130_fd_sc_hd__fill_1
XFILLER_61_1257 VGND VGND VPWR VPWR sky130_fd_sc_hd__decap_3
XFILLER_26_1388 VGND VGND VPWR VPWR sky130_fd_sc_hd__decap_3
XFILLER_17_3 VGND VGND VPWR VPWR sky130_fd_sc_hd__fill_1
XFILLER_66_645 VGND VGND VPWR VPWR sky130_fd_sc_hd__fill_2
XFILLER_65_155 VGND VGND VPWR VPWR sky130_fd_sc_hd__decap_3
X_6970_ _6970_/CLK _6970_/D fanout672/X VGND VGND VPWR VPWR _6970_/Q sky130_fd_sc_hd__dfrtp_2
XFILLER_19_561 VGND VGND VPWR VPWR sky130_fd_sc_hd__decap_3
XFILLER_4_1173 VGND VGND VPWR VPWR sky130_fd_sc_hd__decap_3
XFILLER_47_881 VGND VGND VPWR VPWR sky130_fd_sc_hd__decap_3
XFILLER_0_1015 VGND VGND VPWR VPWR sky130_fd_sc_hd__decap_3
X_5921_ _5921_/A0 _5797_/C _5923_/S VGND VGND VPWR VPWR _6927_/D sky130_fd_sc_hd__mux2_1
XFILLER_80_125 VGND VGND VPWR VPWR sky130_fd_sc_hd__fill_2
XFILLER_0_1037 VGND VGND VPWR VPWR sky130_fd_sc_hd__decap_3
XFILLER_80_136 VGND VGND VPWR VPWR sky130_fd_sc_hd__fill_1
XFILLER_62_851 VGND VGND VPWR VPWR sky130_fd_sc_hd__decap_3
XFILLER_80_169 VGND VGND VPWR VPWR sky130_fd_sc_hd__fill_1
XFILLER_59_1175 VGND VGND VPWR VPWR sky130_fd_sc_hd__fill_1
X_5852_ _5852_/A0 _5899_/A0 _5856_/S VGND VGND VPWR VPWR _6867_/D sky130_fd_sc_hd__mux2_1
XFILLER_59_1186 VGND VGND VPWR VPWR sky130_fd_sc_hd__decap_3
XFILLER_21_203 VGND VGND VPWR VPWR sky130_fd_sc_hd__decap_3
XFILLER_72_1320 VGND VGND VPWR VPWR sky130_fd_sc_hd__decap_3
X_4803_ _4859_/C1 _4800_/X _4802_/Y _4683_/A VGND VGND VPWR VPWR _4803_/X sky130_fd_sc_hd__o211a_2
XFILLER_37_1440 VGND VGND VPWR VPWR sky130_fd_sc_hd__decap_3
X_5783_ _5786_/A _6069_/S _7073_/Q _5868_/B VGND VGND VPWR VPWR _5783_/X sky130_fd_sc_hd__or4bb_2
XFILLER_72_1353 VGND VGND VPWR VPWR sky130_fd_sc_hd__decap_3
XFILLER_33_1304 VGND VGND VPWR VPWR sky130_fd_sc_hd__decap_3
X_4734_ _3485_/B _4731_/X _4732_/Y _4733_/X _4734_/C1 VGND VGND VPWR VPWR _4734_/X
+ sky130_fd_sc_hd__o221a_2
XFILLER_33_1337 VGND VGND VPWR VPWR sky130_fd_sc_hd__decap_3
XFILLER_72_1397 VGND VGND VPWR VPWR sky130_fd_sc_hd__decap_3
XFILLER_33_1348 VGND VGND VPWR VPWR sky130_fd_sc_hd__decap_3
XFILLER_30_781 VGND VGND VPWR VPWR sky130_fd_sc_hd__decap_3
X_4665_ _4842_/A _4665_/B _4842_/C VGND VGND VPWR VPWR _4665_/X sky130_fd_sc_hd__or3_2
X_6404_ _7063_/CLK _6404_/D fanout774/X VGND VGND VPWR VPWR _6404_/Q sky130_fd_sc_hd__dfrtp_2
X_3616_ _3615_/A _3613_/Y _3614_/X _3673_/A VGND VGND VPWR VPWR _3617_/B sky130_fd_sc_hd__a31o_2
Xhold900 _6125_/Q VGND VGND VPWR VPWR hold900/X sky130_fd_sc_hd__dlygate4sd3_1
Xhold911 _6181_/Q VGND VGND VPWR VPWR hold911/X sky130_fd_sc_hd__dlygate4sd3_1
XTAP_TAPCELL_ROW_77_2195 VGND VPWR sky130_fd_sc_hd__tapvpwrvgnd_1
Xhold922 _6044_/X VGND VGND VPWR VPWR _7048_/D sky130_fd_sc_hd__dlygate4sd3_1
X_4596_ _4717_/A _4413_/B _4595_/Y _4771_/C1 VGND VGND VPWR VPWR _4597_/C sky130_fd_sc_hd__o211ai_2
Xhold933 _7017_/Q VGND VGND VPWR VPWR hold933/X sky130_fd_sc_hd__dlygate4sd3_1
Xhold944 _6724_/Q VGND VGND VPWR VPWR hold944/X sky130_fd_sc_hd__dlygate4sd3_1
X_6335_ _6993_/CLK _6335_/D load_slew707/X VGND VGND VPWR VPWR _6335_/Q sky130_fd_sc_hd__dfrtp_2
X_3547_ _6243_/Q _3631_/A2 _5603_/A1 _6331_/Q _3546_/X VGND VGND VPWR VPWR _3547_/X
+ sky130_fd_sc_hd__a221o_2
Xhold955 _6116_/Q VGND VGND VPWR VPWR hold955/X sky130_fd_sc_hd__dlygate4sd3_1
Xhold966 _6212_/Q VGND VGND VPWR VPWR hold966/X sky130_fd_sc_hd__dlygate4sd3_1
Xhold977 _6712_/Q VGND VGND VPWR VPWR hold977/X sky130_fd_sc_hd__dlygate4sd3_1
Xhold988 _5952_/X VGND VGND VPWR VPWR _6956_/D sky130_fd_sc_hd__dlygate4sd3_1
XFILLER_66_1168 VGND VGND VPWR VPWR sky130_fd_sc_hd__decap_3
X_3478_ _6246_/Q _6470_/Q VGND VGND VPWR VPWR _3478_/X sky130_fd_sc_hd__xor2_2
Xhold999 _6193_/Q VGND VGND VPWR VPWR hold999/X sky130_fd_sc_hd__dlygate4sd3_1
X_6266_ _7015_/CLK _6266_/D load_slew801/X VGND VGND VPWR VPWR _6266_/Q sky130_fd_sc_hd__dfrtp_2
XFILLER_44_1400 VGND VGND VPWR VPWR sky130_fd_sc_hd__decap_3
X_5217_ _6752_/Q _5216_/A _5307_/S _5216_/Y VGND VGND VPWR VPWR _5217_/X sky130_fd_sc_hd__o211a_2
XFILLER_44_1444 VGND VGND VPWR VPWR sky130_fd_sc_hd__decap_3
X_6197_ _6925_/CLK _6197_/D load_slew658/X VGND VGND VPWR VPWR _6197_/Q sky130_fd_sc_hd__dfrtp_2
XFILLER_57_601 VGND VGND VPWR VPWR sky130_fd_sc_hd__decap_3
XTAP_TAPCELL_ROW_32_1022 VGND VPWR sky130_fd_sc_hd__tapvpwrvgnd_1
XFILLER_29_314 VGND VGND VPWR VPWR sky130_fd_sc_hd__decap_3
XTAP_TAPCELL_ROW_32_1033 VGND VPWR sky130_fd_sc_hd__tapvpwrvgnd_1
XTAP_TAPCELL_ROW_32_1044 VGND VPWR sky130_fd_sc_hd__tapvpwrvgnd_1
X_5148_ _6721_/Q _5219_/A VGND VGND VPWR VPWR _5148_/X sky130_fd_sc_hd__or2_2
XFILLER_28_58 VGND VGND VPWR VPWR sky130_fd_sc_hd__decap_3
X_5079_ _6465_/Q _5079_/B VGND VGND VPWR VPWR _5080_/B sky130_fd_sc_hd__xnor2_2
XFILLER_44_306 VGND VGND VPWR VPWR sky130_fd_sc_hd__fill_2
XFILLER_38_881 VGND VGND VPWR VPWR sky130_fd_sc_hd__decap_3
XFILLER_72_648 VGND VGND VPWR VPWR sky130_fd_sc_hd__fill_1
XFILLER_77_1231 VGND VGND VPWR VPWR sky130_fd_sc_hd__fill_1
XFILLER_71_125 VGND VGND VPWR VPWR sky130_fd_sc_hd__decap_3
XFILLER_77_1242 VGND VGND VPWR VPWR sky130_fd_sc_hd__decap_3
XFILLER_37_391 VGND VGND VPWR VPWR sky130_fd_sc_hd__fill_1
XFILLER_73_1106 VGND VGND VPWR VPWR sky130_fd_sc_hd__fill_1
XFILLER_77_1275 VGND VGND VPWR VPWR sky130_fd_sc_hd__decap_3
XFILLER_71_169 VGND VGND VPWR VPWR sky130_fd_sc_hd__decap_3
XFILLER_25_564 VGND VGND VPWR VPWR sky130_fd_sc_hd__decap_3
XFILLER_44_57 VGND VGND VPWR VPWR sky130_fd_sc_hd__decap_3
XFILLER_13_726 VGND VGND VPWR VPWR sky130_fd_sc_hd__fill_2
XFILLER_38_1248 VGND VGND VPWR VPWR sky130_fd_sc_hd__decap_3
XFILLER_73_1139 VGND VGND VPWR VPWR sky130_fd_sc_hd__decap_3
XFILLER_12_214 VGND VGND VPWR VPWR sky130_fd_sc_hd__decap_3
XFILLER_9_719 VGND VGND VPWR VPWR sky130_fd_sc_hd__decap_3
XFILLER_51_1404 VGND VGND VPWR VPWR sky130_fd_sc_hd__decap_3
XFILLER_12_269 VGND VGND VPWR VPWR sky130_fd_sc_hd__decap_3
XFILLER_40_589 VGND VGND VPWR VPWR sky130_fd_sc_hd__fill_2
XFILLER_51_1437 VGND VGND VPWR VPWR sky130_fd_sc_hd__decap_3
XTAP_TAPCELL_ROW_23_787 VGND VPWR sky130_fd_sc_hd__tapvpwrvgnd_1
XTAP_TAPCELL_ROW_23_798 VGND VPWR sky130_fd_sc_hd__tapvpwrvgnd_1
XFILLER_5_903 VGND VGND VPWR VPWR sky130_fd_sc_hd__decap_3
XFILLER_20_280 VGND VGND VPWR VPWR sky130_fd_sc_hd__decap_3
XTAP_TAPCELL_ROW_10_448 VGND VPWR sky130_fd_sc_hd__tapvpwrvgnd_1
XTAP_TAPCELL_ROW_10_459 VGND VPWR sky130_fd_sc_hd__tapvpwrvgnd_1
XFILLER_14_1270 VGND VGND VPWR VPWR sky130_fd_sc_hd__decap_3
XFILLER_5_18 VGND VGND VPWR VPWR sky130_fd_sc_hd__decap_3
XTAP_TAPCELL_ROW_39_1209 VGND VPWR sky130_fd_sc_hd__tapvpwrvgnd_1
XFILLER_4_424 VGND VGND VPWR VPWR sky130_fd_sc_hd__decap_3
XFILLER_5_969 VGND VGND VPWR VPWR sky130_fd_sc_hd__decap_3
XFILLER_4_446 VGND VGND VPWR VPWR sky130_fd_sc_hd__decap_3
XFILLER_49_1322 VGND VGND VPWR VPWR sky130_fd_sc_hd__decap_3
XFILLER_69_21 VGND VGND VPWR VPWR sky130_fd_sc_hd__decap_3
XFILLER_10_1167 VGND VGND VPWR VPWR sky130_fd_sc_hd__decap_3
XFILLER_49_1366 VGND VGND VPWR VPWR sky130_fd_sc_hd__decap_3
XFILLER_69_54 VGND VGND VPWR VPWR sky130_fd_sc_hd__fill_2
XFILLER_79_225 VGND VGND VPWR VPWR sky130_fd_sc_hd__decap_3
XFILLER_49_1399 VGND VGND VPWR VPWR sky130_fd_sc_hd__fill_1
XFILLER_69_87 VGND VGND VPWR VPWR sky130_fd_sc_hd__fill_1
XFILLER_0_663 VGND VGND VPWR VPWR sky130_fd_sc_hd__decap_3
XFILLER_76_921 VGND VGND VPWR VPWR sky130_fd_sc_hd__decap_3
XFILLER_0_685 VGND VGND VPWR VPWR sky130_fd_sc_hd__decap_3
XFILLER_75_420 VGND VGND VPWR VPWR sky130_fd_sc_hd__fill_2
XFILLER_48_645 VGND VGND VPWR VPWR sky130_fd_sc_hd__fill_1
XFILLER_5_1460 VGND VGND VPWR VPWR sky130_fd_sc_hd__decap_3
XFILLER_47_155 VGND VGND VPWR VPWR sky130_fd_sc_hd__decap_3
XFILLER_48_678 VGND VGND VPWR VPWR sky130_fd_sc_hd__decap_3
XFILLER_75_475 VGND VGND VPWR VPWR sky130_fd_sc_hd__decap_3
XFILLER_1_1313 VGND VGND VPWR VPWR sky130_fd_sc_hd__decap_3
XFILLER_21_1263 VGND VGND VPWR VPWR sky130_fd_sc_hd__decap_3
XFILLER_29_892 VGND VGND VPWR VPWR sky130_fd_sc_hd__decap_3
XFILLER_1_1357 VGND VGND VPWR VPWR sky130_fd_sc_hd__decap_3
XFILLER_44_862 VGND VGND VPWR VPWR sky130_fd_sc_hd__decap_3
XFILLER_56_1315 VGND VGND VPWR VPWR sky130_fd_sc_hd__fill_1
XFILLER_50_309 VGND VGND VPWR VPWR sky130_fd_sc_hd__fill_1
XFILLER_56_1326 VGND VGND VPWR VPWR sky130_fd_sc_hd__decap_3
XFILLER_56_1359 VGND VGND VPWR VPWR sky130_fd_sc_hd__decap_3
XFILLER_31_556 VGND VGND VPWR VPWR sky130_fd_sc_hd__decap_3
XFILLER_15_1034 VGND VGND VPWR VPWR sky130_fd_sc_hd__decap_3
XFILLER_12_781 VGND VGND VPWR VPWR sky130_fd_sc_hd__fill_1
XFILLER_8_796 VGND VGND VPWR VPWR sky130_fd_sc_hd__decap_3
X_4450_ _6852_/Q _4805_/A2 _4862_/B1 _4449_/X VGND VGND VPWR VPWR _4450_/X sky130_fd_sc_hd__a211o_2
XFILLER_7_284 VGND VGND VPWR VPWR sky130_fd_sc_hd__decap_3
X_3401_ _3401_/A0 _3400_/X _3401_/S VGND VGND VPWR VPWR _6174_/D sky130_fd_sc_hd__mux2_1
XFILLER_67_1422 VGND VGND VPWR VPWR sky130_fd_sc_hd__decap_3
X_4381_ _4405_/B _4133_/B _4380_/Y _4381_/C1 VGND VGND VPWR VPWR _4381_/Y sky130_fd_sc_hd__o211ai_2
XFILLER_28_1406 VGND VGND VPWR VPWR sky130_fd_sc_hd__decap_3
XFILLER_67_1455 VGND VGND VPWR VPWR sky130_fd_sc_hd__fill_1
X_3332_ _6293_/Q _6397_/Q VGND VGND VPWR VPWR _3332_/X sky130_fd_sc_hd__xor2_2
X_6120_ _7036_/CLK _6120_/D load_slew840/X VGND VGND VPWR VPWR _6120_/Q sky130_fd_sc_hd__dfrtp_2
XFILLER_67_1466 VGND VGND VPWR VPWR sky130_fd_sc_hd__decap_3
XTAP_TAPCELL_ROW_72_2070 VGND VPWR sky130_fd_sc_hd__tapvpwrvgnd_1
Xfanout709 fanout713/X VGND VGND VPWR VPWR fanout709/X sky130_fd_sc_hd__clkdlybuf4s25_1
XFILLER_63_1319 VGND VGND VPWR VPWR sky130_fd_sc_hd__decap_3
Xload_slew110 _5293_/A2 VGND VGND VPWR VPWR _5290_/A2 sky130_fd_sc_hd__buf_4
XTAP_TAPCELL_ROW_72_2081 VGND VPWR sky130_fd_sc_hd__tapvpwrvgnd_1
X_6051_ _6204_/Q _6051_/A1 _6051_/S VGND VGND VPWR VPWR _6051_/X sky130_fd_sc_hd__mux2_1
X_3263_ hold987/X _3262_/X _3455_/S VGND VGND VPWR VPWR _6105_/D sky130_fd_sc_hd__mux2_1
XFILLER_79_781 VGND VGND VPWR VPWR sky130_fd_sc_hd__decap_3
XFILLER_67_921 VGND VGND VPWR VPWR sky130_fd_sc_hd__decap_3
X_5002_ _6390_/Q _5240_/B VGND VGND VPWR VPWR _5002_/X sky130_fd_sc_hd__or2_2
XFILLER_6_1235 VGND VGND VPWR VPWR sky130_fd_sc_hd__decap_3
XFILLER_22_1005 VGND VGND VPWR VPWR sky130_fd_sc_hd__decap_3
XFILLER_78_280 VGND VGND VPWR VPWR sky130_fd_sc_hd__fill_1
XFILLER_39_645 VGND VGND VPWR VPWR sky130_fd_sc_hd__decap_3
X_3194_ _3217_/A _3194_/B _3194_/C VGND VGND VPWR VPWR _3194_/X sky130_fd_sc_hd__and3_2
XFILLER_6_1279 VGND VGND VPWR VPWR sky130_fd_sc_hd__decap_3
XFILLER_38_144 VGND VGND VPWR VPWR sky130_fd_sc_hd__decap_3
XFILLER_61_1087 VGND VGND VPWR VPWR sky130_fd_sc_hd__decap_3
XFILLER_67_987 VGND VGND VPWR VPWR sky130_fd_sc_hd__decap_3
XFILLER_66_475 VGND VGND VPWR VPWR sky130_fd_sc_hd__fill_1
XFILLER_66_486 VGND VGND VPWR VPWR sky130_fd_sc_hd__decap_3
XFILLER_53_125 VGND VGND VPWR VPWR sky130_fd_sc_hd__decap_3
XFILLER_54_648 VGND VGND VPWR VPWR sky130_fd_sc_hd__fill_2
X_6953_ _7025_/CLK _6953_/D wire764/X VGND VGND VPWR VPWR _6953_/Q sky130_fd_sc_hd__dfrtp_2
XFILLER_74_1415 VGND VGND VPWR VPWR sky130_fd_sc_hd__decap_3
X_5904_ _5904_/A0 _5904_/A1 _5905_/S VGND VGND VPWR VPWR _6912_/D sky130_fd_sc_hd__mux2_1
XFILLER_53_169 VGND VGND VPWR VPWR sky130_fd_sc_hd__fill_2
X_6884_ _7022_/CLK _6884_/D load_slew748/X VGND VGND VPWR VPWR _6884_/Q sky130_fd_sc_hd__dfrtp_2
XFILLER_50_821 VGND VGND VPWR VPWR sky130_fd_sc_hd__decap_3
XFILLER_74_1459 VGND VGND VPWR VPWR sky130_fd_sc_hd__decap_3
X_5835_ _5909_/A0 _5835_/A1 _5840_/S VGND VGND VPWR VPWR _6852_/D sky130_fd_sc_hd__mux2_1
XFILLER_61_180 VGND VGND VPWR VPWR sky130_fd_sc_hd__decap_3
XFILLER_14_38 VGND VGND VPWR VPWR sky130_fd_sc_hd__decap_3
XFILLER_22_578 VGND VGND VPWR VPWR sky130_fd_sc_hd__decap_3
XFILLER_72_1161 VGND VGND VPWR VPWR sky130_fd_sc_hd__decap_3
XFILLER_37_1281 VGND VGND VPWR VPWR sky130_fd_sc_hd__decap_3
X_5766_ _5932_/A0 _5766_/A1 _5766_/S VGND VGND VPWR VPWR _6809_/D sky130_fd_sc_hd__mux2_1
XFILLER_37_1292 VGND VGND VPWR VPWR sky130_fd_sc_hd__decap_3
XTAP_TAPCELL_ROW_20_713 VGND VPWR sky130_fd_sc_hd__tapvpwrvgnd_1
XTAP_TAPCELL_ROW_79_2246 VGND VPWR sky130_fd_sc_hd__tapvpwrvgnd_1
XFILLER_72_1194 VGND VGND VPWR VPWR sky130_fd_sc_hd__decap_3
XTAP_TAPCELL_ROW_20_724 VGND VPWR sky130_fd_sc_hd__tapvpwrvgnd_1
XTAP_TAPCELL_ROW_79_2257 VGND VPWR sky130_fd_sc_hd__tapvpwrvgnd_1
X_4717_ _4717_/A _4894_/B VGND VGND VPWR VPWR _4717_/Y sky130_fd_sc_hd__nor2_2
X_5697_ _5697_/A0 _5826_/A0 _5702_/S VGND VGND VPWR VPWR _6748_/D sky130_fd_sc_hd__mux2_1
XFILLER_11_1410 VGND VGND VPWR VPWR sky130_fd_sc_hd__decap_3
XFILLER_33_1189 VGND VGND VPWR VPWR sky130_fd_sc_hd__decap_3
XFILLER_68_1208 VGND VGND VPWR VPWR sky130_fd_sc_hd__decap_3
X_4648_ _6261_/Q _4854_/A2 _3380_/X _4882_/B2 VGND VGND VPWR VPWR _4648_/X sky130_fd_sc_hd__a22o_2
XFILLER_11_1443 VGND VGND VPWR VPWR sky130_fd_sc_hd__decap_3
XFILLER_2_917 VGND VGND VPWR VPWR sky130_fd_sc_hd__decap_3
XFILLER_2_928 VGND VGND VPWR VPWR sky130_fd_sc_hd__decap_3
X_4579_ _4586_/A _5589_/A3 _4562_/C _4586_/D _4578_/X VGND VGND VPWR VPWR _4582_/B
+ sky130_fd_sc_hd__a41o_2
XFILLER_1_405 VGND VGND VPWR VPWR sky130_fd_sc_hd__decap_3
X_6318_ _7024_/CLK _6318_/D fanout699/A VGND VGND VPWR VPWR _6318_/Q sky130_fd_sc_hd__dfrtp_2
XFILLER_1_449 VGND VGND VPWR VPWR sky130_fd_sc_hd__decap_3
X_6249_ _7039_/CLK _6249_/D load_slew822/X VGND VGND VPWR VPWR _6249_/Q sky130_fd_sc_hd__dfrtp_2
XFILLER_58_921 VGND VGND VPWR VPWR sky130_fd_sc_hd__decap_3
XFILLER_44_1252 VGND VGND VPWR VPWR sky130_fd_sc_hd__decap_3
XFILLER_29_122 VGND VGND VPWR VPWR sky130_fd_sc_hd__fill_1
XFILLER_44_1285 VGND VGND VPWR VPWR sky130_fd_sc_hd__decap_3
Xhold1430 _6544_/Q VGND VGND VPWR VPWR _5432_/A1 sky130_fd_sc_hd__dlygate4sd3_1
XFILLER_79_1304 VGND VGND VPWR VPWR sky130_fd_sc_hd__decap_3
Xhold1441 _6754_/Q VGND VGND VPWR VPWR _5705_/A1 sky130_fd_sc_hd__dlygate4sd3_1
Xhold1452 _6745_/Q VGND VGND VPWR VPWR _5693_/A0 sky130_fd_sc_hd__dlygate4sd3_1
XFILLER_55_12 VGND VGND VPWR VPWR sky130_fd_sc_hd__decap_3
Xhold1463 _6905_/Q VGND VGND VPWR VPWR _5896_/A1 sky130_fd_sc_hd__dlygate4sd3_1
Xhold1474 _6572_/Q VGND VGND VPWR VPWR _5460_/A1 sky130_fd_sc_hd__dlygate4sd3_1
XFILLER_79_1337 VGND VGND VPWR VPWR sky130_fd_sc_hd__decap_3
XTAP_TAPCELL_ROW_4_298 VGND VPWR sky130_fd_sc_hd__tapvpwrvgnd_1
XFILLER_45_626 VGND VGND VPWR VPWR sky130_fd_sc_hd__decap_3
XFILLER_79_1348 VGND VGND VPWR VPWR sky130_fd_sc_hd__decap_3
XFILLER_17_328 VGND VGND VPWR VPWR sky130_fd_sc_hd__decap_3
Xhold1485 _6524_/Q VGND VGND VPWR VPWR _5412_/A1 sky130_fd_sc_hd__dlygate4sd3_1
XFILLER_55_45 VGND VGND VPWR VPWR sky130_fd_sc_hd__decap_3
Xhold1496 _6619_/Q VGND VGND VPWR VPWR _5536_/B1 sky130_fd_sc_hd__dlygate4sd3_1
XFILLER_29_199 VGND VGND VPWR VPWR sky130_fd_sc_hd__decap_3
XTAP_TAPCELL_ROW_68_1961 VGND VPWR sky130_fd_sc_hd__tapvpwrvgnd_1
XFILLER_72_467 VGND VGND VPWR VPWR sky130_fd_sc_hd__fill_2
XTAP_TAPCELL_ROW_68_1972 VGND VPWR sky130_fd_sc_hd__tapvpwrvgnd_1
XFILLER_38_1001 VGND VGND VPWR VPWR sky130_fd_sc_hd__fill_2
XFILLER_44_169 VGND VGND VPWR VPWR sky130_fd_sc_hd__decap_3
XFILLER_25_361 VGND VGND VPWR VPWR sky130_fd_sc_hd__decap_3
XFILLER_38_1023 VGND VGND VPWR VPWR sky130_fd_sc_hd__fill_2
XFILLER_41_810 VGND VGND VPWR VPWR sky130_fd_sc_hd__decap_3
XFILLER_77_1083 VGND VGND VPWR VPWR sky130_fd_sc_hd__decap_3
XFILLER_38_1034 VGND VGND VPWR VPWR sky130_fd_sc_hd__fill_2
XFILLER_13_523 VGND VGND VPWR VPWR sky130_fd_sc_hd__fill_1
XTAP_TAPCELL_ROW_64_1858 VGND VPWR sky130_fd_sc_hd__tapvpwrvgnd_1
XTAP_TAPCELL_ROW_64_1869 VGND VPWR sky130_fd_sc_hd__tapvpwrvgnd_1
XFILLER_71_33 VGND VGND VPWR VPWR sky130_fd_sc_hd__decap_3
XFILLER_9_505 VGND VGND VPWR VPWR sky130_fd_sc_hd__decap_3
XFILLER_13_567 VGND VGND VPWR VPWR sky130_fd_sc_hd__decap_3
XFILLER_40_353 VGND VGND VPWR VPWR sky130_fd_sc_hd__decap_3
XFILLER_41_876 VGND VGND VPWR VPWR sky130_fd_sc_hd__fill_2
XFILLER_13_589 VGND VGND VPWR VPWR sky130_fd_sc_hd__fill_1
XFILLER_16_1332 VGND VGND VPWR VPWR sky130_fd_sc_hd__decap_3
XFILLER_55_1381 VGND VGND VPWR VPWR sky130_fd_sc_hd__decap_3
XFILLER_16_1365 VGND VGND VPWR VPWR sky130_fd_sc_hd__decap_3
XFILLER_51_1245 VGND VGND VPWR VPWR sky130_fd_sc_hd__decap_3
XFILLER_16_1376 VGND VGND VPWR VPWR sky130_fd_sc_hd__decap_3
XFILLER_12_1229 VGND VGND VPWR VPWR sky130_fd_sc_hd__decap_3
XFILLER_51_1278 VGND VGND VPWR VPWR sky130_fd_sc_hd__decap_3
XFILLER_5_711 VGND VGND VPWR VPWR sky130_fd_sc_hd__decap_3
XFILLER_51_1289 VGND VGND VPWR VPWR sky130_fd_sc_hd__decap_3
XFILLER_5_788 VGND VGND VPWR VPWR sky130_fd_sc_hd__fill_1
XFILLER_49_1152 VGND VGND VPWR VPWR sky130_fd_sc_hd__decap_3
XFILLER_45_1038 VGND VGND VPWR VPWR sky130_fd_sc_hd__fill_1
XFILLER_49_910 VGND VGND VPWR VPWR sky130_fd_sc_hd__decap_3
XFILLER_1_983 VGND VGND VPWR VPWR sky130_fd_sc_hd__decap_3
XFILLER_62_1341 VGND VGND VPWR VPWR sky130_fd_sc_hd__decap_3
XFILLER_67_239 VGND VGND VPWR VPWR sky130_fd_sc_hd__decap_3
XFILLER_23_1325 VGND VGND VPWR VPWR sky130_fd_sc_hd__decap_3
XFILLER_62_1385 VGND VGND VPWR VPWR sky130_fd_sc_hd__decap_3
XFILLER_76_751 VGND VGND VPWR VPWR sky130_fd_sc_hd__decap_3
XFILLER_3_1419 VGND VGND VPWR VPWR sky130_fd_sc_hd__decap_3
XFILLER_76_784 VGND VGND VPWR VPWR sky130_fd_sc_hd__decap_3
XFILLER_23_1369 VGND VGND VPWR VPWR sky130_fd_sc_hd__decap_3
XFILLER_1_1110 VGND VGND VPWR VPWR sky130_fd_sc_hd__decap_3
XFILLER_1_1121 VGND VGND VPWR VPWR sky130_fd_sc_hd__decap_3
XFILLER_36_659 VGND VGND VPWR VPWR sky130_fd_sc_hd__decap_3
XFILLER_1_1154 VGND VGND VPWR VPWR sky130_fd_sc_hd__decap_3
XFILLER_17_873 VGND VGND VPWR VPWR sky130_fd_sc_hd__decap_3
XFILLER_35_169 VGND VGND VPWR VPWR sky130_fd_sc_hd__decap_3
X_3950_ _4230_/B _4258_/B VGND VGND VPWR VPWR _4349_/A sky130_fd_sc_hd__xnor2_2
XFILLER_1_1198 VGND VGND VPWR VPWR sky130_fd_sc_hd__decap_3
XFILLER_56_1134 VGND VGND VPWR VPWR sky130_fd_sc_hd__decap_3
XTAP_TAPCELL_ROW_27_890 VGND VPWR sky130_fd_sc_hd__tapvpwrvgnd_1
X_3881_ _3591_/Y _3881_/B VGND VGND VPWR VPWR _3883_/A sky130_fd_sc_hd__nand2b_2
XFILLER_31_331 VGND VGND VPWR VPWR sky130_fd_sc_hd__decap_3
XFILLER_34_1421 VGND VGND VPWR VPWR sky130_fd_sc_hd__decap_3
X_5620_ hold981/X _5907_/A0 _5626_/S VGND VGND VPWR VPWR _6682_/D sky130_fd_sc_hd__mux2_1
XTAP_TAPCELL_ROW_14_562 VGND VPWR sky130_fd_sc_hd__tapvpwrvgnd_1
XFILLER_34_1432 VGND VGND VPWR VPWR sky130_fd_sc_hd__decap_3
XTAP_TAPCELL_ROW_14_573 VGND VPWR sky130_fd_sc_hd__tapvpwrvgnd_1
XFILLER_34_1465 VGND VGND VPWR VPWR sky130_fd_sc_hd__decap_3
X_5551_ _6352_/Q _5501_/B _5551_/B1 _5562_/B2 VGND VGND VPWR VPWR _6634_/D sky130_fd_sc_hd__a22o_2
XFILLER_8_560 VGND VGND VPWR VPWR sky130_fd_sc_hd__decap_3
XFILLER_30_1329 VGND VGND VPWR VPWR sky130_fd_sc_hd__decap_3
X_4502_ _3796_/A _3796_/B _4562_/C _4665_/B _4394_/A VGND VGND VPWR VPWR _4502_/X
+ sky130_fd_sc_hd__o2111a_2
X_5482_ _5482_/A1 _5485_/A2 _4073_/X VGND VGND VPWR VPWR _6594_/D sky130_fd_sc_hd__a21o_2
XTAP_TAPCELL_ROW_74_2121 VGND VPWR sky130_fd_sc_hd__tapvpwrvgnd_1
XTAP_TAPCELL_ROW_74_2132 VGND VPWR sky130_fd_sc_hd__tapvpwrvgnd_1
XFILLER_6_61 VGND VGND VPWR VPWR sky130_fd_sc_hd__fill_2
X_4433_ _4788_/A _4433_/B _4433_/C VGND VGND VPWR VPWR _4433_/X sky130_fd_sc_hd__and3_2
XTAP_TAPCELL_ROW_70_2018 VGND VPWR sky130_fd_sc_hd__tapvpwrvgnd_1
XTAP_TAPCELL_ROW_70_2029 VGND VPWR sky130_fd_sc_hd__tapvpwrvgnd_1
XFILLER_67_1263 VGND VGND VPWR VPWR sky130_fd_sc_hd__decap_3
XFILLER_28_1225 VGND VGND VPWR VPWR sky130_fd_sc_hd__decap_3
X_4364_ _4771_/C1 _4361_/X _4362_/Y _4363_/X _4597_/A VGND VGND VPWR VPWR _4364_/X
+ sky130_fd_sc_hd__o221a_2
Xfanout506 wire515/A VGND VGND VPWR VPWR wire507/A sky130_fd_sc_hd__clkdlybuf4s25_1
X_6103_ _6986_/CLK _6103_/D load_slew650/X VGND VGND VPWR VPWR _6103_/Q sky130_fd_sc_hd__dfrtp_2
Xfanout517 _7084_/Q VGND VGND VPWR VPWR _5565_/A2 sky130_fd_sc_hd__clkdlybuf4s25_1
Xfanout528 _5348_/S VGND VGND VPWR VPWR _5194_/B sky130_fd_sc_hd__clkdlybuf4s25_1
X_3315_ hold952/X _3314_/X _3401_/S VGND VGND VPWR VPWR _6131_/D sky130_fd_sc_hd__mux2_1
XFILLER_28_1258 VGND VGND VPWR VPWR sky130_fd_sc_hd__fill_2
XFILLER_63_1138 VGND VGND VPWR VPWR sky130_fd_sc_hd__fill_1
X_4295_ _4283_/A _4294_/Y _4796_/A VGND VGND VPWR VPWR _4295_/Y sky130_fd_sc_hd__a21oi_2
Xfanout539 _5352_/S VGND VGND VPWR VPWR wire540/A sky130_fd_sc_hd__clkdlybuf4s25_1
X_7083_ _7089_/CLK _7083_/D wire734/X VGND VGND VPWR VPWR _7083_/Q sky130_fd_sc_hd__dfrtp_2
XFILLER_59_729 VGND VGND VPWR VPWR sky130_fd_sc_hd__fill_1
XFILLER_80_1441 VGND VGND VPWR VPWR sky130_fd_sc_hd__decap_3
X_3246_ _6258_/Q _6354_/Q VGND VGND VPWR VPWR _3246_/X sky130_fd_sc_hd__xor2_2
X_6034_ hold927/X _7038_/Q _6058_/S VGND VGND VPWR VPWR _6034_/X sky130_fd_sc_hd__mux2_1
XFILLER_80_1463 VGND VGND VPWR VPWR sky130_fd_sc_hd__decap_3
XFILLER_41_1425 VGND VGND VPWR VPWR sky130_fd_sc_hd__decap_3
XFILLER_67_740 VGND VGND VPWR VPWR sky130_fd_sc_hd__decap_3
XFILLER_39_442 VGND VGND VPWR VPWR sky130_fd_sc_hd__decap_3
X_3177_ _6942_/Q _3219_/B2 _3223_/A1 _3176_/X _3223_/C1 VGND VGND VPWR VPWR _3177_/X
+ sky130_fd_sc_hd__a221o_2
XFILLER_66_250 VGND VGND VPWR VPWR sky130_fd_sc_hd__fill_2
XFILLER_6_1087 VGND VGND VPWR VPWR sky130_fd_sc_hd__decap_3
XTAP_TAPCELL_ROW_1_224 VGND VPWR sky130_fd_sc_hd__tapvpwrvgnd_1
XTAP_TAPCELL_ROW_1_235 VGND VPWR sky130_fd_sc_hd__tapvpwrvgnd_1
XPHY_EDGE_ROW_16_Left_97 VGND VGND VPWR VPWR sky130_fd_sc_hd__decap_3
XFILLER_25_15 VGND VGND VPWR VPWR sky130_fd_sc_hd__decap_3
XFILLER_39_1310 VGND VGND VPWR VPWR sky130_fd_sc_hd__decap_3
XFILLER_54_467 VGND VGND VPWR VPWR sky130_fd_sc_hd__decap_3
XFILLER_14_309 VGND VGND VPWR VPWR sky130_fd_sc_hd__decap_3
X_6936_ _7064_/CLK _6936_/D fanout721/X VGND VGND VPWR VPWR _6936_/Q sky130_fd_sc_hd__dfrtp_2
XFILLER_70_949 VGND VGND VPWR VPWR sky130_fd_sc_hd__decap_3
XFILLER_35_670 VGND VGND VPWR VPWR sky130_fd_sc_hd__fill_2
XFILLER_74_1223 VGND VGND VPWR VPWR sky130_fd_sc_hd__decap_3
XTAP_TAPCELL_ROW_25_838 VGND VPWR sky130_fd_sc_hd__tapvpwrvgnd_1
XFILLER_39_1343 VGND VGND VPWR VPWR sky130_fd_sc_hd__fill_1
XFILLER_39_1354 VGND VGND VPWR VPWR sky130_fd_sc_hd__decap_3
XTAP_TAPCELL_ROW_25_849 VGND VPWR sky130_fd_sc_hd__tapvpwrvgnd_1
XFILLER_74_1256 VGND VGND VPWR VPWR sky130_fd_sc_hd__decap_3
XFILLER_50_640 VGND VGND VPWR VPWR sky130_fd_sc_hd__decap_3
X_6867_ _6900_/CLK _6867_/D load_slew829/X VGND VGND VPWR VPWR _6867_/Q sky130_fd_sc_hd__dfrtp_2
XFILLER_74_1267 VGND VGND VPWR VPWR sky130_fd_sc_hd__decap_3
XFILLER_23_865 VGND VGND VPWR VPWR sky130_fd_sc_hd__decap_3
XFILLER_39_1387 VGND VGND VPWR VPWR sky130_fd_sc_hd__decap_3
XFILLER_50_651 VGND VGND VPWR VPWR sky130_fd_sc_hd__fill_1
XFILLER_50_673 VGND VGND VPWR VPWR sky130_fd_sc_hd__decap_3
X_5818_ _5818_/A0 _5901_/A0 _5822_/S VGND VGND VPWR VPWR _6837_/D sky130_fd_sc_hd__mux2_1
X_6798_ _7046_/CLK _6798_/D load_slew754/X VGND VGND VPWR VPWR _6798_/Q sky130_fd_sc_hd__dfrtp_2
X_5749_ _5749_/A _7068_/Q _7067_/Q _5758_/C VGND VGND VPWR VPWR _5750_/S sky130_fd_sc_hd__or4_2
XFILLER_6_519 VGND VGND VPWR VPWR sky130_fd_sc_hd__decap_3
XFILLER_11_1251 VGND VGND VPWR VPWR sky130_fd_sc_hd__decap_3
XFILLER_11_1284 VGND VGND VPWR VPWR sky130_fd_sc_hd__decap_3
XFILLER_11_1295 VGND VGND VPWR VPWR sky130_fd_sc_hd__decap_3
XFILLER_1_202 VGND VGND VPWR VPWR sky130_fd_sc_hd__decap_3
XFILLER_2_725 VGND VGND VPWR VPWR sky130_fd_sc_hd__decap_3
XFILLER_46_1303 VGND VGND VPWR VPWR sky130_fd_sc_hd__decap_3
XTAP_TAPCELL_ROW_57_1673 VGND VPWR sky130_fd_sc_hd__tapvpwrvgnd_1
XTAP_TAPCELL_ROW_57_1684 VGND VPWR sky130_fd_sc_hd__tapvpwrvgnd_1
XFILLER_1_246 VGND VGND VPWR VPWR sky130_fd_sc_hd__decap_3
XFILLER_46_1347 VGND VGND VPWR VPWR sky130_fd_sc_hd__decap_3
XTAP_TAPCELL_ROW_57_1695 VGND VPWR sky130_fd_sc_hd__tapvpwrvgnd_1
XFILLER_77_526 VGND VGND VPWR VPWR sky130_fd_sc_hd__decap_3
XFILLER_1_279 VGND VGND VPWR VPWR sky130_fd_sc_hd__fill_1
XFILLER_77_559 VGND VGND VPWR VPWR sky130_fd_sc_hd__fill_1
XFILLER_44_1082 VGND VGND VPWR VPWR sky130_fd_sc_hd__decap_3
XFILLER_66_44 VGND VGND VPWR VPWR sky130_fd_sc_hd__decap_3
XFILLER_18_604 VGND VGND VPWR VPWR sky130_fd_sc_hd__fill_1
XFILLER_79_1112 VGND VGND VPWR VPWR sky130_fd_sc_hd__decap_3
XFILLER_66_77 VGND VGND VPWR VPWR sky130_fd_sc_hd__decap_3
Xhold1260 _6933_/Q VGND VGND VPWR VPWR _5928_/A1 sky130_fd_sc_hd__dlygate4sd3_1
XFILLER_57_272 VGND VGND VPWR VPWR sky130_fd_sc_hd__decap_3
XFILLER_73_732 VGND VGND VPWR VPWR sky130_fd_sc_hd__fill_2
Xhold1271 _6987_/Q VGND VGND VPWR VPWR _5983_/A1 sky130_fd_sc_hd__dlygate4sd3_1
XFILLER_79_1145 VGND VGND VPWR VPWR sky130_fd_sc_hd__decap_3
Xhold1282 _6961_/Q VGND VGND VPWR VPWR _5957_/A1 sky130_fd_sc_hd__dlygate4sd3_1
Xhold1293 _6897_/Q VGND VGND VPWR VPWR _5887_/A1 sky130_fd_sc_hd__dlygate4sd3_1
XTAP_TAPCELL_ROW_66_1909 VGND VPWR sky130_fd_sc_hd__tapvpwrvgnd_1
XFILLER_2_1441 VGND VGND VPWR VPWR sky130_fd_sc_hd__decap_3
XFILLER_22_1391 VGND VGND VPWR VPWR sky130_fd_sc_hd__decap_3
XFILLER_79_1189 VGND VGND VPWR VPWR sky130_fd_sc_hd__decap_3
XFILLER_72_253 VGND VGND VPWR VPWR sky130_fd_sc_hd__decap_3
XFILLER_57_1410 VGND VGND VPWR VPWR sky130_fd_sc_hd__decap_3
XFILLER_17_169 VGND VGND VPWR VPWR sky130_fd_sc_hd__decap_3
XFILLER_60_404 VGND VGND VPWR VPWR sky130_fd_sc_hd__fill_2
XFILLER_14_810 VGND VGND VPWR VPWR sky130_fd_sc_hd__fill_2
XFILLER_32_128 VGND VGND VPWR VPWR sky130_fd_sc_hd__decap_3
XFILLER_57_1443 VGND VGND VPWR VPWR sky130_fd_sc_hd__decap_3
XFILLER_13_331 VGND VGND VPWR VPWR sky130_fd_sc_hd__decap_3
XFILLER_18_1427 VGND VGND VPWR VPWR sky130_fd_sc_hd__fill_1
XFILLER_53_1307 VGND VGND VPWR VPWR sky130_fd_sc_hd__decap_3
XFILLER_18_1438 VGND VGND VPWR VPWR sky130_fd_sc_hd__decap_3
XFILLER_13_353 VGND VGND VPWR VPWR sky130_fd_sc_hd__fill_1
XFILLER_13_375 VGND VGND VPWR VPWR sky130_fd_sc_hd__decap_3
XFILLER_41_684 VGND VGND VPWR VPWR sky130_fd_sc_hd__decap_3
XFILLER_40_194 VGND VGND VPWR VPWR sky130_fd_sc_hd__fill_2
XFILLER_70_9 VGND VGND VPWR VPWR sky130_fd_sc_hd__decap_3
XFILLER_12_1015 VGND VGND VPWR VPWR sky130_fd_sc_hd__fill_2
XFILLER_5_541 VGND VGND VPWR VPWR sky130_fd_sc_hd__decap_3
XFILLER_64_1403 VGND VGND VPWR VPWR sky130_fd_sc_hd__decap_3
XFILLER_49_6 VGND VGND VPWR VPWR sky130_fd_sc_hd__decap_3
XFILLER_64_1447 VGND VGND VPWR VPWR sky130_fd_sc_hd__decap_3
X_3100_ _7081_/Q _3100_/B VGND VGND VPWR VPWR _3483_/B sky130_fd_sc_hd__nand2_2
XFILLER_1_780 VGND VGND VPWR VPWR sky130_fd_sc_hd__decap_3
X_4080_ _3472_/X _4080_/A2 _4080_/B1 _6933_/Q _4080_/C1 VGND VGND VPWR VPWR _4080_/X
+ sky130_fd_sc_hd__a221o_2
XFILLER_1_791 VGND VGND VPWR VPWR sky130_fd_sc_hd__decap_3
XFILLER_7_1363 VGND VGND VPWR VPWR sky130_fd_sc_hd__decap_3
XFILLER_0_290 VGND VGND VPWR VPWR sky130_fd_sc_hd__decap_3
XFILLER_49_762 VGND VGND VPWR VPWR sky130_fd_sc_hd__decap_3
XFILLER_3_1216 VGND VGND VPWR VPWR sky130_fd_sc_hd__decap_3
XFILLER_7_1396 VGND VGND VPWR VPWR sky130_fd_sc_hd__decap_3
XFILLER_37_946 VGND VGND VPWR VPWR sky130_fd_sc_hd__decap_3
XFILLER_76_592 VGND VGND VPWR VPWR sky130_fd_sc_hd__decap_3
XFILLER_48_294 VGND VGND VPWR VPWR sky130_fd_sc_hd__decap_3
XFILLER_64_754 VGND VGND VPWR VPWR sky130_fd_sc_hd__fill_2
XFILLER_24_607 VGND VGND VPWR VPWR sky130_fd_sc_hd__decap_3
XFILLER_63_242 VGND VGND VPWR VPWR sky130_fd_sc_hd__decap_3
X_4982_ _6387_/Q _5231_/B wire434/X VGND VGND VPWR VPWR _4982_/Y sky130_fd_sc_hd__a21oi_2
XTAP_TAPCELL_ROW_19_687 VGND VPWR sky130_fd_sc_hd__tapvpwrvgnd_1
XFILLER_51_426 VGND VGND VPWR VPWR sky130_fd_sc_hd__decap_3
XFILLER_17_681 VGND VGND VPWR VPWR sky130_fd_sc_hd__decap_3
XTAP_TAPCELL_ROW_19_698 VGND VPWR sky130_fd_sc_hd__tapvpwrvgnd_1
XFILLER_63_297 VGND VGND VPWR VPWR sky130_fd_sc_hd__fill_1
X_6721_ _6974_/CLK _6721_/D fanout729/X VGND VGND VPWR VPWR _6721_/Q sky130_fd_sc_hd__dfrtp_2
X_3933_ _3933_/A _4095_/B VGND VGND VPWR VPWR _3933_/Y sky130_fd_sc_hd__nand2_2
XFILLER_71_1407 VGND VGND VPWR VPWR sky130_fd_sc_hd__decap_3
XFILLER_32_640 VGND VGND VPWR VPWR sky130_fd_sc_hd__decap_3
XFILLER_20_813 VGND VGND VPWR VPWR sky130_fd_sc_hd__decap_3
X_6652_ _6807_/CLK _6652_/D load_slew784/X VGND VGND VPWR VPWR _6652_/Q sky130_fd_sc_hd__dfrtp_2
XFILLER_32_684 VGND VGND VPWR VPWR sky130_fd_sc_hd__decap_3
X_3864_ _6243_/Q _3864_/A2 _3862_/X _3863_/X VGND VGND VPWR VPWR _4220_/B sky130_fd_sc_hd__o22a_2
X_5603_ _5603_/A1 _5569_/Y _5610_/B1 _5603_/B2 VGND VGND VPWR VPWR _6674_/D sky130_fd_sc_hd__a22o_2
XFILLER_34_1251 VGND VGND VPWR VPWR sky130_fd_sc_hd__decap_3
XFILLER_31_194 VGND VGND VPWR VPWR sky130_fd_sc_hd__decap_3
X_6583_ _7057_/CLK _6583_/D fanout706/X VGND VGND VPWR VPWR _6583_/Q sky130_fd_sc_hd__dfrtp_2
X_3795_ _3888_/A _3888_/B _3794_/C VGND VGND VPWR VPWR _3796_/B sky130_fd_sc_hd__a21oi_2
XFILLER_34_1273 VGND VGND VPWR VPWR sky130_fd_sc_hd__decap_3
XFILLER_9_880 VGND VGND VPWR VPWR sky130_fd_sc_hd__decap_3
X_5534_ _5534_/A1 _3097_/B _5534_/B1 _6617_/Q VGND VGND VPWR VPWR _6617_/D sky130_fd_sc_hd__a22o_2
XFILLER_69_1325 VGND VGND VPWR VPWR sky130_fd_sc_hd__decap_3
X_5465_ _5465_/A1 _5465_/A2 _4796_/X VGND VGND VPWR VPWR _6577_/D sky130_fd_sc_hd__a21bo_2
XFILLER_69_1369 VGND VGND VPWR VPWR sky130_fd_sc_hd__decap_3
X_4416_ _6302_/Q _4416_/A2 _3302_/X _4773_/B2 VGND VGND VPWR VPWR _4416_/X sky130_fd_sc_hd__a22o_2
X_5396_ _5396_/A1 _5484_/A2 _4398_/X VGND VGND VPWR VPWR _6508_/D sky130_fd_sc_hd__a21o_2
XFILLER_67_1060 VGND VGND VPWR VPWR sky130_fd_sc_hd__decap_3
XFILLER_8_1105 VGND VGND VPWR VPWR sky130_fd_sc_hd__decap_3
XFILLER_28_1033 VGND VGND VPWR VPWR sky130_fd_sc_hd__decap_3
Xfanout314 _3105_/X VGND VGND VPWR VPWR _3223_/C1 sky130_fd_sc_hd__clkdlybuf4s25_1
X_4347_ _4347_/A _4347_/B VGND VGND VPWR VPWR _4348_/B sky130_fd_sc_hd__xor2_2
XFILLER_8_1138 VGND VGND VPWR VPWR sky130_fd_sc_hd__decap_3
XTAP_TAPCELL_ROW_6_349 VGND VPWR sky130_fd_sc_hd__tapvpwrvgnd_1
Xfanout336 _4771_/A1 VGND VGND VPWR VPWR _4770_/B sky130_fd_sc_hd__clkdlybuf4s25_1
XFILLER_8_1149 VGND VGND VPWR VPWR sky130_fd_sc_hd__decap_3
XFILLER_28_1077 VGND VGND VPWR VPWR sky130_fd_sc_hd__decap_3
Xfanout358 _5610_/A1 VGND VGND VPWR VPWR _5606_/A2 sky130_fd_sc_hd__clkdlybuf4s25_1
X_7066_ _7096_/CLK _7066_/D load_slew681/X VGND VGND VPWR VPWR _7066_/Q sky130_fd_sc_hd__dfrtp_2
Xfanout369 _4312_/A VGND VGND VPWR VPWR _5600_/A2 sky130_fd_sc_hd__clkdlybuf4s25_1
X_4278_ _4723_/B wire154/X _4277_/X _4267_/X _6489_/Q VGND VGND VPWR VPWR _4278_/X
+ sky130_fd_sc_hd__a32o_2
XFILLER_74_507 VGND VGND VPWR VPWR sky130_fd_sc_hd__fill_1
XFILLER_80_1282 VGND VGND VPWR VPWR sky130_fd_sc_hd__decap_3
X_6017_ _6017_/A0 _7021_/Q _6017_/S VGND VGND VPWR VPWR _6017_/X sky130_fd_sc_hd__mux2_1
XFILLER_28_913 VGND VGND VPWR VPWR sky130_fd_sc_hd__decap_3
XFILLER_74_529 VGND VGND VPWR VPWR sky130_fd_sc_hd__decap_3
X_3229_ hold894/X _3228_/X _3423_/S VGND VGND VPWR VPWR _6088_/D sky130_fd_sc_hd__mux2_1
XFILLER_67_570 VGND VGND VPWR VPWR sky130_fd_sc_hd__fill_2
XFILLER_41_1266 VGND VGND VPWR VPWR sky130_fd_sc_hd__decap_3
XFILLER_28_968 VGND VGND VPWR VPWR sky130_fd_sc_hd__decap_3
XFILLER_27_445 VGND VGND VPWR VPWR sky130_fd_sc_hd__decap_3
XFILLER_54_231 VGND VGND VPWR VPWR sky130_fd_sc_hd__decap_3
XFILLER_15_607 VGND VGND VPWR VPWR sky130_fd_sc_hd__decap_3
XFILLER_76_1329 VGND VGND VPWR VPWR sky130_fd_sc_hd__decap_3
XFILLER_70_724 VGND VGND VPWR VPWR sky130_fd_sc_hd__decap_3
XFILLER_14_106 VGND VGND VPWR VPWR sky130_fd_sc_hd__decap_3
XFILLER_74_1020 VGND VGND VPWR VPWR sky130_fd_sc_hd__decap_3
X_6919_ _7055_/CLK _6919_/D wire796/X VGND VGND VPWR VPWR _6919_/Q sky130_fd_sc_hd__dfrtp_2
XFILLER_42_459 VGND VGND VPWR VPWR sky130_fd_sc_hd__decap_3
XFILLER_70_779 VGND VGND VPWR VPWR sky130_fd_sc_hd__decap_3
XFILLER_23_673 VGND VGND VPWR VPWR sky130_fd_sc_hd__fill_2
XTAP_TAPCELL_ROW_46_1385 VGND VPWR sky130_fd_sc_hd__tapvpwrvgnd_1
XTAP_TAPCELL_ROW_46_1396 VGND VPWR sky130_fd_sc_hd__tapvpwrvgnd_1
XFILLER_10_312 VGND VGND VPWR VPWR sky130_fd_sc_hd__decap_3
XFILLER_22_172 VGND VGND VPWR VPWR sky130_fd_sc_hd__decap_3
XFILLER_10_323 VGND VGND VPWR VPWR sky130_fd_sc_hd__decap_3
XFILLER_17_1460 VGND VGND VPWR VPWR sky130_fd_sc_hd__decap_3
Xwire715 wire715/A VGND VGND VPWR VPWR wire715/X sky130_fd_sc_hd__clkbuf_4
XFILLER_11_868 VGND VGND VPWR VPWR sky130_fd_sc_hd__decap_3
XFILLER_13_1313 VGND VGND VPWR VPWR sky130_fd_sc_hd__decap_3
XFILLER_6_305 VGND VGND VPWR VPWR sky130_fd_sc_hd__decap_3
XFILLER_52_1362 VGND VGND VPWR VPWR sky130_fd_sc_hd__decap_3
XFILLER_7_839 VGND VGND VPWR VPWR sky130_fd_sc_hd__fill_1
XFILLER_52_1373 VGND VGND VPWR VPWR sky130_fd_sc_hd__decap_3
XFILLER_13_1357 VGND VGND VPWR VPWR sky130_fd_sc_hd__decap_3
XFILLER_6_349 VGND VGND VPWR VPWR sky130_fd_sc_hd__decap_3
XTAP_TAPCELL_ROW_59_1724 VGND VPWR sky130_fd_sc_hd__tapvpwrvgnd_1
XTAP_TAPCELL_ROW_59_1735 VGND VPWR sky130_fd_sc_hd__tapvpwrvgnd_1
XTAP_TAPCELL_ROW_59_1746 VGND VPWR sky130_fd_sc_hd__tapvpwrvgnd_1
XFILLER_48_1409 VGND VGND VPWR VPWR sky130_fd_sc_hd__decap_3
XFILLER_11_1081 VGND VGND VPWR VPWR sky130_fd_sc_hd__decap_3
XFILLER_77_21 VGND VGND VPWR VPWR sky130_fd_sc_hd__decap_3
XFILLER_2_577 VGND VGND VPWR VPWR sky130_fd_sc_hd__fill_2
XFILLER_77_54 VGND VGND VPWR VPWR sky130_fd_sc_hd__fill_2
XFILLER_77_334 VGND VGND VPWR VPWR sky130_fd_sc_hd__fill_2
XFILLER_42_1019 VGND VGND VPWR VPWR sky130_fd_sc_hd__fill_2
XFILLER_65_518 VGND VGND VPWR VPWR sky130_fd_sc_hd__decap_3
XFILLER_24_1453 VGND VGND VPWR VPWR sky130_fd_sc_hd__decap_3
XFILLER_19_924 VGND VGND VPWR VPWR sky130_fd_sc_hd__decap_3
XFILLER_46_710 VGND VGND VPWR VPWR sky130_fd_sc_hd__decap_3
XFILLER_18_412 VGND VGND VPWR VPWR sky130_fd_sc_hd__decap_3
XFILLER_20_1306 VGND VGND VPWR VPWR sky130_fd_sc_hd__decap_3
XFILLER_20_1317 VGND VGND VPWR VPWR sky130_fd_sc_hd__decap_3
XFILLER_45_220 VGND VGND VPWR VPWR sky130_fd_sc_hd__decap_3
XFILLER_46_754 VGND VGND VPWR VPWR sky130_fd_sc_hd__fill_2
Xhold1090 _6211_/Q VGND VGND VPWR VPWR _6058_/A0 sky130_fd_sc_hd__dlygate4sd3_1
XTAP_TAPCELL_ROW_29_952 VGND VPWR sky130_fd_sc_hd__tapvpwrvgnd_1
XFILLER_34_905 VGND VGND VPWR VPWR sky130_fd_sc_hd__decap_3
XTAP_TAPCELL_ROW_29_963 VGND VPWR sky130_fd_sc_hd__tapvpwrvgnd_1
XFILLER_46_787 VGND VGND VPWR VPWR sky130_fd_sc_hd__decap_3
XFILLER_18_489 VGND VGND VPWR VPWR sky130_fd_sc_hd__decap_3
XFILLER_2_1282 VGND VGND VPWR VPWR sky130_fd_sc_hd__decap_3
XTAP_TAPCELL_ROW_16_613 VGND VPWR sky130_fd_sc_hd__tapvpwrvgnd_1
XFILLER_61_735 VGND VGND VPWR VPWR sky130_fd_sc_hd__decap_3
XTAP_TAPCELL_ROW_16_624 VGND VPWR sky130_fd_sc_hd__tapvpwrvgnd_1
XFILLER_60_223 VGND VGND VPWR VPWR sky130_fd_sc_hd__decap_3
XFILLER_14_640 VGND VGND VPWR VPWR sky130_fd_sc_hd__decap_3
XFILLER_57_1251 VGND VGND VPWR VPWR sky130_fd_sc_hd__decap_3
XFILLER_61_779 VGND VGND VPWR VPWR sky130_fd_sc_hd__decap_3
XFILLER_14_651 VGND VGND VPWR VPWR sky130_fd_sc_hd__decap_3
XFILLER_18_1235 VGND VGND VPWR VPWR sky130_fd_sc_hd__decap_3
XFILLER_57_1284 VGND VGND VPWR VPWR sky130_fd_sc_hd__decap_3
XFILLER_20_109 VGND VGND VPWR VPWR sky130_fd_sc_hd__decap_3
XFILLER_57_1295 VGND VGND VPWR VPWR sky130_fd_sc_hd__decap_3
XFILLER_41_470 VGND VGND VPWR VPWR sky130_fd_sc_hd__decap_3
XFILLER_18_1279 VGND VGND VPWR VPWR sky130_fd_sc_hd__decap_3
XFILLER_70_1462 VGND VGND VPWR VPWR sky130_fd_sc_hd__decap_3
XFILLER_31_1413 VGND VGND VPWR VPWR sky130_fd_sc_hd__decap_3
XFILLER_9_187 VGND VGND VPWR VPWR sky130_fd_sc_hd__decap_3
XFILLER_31_1446 VGND VGND VPWR VPWR sky130_fd_sc_hd__decap_3
X_3580_ _3579_/B _3579_/C _3652_/A VGND VGND VPWR VPWR _3583_/C sky130_fd_sc_hd__a21bo_2
XFILLER_31_1457 VGND VGND VPWR VPWR sky130_fd_sc_hd__decap_3
XFILLER_6_883 VGND VGND VPWR VPWR sky130_fd_sc_hd__fill_1
X_5250_ _6763_/Q _5328_/S _5321_/S _5249_/Y VGND VGND VPWR VPWR _5250_/X sky130_fd_sc_hd__o211a_2
XFILLER_5_393 VGND VGND VPWR VPWR sky130_fd_sc_hd__decap_3
XFILLER_47_3 VGND VGND VPWR VPWR sky130_fd_sc_hd__decap_3
XFILLER_64_1200 VGND VGND VPWR VPWR sky130_fd_sc_hd__decap_3
XFILLER_29_1331 VGND VGND VPWR VPWR sky130_fd_sc_hd__decap_3
XFILLER_64_1211 VGND VGND VPWR VPWR sky130_fd_sc_hd__decap_3
XFILLER_69_802 VGND VGND VPWR VPWR sky130_fd_sc_hd__decap_3
X_4201_ _4201_/A _4280_/A VGND VGND VPWR VPWR _4203_/A sky130_fd_sc_hd__xnor2_2
XFILLER_68_1391 VGND VGND VPWR VPWR sky130_fd_sc_hd__decap_3
XFILLER_9_1425 VGND VGND VPWR VPWR sky130_fd_sc_hd__decap_3
X_5181_ _6399_/Q _5269_/A2 _5069_/S _5180_/X VGND VGND VPWR VPWR _6399_/D sky130_fd_sc_hd__a22o_2
XFILLER_64_1244 VGND VGND VPWR VPWR sky130_fd_sc_hd__decap_3
XFILLER_29_1375 VGND VGND VPWR VPWR sky130_fd_sc_hd__decap_3
XFILLER_69_835 VGND VGND VPWR VPWR sky130_fd_sc_hd__decap_3
XFILLER_3_51 VGND VGND VPWR VPWR sky130_fd_sc_hd__decap_3
XFILLER_60_1108 VGND VGND VPWR VPWR sky130_fd_sc_hd__decap_3
X_4132_ _4132_/A _4132_/B VGND VGND VPWR VPWR _4133_/B sky130_fd_sc_hd__xnor2_2
XFILLER_25_1239 VGND VGND VPWR VPWR sky130_fd_sc_hd__decap_3
XFILLER_64_1288 VGND VGND VPWR VPWR sky130_fd_sc_hd__decap_3
XFILLER_68_345 VGND VGND VPWR VPWR sky130_fd_sc_hd__fill_2
XFILLER_3_84 VGND VGND VPWR VPWR sky130_fd_sc_hd__decap_3
XFILLER_56_518 VGND VGND VPWR VPWR sky130_fd_sc_hd__decap_3
XFILLER_7_1160 VGND VGND VPWR VPWR sky130_fd_sc_hd__decap_3
XFILLER_68_378 VGND VGND VPWR VPWR sky130_fd_sc_hd__decap_3
X_4063_ _6240_/Q _4081_/A2 _4061_/X _4062_/X VGND VGND VPWR VPWR _6240_/D sky130_fd_sc_hd__o22a_2
XFILLER_3_1002 VGND VGND VPWR VPWR sky130_fd_sc_hd__decap_3
XFILLER_49_592 VGND VGND VPWR VPWR sky130_fd_sc_hd__decap_3
XFILLER_3_1057 VGND VGND VPWR VPWR sky130_fd_sc_hd__decap_3
XFILLER_25_905 VGND VGND VPWR VPWR sky130_fd_sc_hd__decap_3
XFILLER_3_1068 VGND VGND VPWR VPWR sky130_fd_sc_hd__decap_3
XFILLER_36_253 VGND VGND VPWR VPWR sky130_fd_sc_hd__decap_3
XFILLER_25_949 VGND VGND VPWR VPWR sky130_fd_sc_hd__decap_3
XFILLER_36_286 VGND VGND VPWR VPWR sky130_fd_sc_hd__decap_3
XFILLER_75_1340 VGND VGND VPWR VPWR sky130_fd_sc_hd__decap_3
XFILLER_75_1351 VGND VGND VPWR VPWR sky130_fd_sc_hd__decap_3
X_4965_ _6449_/Q _6667_/Q VGND VGND VPWR VPWR _4966_/B sky130_fd_sc_hd__xor2_2
XFILLER_71_1204 VGND VGND VPWR VPWR sky130_fd_sc_hd__decap_3
XFILLER_75_1384 VGND VGND VPWR VPWR sky130_fd_sc_hd__decap_3
XFILLER_11_109 VGND VGND VPWR VPWR sky130_fd_sc_hd__decap_3
X_6704_ _7056_/CLK _6704_/D load_slew700/X VGND VGND VPWR VPWR _6704_/Q sky130_fd_sc_hd__dfrtp_2
XFILLER_36_1335 VGND VGND VPWR VPWR sky130_fd_sc_hd__decap_3
XFILLER_51_289 VGND VGND VPWR VPWR sky130_fd_sc_hd__decap_3
X_3916_ _4008_/B _4002_/A2 _5609_/A3 _3089_/B _6502_/Q VGND VGND VPWR VPWR _3916_/X
+ sky130_fd_sc_hd__a32o_2
XFILLER_71_1248 VGND VGND VPWR VPWR sky130_fd_sc_hd__decap_3
X_4896_ _4896_/A1 _4893_/X _4894_/Y _4895_/X _4896_/C1 VGND VGND VPWR VPWR _4896_/X
+ sky130_fd_sc_hd__o221a_2
XFILLER_32_492 VGND VGND VPWR VPWR sky130_fd_sc_hd__decap_3
XFILLER_36_1368 VGND VGND VPWR VPWR sky130_fd_sc_hd__decap_3
XFILLER_20_643 VGND VGND VPWR VPWR sky130_fd_sc_hd__fill_1
XFILLER_36_1379 VGND VGND VPWR VPWR sky130_fd_sc_hd__decap_3
X_6635_ _6943_/CLK _6635_/D fanout823/X VGND VGND VPWR VPWR _6635_/Q sky130_fd_sc_hd__dfrtp_2
X_3847_ _4302_/A _4222_/A VGND VGND VPWR VPWR _3848_/B sky130_fd_sc_hd__xor2_2
XFILLER_34_1070 VGND VGND VPWR VPWR sky130_fd_sc_hd__decap_3
XFILLER_20_687 VGND VGND VPWR VPWR sky130_fd_sc_hd__decap_3
XTAP_TAPCELL_ROW_41_1260 VGND VPWR sky130_fd_sc_hd__tapvpwrvgnd_1
XTAP_TAPCELL_ROW_41_1271 VGND VPWR sky130_fd_sc_hd__tapvpwrvgnd_1
X_6566_ _7000_/CLK _6566_/D fanout721/X VGND VGND VPWR VPWR _6566_/Q sky130_fd_sc_hd__dfrtp_2
X_3778_ _6289_/Q _3928_/A2 _3928_/B1 _6265_/Q _3928_/C1 VGND VGND VPWR VPWR _3778_/X
+ sky130_fd_sc_hd__a221o_2
X_5517_ _3098_/A _3092_/B _5517_/A3 _5359_/C _5517_/B2 VGND VGND VPWR VPWR _6609_/D
+ sky130_fd_sc_hd__a32o_2
XFILLER_3_308 VGND VGND VPWR VPWR sky130_fd_sc_hd__decap_3
XFILLER_69_1144 VGND VGND VPWR VPWR sky130_fd_sc_hd__decap_3
X_6497_ _6910_/CLK _6497_/D load_slew786/X VGND VGND VPWR VPWR _6497_/Q sky130_fd_sc_hd__dfrtp_2
XFILLER_69_1177 VGND VGND VPWR VPWR sky130_fd_sc_hd__decap_3
X_5448_ _5448_/A1 _5480_/A2 _4013_/X VGND VGND VPWR VPWR _6560_/D sky130_fd_sc_hd__a21o_2
XFILLER_0_9 VGND VGND VPWR VPWR sky130_fd_sc_hd__decap_3
XTAP_TAPCELL_ROW_54_1610 VGND VPWR sky130_fd_sc_hd__tapvpwrvgnd_1
XFILLER_47_1431 VGND VGND VPWR VPWR sky130_fd_sc_hd__decap_3
X_5379_ _5379_/A1 _5470_/A2 _4308_/X VGND VGND VPWR VPWR _6491_/D sky130_fd_sc_hd__a21o_2
Xfanout111 _5260_/A2 VGND VGND VPWR VPWR wire112/A sky130_fd_sc_hd__clkdlybuf4s25_1
Xfanout122 _5355_/S VGND VGND VPWR VPWR _5271_/B1 sky130_fd_sc_hd__clkdlybuf4s25_1
XTAP_TAPCELL_ROW_50_1507 VGND VPWR sky130_fd_sc_hd__tapvpwrvgnd_1
XFILLER_59_323 VGND VGND VPWR VPWR sky130_fd_sc_hd__decap_3
XFILLER_43_1328 VGND VGND VPWR VPWR sky130_fd_sc_hd__decap_3
Xfanout155 _3717_/Y VGND VGND VPWR VPWR _4335_/A2 sky130_fd_sc_hd__clkdlybuf4s25_1
Xfanout188 _3459_/S VGND VGND VPWR VPWR _3379_/S sky130_fd_sc_hd__clkdlybuf4s25_1
X_7049_ _7057_/CLK _7049_/D fanout708/X VGND VGND VPWR VPWR _7049_/Q sky130_fd_sc_hd__dfrtp_2
XFILLER_47_529 VGND VGND VPWR VPWR sky130_fd_sc_hd__fill_1
XFILLER_28_710 VGND VGND VPWR VPWR sky130_fd_sc_hd__fill_2
XPHY_EDGE_ROW_29_Right_29 VGND VGND VPWR VPWR sky130_fd_sc_hd__decap_3
XFILLER_47_57 VGND VGND VPWR VPWR sky130_fd_sc_hd__decap_3
XFILLER_27_242 VGND VGND VPWR VPWR sky130_fd_sc_hd__fill_2
XFILLER_55_573 VGND VGND VPWR VPWR sky130_fd_sc_hd__fill_2
XFILLER_76_1126 VGND VGND VPWR VPWR sky130_fd_sc_hd__decap_3
XFILLER_63_12 VGND VGND VPWR VPWR sky130_fd_sc_hd__decap_3
XTAP_TAPCELL_ROW_48_1436 VGND VPWR sky130_fd_sc_hd__tapvpwrvgnd_1
XFILLER_42_212 VGND VGND VPWR VPWR sky130_fd_sc_hd__decap_3
XTAP_TAPCELL_ROW_48_1447 VGND VPWR sky130_fd_sc_hd__tapvpwrvgnd_1
XTAP_TAPCELL_ROW_48_1458 VGND VPWR sky130_fd_sc_hd__tapvpwrvgnd_1
XFILLER_63_45 VGND VGND VPWR VPWR sky130_fd_sc_hd__fill_2
XFILLER_42_234 VGND VGND VPWR VPWR sky130_fd_sc_hd__decap_3
XFILLER_42_256 VGND VGND VPWR VPWR sky130_fd_sc_hd__decap_3
XFILLER_43_779 VGND VGND VPWR VPWR sky130_fd_sc_hd__decap_3
XFILLER_24_971 VGND VGND VPWR VPWR sky130_fd_sc_hd__decap_3
XFILLER_30_407 VGND VGND VPWR VPWR sky130_fd_sc_hd__decap_3
XFILLER_54_1424 VGND VGND VPWR VPWR sky130_fd_sc_hd__decap_3
XFILLER_54_1435 VGND VGND VPWR VPWR sky130_fd_sc_hd__decap_3
XFILLER_8_18 VGND VGND VPWR VPWR sky130_fd_sc_hd__decap_3
XFILLER_8_29 VGND VGND VPWR VPWR sky130_fd_sc_hd__decap_3
XFILLER_15_1419 VGND VGND VPWR VPWR sky130_fd_sc_hd__decap_3
XFILLER_54_1468 VGND VGND VPWR VPWR sky130_fd_sc_hd__fill_1
XFILLER_11_643 VGND VGND VPWR VPWR sky130_fd_sc_hd__decap_3
XFILLER_11_665 VGND VGND VPWR VPWR sky130_fd_sc_hd__decap_3
XPHY_EDGE_ROW_38_Right_38 VGND VGND VPWR VPWR sky130_fd_sc_hd__decap_3
XFILLER_13_1121 VGND VGND VPWR VPWR sky130_fd_sc_hd__decap_3
XFILLER_11_687 VGND VGND VPWR VPWR sky130_fd_sc_hd__fill_1
XFILLER_10_153 VGND VGND VPWR VPWR sky130_fd_sc_hd__fill_1
XFILLER_6_113 VGND VGND VPWR VPWR sky130_fd_sc_hd__decap_3
XFILLER_10_175 VGND VGND VPWR VPWR sky130_fd_sc_hd__decap_3
XFILLER_7_658 VGND VGND VPWR VPWR sky130_fd_sc_hd__decap_3
XFILLER_10_197 VGND VGND VPWR VPWR sky130_fd_sc_hd__decap_3
XFILLER_48_1239 VGND VGND VPWR VPWR sky130_fd_sc_hd__decap_3
XFILLER_3_853 VGND VGND VPWR VPWR sky130_fd_sc_hd__decap_3
XFILLER_3_886 VGND VGND VPWR VPWR sky130_fd_sc_hd__decap_3
XFILLER_3_897 VGND VGND VPWR VPWR sky130_fd_sc_hd__decap_3
XFILLER_2_363 VGND VGND VPWR VPWR sky130_fd_sc_hd__fill_1
XFILLER_2_374 VGND VGND VPWR VPWR sky130_fd_sc_hd__decap_3
XFILLER_33_9 VGND VGND VPWR VPWR sky130_fd_sc_hd__decap_3
XFILLER_61_1428 VGND VGND VPWR VPWR sky130_fd_sc_hd__decap_3
XPHY_EDGE_ROW_47_Right_47 VGND VGND VPWR VPWR sky130_fd_sc_hd__decap_3
XFILLER_66_805 VGND VGND VPWR VPWR sky130_fd_sc_hd__decap_3
XFILLER_4_1300 VGND VGND VPWR VPWR sky130_fd_sc_hd__decap_3
XFILLER_65_304 VGND VGND VPWR VPWR sky130_fd_sc_hd__decap_3
XFILLER_24_1250 VGND VGND VPWR VPWR sky130_fd_sc_hd__decap_3
XFILLER_77_186 VGND VGND VPWR VPWR sky130_fd_sc_hd__decap_3
XFILLER_24_1261 VGND VGND VPWR VPWR sky130_fd_sc_hd__decap_3
XFILLER_4_1344 VGND VGND VPWR VPWR sky130_fd_sc_hd__decap_3
XFILLER_65_348 VGND VGND VPWR VPWR sky130_fd_sc_hd__decap_3
XFILLER_24_1294 VGND VGND VPWR VPWR sky130_fd_sc_hd__decap_3
XFILLER_0_1208 VGND VGND VPWR VPWR sky130_fd_sc_hd__decap_3
XFILLER_18_242 VGND VGND VPWR VPWR sky130_fd_sc_hd__fill_1
XFILLER_46_551 VGND VGND VPWR VPWR sky130_fd_sc_hd__decap_3
XFILLER_59_1313 VGND VGND VPWR VPWR sky130_fd_sc_hd__decap_3
XFILLER_4_1388 VGND VGND VPWR VPWR sky130_fd_sc_hd__decap_3
XFILLER_46_584 VGND VGND VPWR VPWR sky130_fd_sc_hd__decap_3
XFILLER_59_1357 VGND VGND VPWR VPWR sky130_fd_sc_hd__decap_3
XFILLER_34_757 VGND VGND VPWR VPWR sky130_fd_sc_hd__fill_2
XFILLER_33_234 VGND VGND VPWR VPWR sky130_fd_sc_hd__decap_3
XFILLER_22_919 VGND VGND VPWR VPWR sky130_fd_sc_hd__decap_3
XFILLER_33_267 VGND VGND VPWR VPWR sky130_fd_sc_hd__fill_1
X_4750_ _6251_/Q _4750_/A2 _3424_/X _4750_/B2 VGND VGND VPWR VPWR _4750_/X sky130_fd_sc_hd__a22o_2
XFILLER_14_470 VGND VGND VPWR VPWR sky130_fd_sc_hd__decap_3
XFILLER_18_1043 VGND VGND VPWR VPWR sky130_fd_sc_hd__decap_3
XPHY_EDGE_ROW_56_Right_56 VGND VGND VPWR VPWR sky130_fd_sc_hd__decap_3
XFILLER_30_941 VGND VGND VPWR VPWR sky130_fd_sc_hd__decap_3
X_3701_ _3855_/A _3701_/B VGND VGND VPWR VPWR _3787_/A sky130_fd_sc_hd__xnor2_2
X_4681_ _6554_/Q _4703_/A VGND VGND VPWR VPWR _4681_/Y sky130_fd_sc_hd__nand2_2
XFILLER_30_974 VGND VGND VPWR VPWR sky130_fd_sc_hd__fill_2
XFILLER_70_1270 VGND VGND VPWR VPWR sky130_fd_sc_hd__decap_3
X_6420_ _7046_/CLK _6420_/D load_slew744/X VGND VGND VPWR VPWR _6420_/Q sky130_fd_sc_hd__dfrtp_2
XFILLER_30_996 VGND VGND VPWR VPWR sky130_fd_sc_hd__decap_3
XFILLER_35_1390 VGND VGND VPWR VPWR sky130_fd_sc_hd__decap_3
X_3632_ _6642_/Q _4723_/C VGND VGND VPWR VPWR _3632_/X sky130_fd_sc_hd__or2_2
XFILLER_31_1254 VGND VGND VPWR VPWR sky130_fd_sc_hd__decap_3
X_6351_ _6913_/CLK _6351_/D fanout729/X VGND VGND VPWR VPWR _6351_/Q sky130_fd_sc_hd__dfrtp_2
X_3563_ _6644_/Q _6636_/Q _6628_/Q _6620_/Q _3496_/B _3566_/A VGND VGND VPWR VPWR
+ _3564_/B sky130_fd_sc_hd__mux4_2
XFILLER_31_1287 VGND VGND VPWR VPWR sky130_fd_sc_hd__fill_1
XFILLER_31_1298 VGND VGND VPWR VPWR sky130_fd_sc_hd__decap_3
XFILLER_66_1306 VGND VGND VPWR VPWR sky130_fd_sc_hd__decap_3
X_5302_ _6782_/Q _4931_/B _5352_/S VGND VGND VPWR VPWR _5302_/X sky130_fd_sc_hd__mux2_1
XFILLER_66_1317 VGND VGND VPWR VPWR sky130_fd_sc_hd__decap_3
X_6282_ _7012_/CLK _6282_/D load_slew810/X VGND VGND VPWR VPWR _6282_/Q sky130_fd_sc_hd__dfrtp_2
X_3494_ _3601_/A _3550_/B VGND VGND VPWR VPWR _4723_/C sky130_fd_sc_hd__or2_2
X_5233_ _6419_/Q _5257_/A2 _5232_/X VGND VGND VPWR VPWR _6419_/D sky130_fd_sc_hd__a21o_2
XFILLER_9_1222 VGND VGND VPWR VPWR sky130_fd_sc_hd__decap_3
XPHY_EDGE_ROW_65_Right_65 VGND VGND VPWR VPWR sky130_fd_sc_hd__decap_3
XFILLER_9_1233 VGND VGND VPWR VPWR sky130_fd_sc_hd__decap_3
XFILLER_68_120 VGND VGND VPWR VPWR sky130_fd_sc_hd__decap_3
X_5164_ _6729_/Q _5164_/B VGND VGND VPWR VPWR _5164_/X sky130_fd_sc_hd__or2_2
XFILLER_9_1266 VGND VGND VPWR VPWR sky130_fd_sc_hd__decap_3
XFILLER_5_1119 VGND VGND VPWR VPWR sky130_fd_sc_hd__fill_1
X_4115_ _6272_/Q _4750_/A2 _3226_/X _4115_/B2 VGND VGND VPWR VPWR _4115_/X sky130_fd_sc_hd__a22o_2
X_5095_ _6467_/Q _5095_/B VGND VGND VPWR VPWR _5096_/B sky130_fd_sc_hd__xnor2_2
XFILLER_42_1350 VGND VGND VPWR VPWR sky130_fd_sc_hd__decap_3
XFILLER_68_197 VGND VGND VPWR VPWR sky130_fd_sc_hd__decap_3
XFILLER_37_540 VGND VGND VPWR VPWR sky130_fd_sc_hd__fill_2
X_4046_ _4008_/B _3717_/A _5609_/A3 _4008_/Y _6566_/Q VGND VGND VPWR VPWR _4046_/X
+ sky130_fd_sc_hd__a32o_2
XFILLER_42_1394 VGND VGND VPWR VPWR sky130_fd_sc_hd__decap_3
XFILLER_77_1413 VGND VGND VPWR VPWR sky130_fd_sc_hd__decap_3
XFILLER_77_1446 VGND VGND VPWR VPWR sky130_fd_sc_hd__decap_3
XFILLER_77_1457 VGND VGND VPWR VPWR sky130_fd_sc_hd__decap_3
XFILLER_37_595 VGND VGND VPWR VPWR sky130_fd_sc_hd__fill_2
XFILLER_80_841 VGND VGND VPWR VPWR sky130_fd_sc_hd__decap_3
XFILLER_25_746 VGND VGND VPWR VPWR sky130_fd_sc_hd__decap_3
XPHY_EDGE_ROW_74_Right_74 VGND VGND VPWR VPWR sky130_fd_sc_hd__decap_3
X_5997_ _5997_/A0 _5997_/A1 _5997_/S VGND VGND VPWR VPWR _7001_/D sky130_fd_sc_hd__mux2_1
XFILLER_40_727 VGND VGND VPWR VPWR sky130_fd_sc_hd__decap_3
XFILLER_52_587 VGND VGND VPWR VPWR sky130_fd_sc_hd__fill_1
XFILLER_71_1012 VGND VGND VPWR VPWR sky130_fd_sc_hd__fill_2
XTAP_TAPCELL_ROW_43_1311 VGND VPWR sky130_fd_sc_hd__tapvpwrvgnd_1
XTAP_TAPCELL_ROW_43_1322 VGND VPWR sky130_fd_sc_hd__tapvpwrvgnd_1
X_4948_ _4946_/X _4947_/Y wire105/X VGND VGND VPWR VPWR _4950_/S sky130_fd_sc_hd__a21oi_2
XFILLER_75_1192 VGND VGND VPWR VPWR sky130_fd_sc_hd__decap_3
XFILLER_36_1176 VGND VGND VPWR VPWR sky130_fd_sc_hd__fill_1
X_4879_ _6589_/Q _4879_/B VGND VGND VPWR VPWR _4879_/Y sky130_fd_sc_hd__nand2_2
XFILLER_36_1198 VGND VGND VPWR VPWR sky130_fd_sc_hd__decap_3
XFILLER_14_1441 VGND VGND VPWR VPWR sky130_fd_sc_hd__decap_3
X_6618_ _7073_/CLK _6618_/D load_slew684/X VGND VGND VPWR VPWR _6618_/Q sky130_fd_sc_hd__dfrtp_2
Xclkbuf_3_5_0_clk clkbuf_0_clk/X VGND VGND VPWR VPWR clkbuf_3_5_0_clk/X sky130_fd_sc_hd__clkbuf_8
X_6549_ _6863_/CLK _6549_/D fanout791/A VGND VGND VPWR VPWR _6549_/Q sky130_fd_sc_hd__dfrtp_2
XFILLER_10_1338 VGND VGND VPWR VPWR sky130_fd_sc_hd__decap_3
XFILLER_4_628 VGND VGND VPWR VPWR sky130_fd_sc_hd__decap_3
XFILLER_3_105 VGND VGND VPWR VPWR sky130_fd_sc_hd__decap_3
XFILLER_3_116 VGND VGND VPWR VPWR sky130_fd_sc_hd__decap_3
XFILLER_79_407 VGND VGND VPWR VPWR sky130_fd_sc_hd__decap_3
XTAP_TAPCELL_ROW_37_1159 VGND VPWR sky130_fd_sc_hd__tapvpwrvgnd_1
XFILLER_0_834 VGND VGND VPWR VPWR sky130_fd_sc_hd__decap_3
XFILLER_47_1272 VGND VGND VPWR VPWR sky130_fd_sc_hd__decap_3
XFILLER_0_856 VGND VGND VPWR VPWR sky130_fd_sc_hd__decap_3
XFILLER_58_56 VGND VGND VPWR VPWR sky130_fd_sc_hd__decap_3
XFILLER_0_878 VGND VGND VPWR VPWR sky130_fd_sc_hd__decap_3
XFILLER_21_1401 VGND VGND VPWR VPWR sky130_fd_sc_hd__decap_3
XFILLER_60_1450 VGND VGND VPWR VPWR sky130_fd_sc_hd__decap_3
XFILLER_74_123 VGND VGND VPWR VPWR sky130_fd_sc_hd__fill_1
XFILLER_47_337 VGND VGND VPWR VPWR sky130_fd_sc_hd__decap_3
XFILLER_21_1434 VGND VGND VPWR VPWR sky130_fd_sc_hd__decap_3
XFILLER_74_156 VGND VGND VPWR VPWR sky130_fd_sc_hd__fill_1
XFILLER_74_44 VGND VGND VPWR VPWR sky130_fd_sc_hd__decap_3
XFILLER_74_178 VGND VGND VPWR VPWR sky130_fd_sc_hd__decap_3
XFILLER_28_573 VGND VGND VPWR VPWR sky130_fd_sc_hd__decap_3
XFILLER_16_724 VGND VGND VPWR VPWR sky130_fd_sc_hd__decap_3
XFILLER_74_77 VGND VGND VPWR VPWR sky130_fd_sc_hd__decap_3
XFILLER_74_88 VGND VGND VPWR VPWR sky130_fd_sc_hd__decap_3
XFILLER_16_757 VGND VGND VPWR VPWR sky130_fd_sc_hd__decap_3
XFILLER_15_267 VGND VGND VPWR VPWR sky130_fd_sc_hd__decap_3
XFILLER_43_587 VGND VGND VPWR VPWR sky130_fd_sc_hd__decap_3
XFILLER_70_373 VGND VGND VPWR VPWR sky130_fd_sc_hd__decap_3
XFILLER_54_1232 VGND VGND VPWR VPWR sky130_fd_sc_hd__decap_3
XPHY_EDGE_ROW_4_Left_85 VGND VGND VPWR VPWR sky130_fd_sc_hd__decap_3
XFILLER_19_1363 VGND VGND VPWR VPWR sky130_fd_sc_hd__decap_3
XFILLER_12_952 VGND VGND VPWR VPWR sky130_fd_sc_hd__decap_3
XFILLER_8_901 VGND VGND VPWR VPWR sky130_fd_sc_hd__decap_3
XFILLER_15_1216 VGND VGND VPWR VPWR sky130_fd_sc_hd__decap_3
XFILLER_11_440 VGND VGND VPWR VPWR sky130_fd_sc_hd__decap_3
XFILLER_19_1396 VGND VGND VPWR VPWR sky130_fd_sc_hd__decap_3
XFILLER_54_1276 VGND VGND VPWR VPWR sky130_fd_sc_hd__decap_3
XFILLER_11_462 VGND VGND VPWR VPWR sky130_fd_sc_hd__decap_3
XFILLER_7_411 VGND VGND VPWR VPWR sky130_fd_sc_hd__decap_3
Xwire331 _5501_/Y VGND VGND VPWR VPWR wire331/X sky130_fd_sc_hd__buf_4
XFILLER_7_444 VGND VGND VPWR VPWR sky130_fd_sc_hd__decap_3
XFILLER_8_978 VGND VGND VPWR VPWR sky130_fd_sc_hd__fill_2
XFILLER_7_455 VGND VGND VPWR VPWR sky130_fd_sc_hd__decap_3
XFILLER_7_488 VGND VGND VPWR VPWR sky130_fd_sc_hd__decap_3
XFILLER_48_1025 VGND VGND VPWR VPWR sky130_fd_sc_hd__decap_3
XFILLER_3_661 VGND VGND VPWR VPWR sky130_fd_sc_hd__decap_3
Xload_slew303 fanout302/X VGND VGND VPWR VPWR _4855_/A2 sky130_fd_sc_hd__clkbuf_4
XFILLER_3_694 VGND VGND VPWR VPWR sky130_fd_sc_hd__decap_3
XFILLER_2_171 VGND VGND VPWR VPWR sky130_fd_sc_hd__decap_3
XFILLER_26_1312 VGND VGND VPWR VPWR sky130_fd_sc_hd__decap_3
XFILLER_31_6 VGND VGND VPWR VPWR sky130_fd_sc_hd__decap_3
Xload_slew325 _5546_/B2 VGND VGND VPWR VPWR _5562_/B2 sky130_fd_sc_hd__clkbuf_4
XFILLER_26_1323 VGND VGND VPWR VPWR sky130_fd_sc_hd__decap_3
XFILLER_65_1372 VGND VGND VPWR VPWR sky130_fd_sc_hd__decap_3
Xload_slew347 _3807_/A2 VGND VGND VPWR VPWR _4822_/A sky130_fd_sc_hd__buf_2
XFILLER_6_1406 VGND VGND VPWR VPWR sky130_fd_sc_hd__decap_3
XFILLER_79_974 VGND VGND VPWR VPWR sky130_fd_sc_hd__fill_1
XFILLER_78_451 VGND VGND VPWR VPWR sky130_fd_sc_hd__decap_3
XFILLER_61_1225 VGND VGND VPWR VPWR sky130_fd_sc_hd__decap_3
XFILLER_26_1356 VGND VGND VPWR VPWR sky130_fd_sc_hd__decap_3
XFILLER_61_1236 VGND VGND VPWR VPWR sky130_fd_sc_hd__decap_3
XFILLER_38_304 VGND VGND VPWR VPWR sky130_fd_sc_hd__decap_3
XFILLER_39_838 VGND VGND VPWR VPWR sky130_fd_sc_hd__fill_2
XFILLER_61_1269 VGND VGND VPWR VPWR sky130_fd_sc_hd__decap_3
XFILLER_4_1141 VGND VGND VPWR VPWR sky130_fd_sc_hd__decap_3
XFILLER_54_819 VGND VGND VPWR VPWR sky130_fd_sc_hd__fill_2
XFILLER_4_1152 VGND VGND VPWR VPWR sky130_fd_sc_hd__decap_3
XFILLER_19_551 VGND VGND VPWR VPWR sky130_fd_sc_hd__decap_3
XFILLER_65_167 VGND VGND VPWR VPWR sky130_fd_sc_hd__fill_1
XFILLER_0_41 VGND VGND VPWR VPWR sky130_fd_sc_hd__decap_3
XFILLER_0_1005 VGND VGND VPWR VPWR sky130_fd_sc_hd__decap_3
X_5920_ _5920_/A0 _5795_/C _5923_/S VGND VGND VPWR VPWR _6926_/D sky130_fd_sc_hd__mux2_1
XFILLER_4_1185 VGND VGND VPWR VPWR sky130_fd_sc_hd__decap_3
XFILLER_59_1121 VGND VGND VPWR VPWR sky130_fd_sc_hd__fill_1
XFILLER_0_1027 VGND VGND VPWR VPWR sky130_fd_sc_hd__decap_3
XFILLER_0_63 VGND VGND VPWR VPWR sky130_fd_sc_hd__decap_3
XFILLER_34_521 VGND VGND VPWR VPWR sky130_fd_sc_hd__fill_1
XFILLER_74_690 VGND VGND VPWR VPWR sky130_fd_sc_hd__fill_1
XFILLER_0_85 VGND VGND VPWR VPWR sky130_fd_sc_hd__decap_3
XFILLER_0_1049 VGND VGND VPWR VPWR sky130_fd_sc_hd__decap_3
XFILLER_34_554 VGND VGND VPWR VPWR sky130_fd_sc_hd__decap_3
XFILLER_55_1007 VGND VGND VPWR VPWR sky130_fd_sc_hd__fill_1
XFILLER_62_863 VGND VGND VPWR VPWR sky130_fd_sc_hd__decap_3
X_5851_ _5851_/A0 _5889_/A0 wire97/X VGND VGND VPWR VPWR _6866_/D sky130_fd_sc_hd__mux2_1
X_4802_ _4822_/A _4624_/B _4801_/Y _4859_/C1 VGND VGND VPWR VPWR _4802_/Y sky130_fd_sc_hd__o211ai_2
XFILLER_61_373 VGND VGND VPWR VPWR sky130_fd_sc_hd__decap_3
XFILLER_62_896 VGND VGND VPWR VPWR sky130_fd_sc_hd__decap_3
XFILLER_21_215 VGND VGND VPWR VPWR sky130_fd_sc_hd__fill_1
XFILLER_72_1332 VGND VGND VPWR VPWR sky130_fd_sc_hd__decap_3
XFILLER_37_1452 VGND VGND VPWR VPWR sky130_fd_sc_hd__decap_3
X_5782_ _5782_/A0 _5923_/A1 _5782_/S VGND VGND VPWR VPWR _6817_/D sky130_fd_sc_hd__mux2_1
XFILLER_37_1463 VGND VGND VPWR VPWR sky130_fd_sc_hd__decap_3
XFILLER_21_248 VGND VGND VPWR VPWR sky130_fd_sc_hd__decap_3
XFILLER_72_1365 VGND VGND VPWR VPWR sky130_fd_sc_hd__decap_3
XFILLER_33_1316 VGND VGND VPWR VPWR sky130_fd_sc_hd__decap_3
X_4733_ _6569_/Q _4732_/A _3485_/B VGND VGND VPWR VPWR _4733_/X sky130_fd_sc_hd__a21bo_2
XFILLER_72_1376 VGND VGND VPWR VPWR sky130_fd_sc_hd__decap_3
XFILLER_30_760 VGND VGND VPWR VPWR sky130_fd_sc_hd__decap_3
XFILLER_30_793 VGND VGND VPWR VPWR sky130_fd_sc_hd__decap_3
X_4664_ _6311_/Q _4663_/X _4664_/S VGND VGND VPWR VPWR _6311_/D sky130_fd_sc_hd__mux2_1
X_6403_ _7092_/CLK _6403_/D load_slew690/X VGND VGND VPWR VPWR _6403_/Q sky130_fd_sc_hd__dfrtp_2
X_3615_ _3615_/A _3673_/A _3615_/C VGND VGND VPWR VPWR _3617_/A sky130_fd_sc_hd__nand3_2
X_4595_ _6542_/Q _4717_/A VGND VGND VPWR VPWR _4595_/Y sky130_fd_sc_hd__nand2_2
Xhold901 _5972_/X VGND VGND VPWR VPWR _6976_/D sky130_fd_sc_hd__dlygate4sd3_1
Xhold912 _6028_/X VGND VGND VPWR VPWR _7032_/D sky130_fd_sc_hd__dlygate4sd3_1
XFILLER_31_1084 VGND VGND VPWR VPWR sky130_fd_sc_hd__decap_3
Xhold923 _6209_/Q VGND VGND VPWR VPWR hold923/X sky130_fd_sc_hd__dlygate4sd3_1
XTAP_TAPCELL_ROW_77_2196 VGND VPWR sky130_fd_sc_hd__tapvpwrvgnd_1
X_6334_ _6925_/CLK _6334_/D load_slew658/X VGND VGND VPWR VPWR _6334_/Q sky130_fd_sc_hd__dfrtp_2
Xhold934 _7071_/Q VGND VGND VPWR VPWR hold934/X sky130_fd_sc_hd__dlygate4sd3_1
X_3546_ _6339_/Q _5594_/A1 _3630_/C1 _6323_/Q VGND VGND VPWR VPWR _3546_/X sky130_fd_sc_hd__a22o_2
Xhold945 _6090_/Q VGND VGND VPWR VPWR hold945/X sky130_fd_sc_hd__dlygate4sd3_1
XFILLER_66_1125 VGND VGND VPWR VPWR sky130_fd_sc_hd__decap_3
Xhold956 _5963_/X VGND VGND VPWR VPWR _6967_/D sky130_fd_sc_hd__dlygate4sd3_1
Xhold967 _7022_/Q VGND VGND VPWR VPWR hold967/X sky130_fd_sc_hd__dlygate4sd3_1
Xhold978 _6949_/Q VGND VGND VPWR VPWR hold978/X sky130_fd_sc_hd__dlygate4sd3_1
Xhold989 _6172_/Q VGND VGND VPWR VPWR hold989/X sky130_fd_sc_hd__dlygate4sd3_1
X_6265_ _6923_/CLK _6265_/D fanout802/X VGND VGND VPWR VPWR _6265_/Q sky130_fd_sc_hd__dfrtp_2
X_3477_ hold966/X _3476_/X _3477_/S VGND VGND VPWR VPWR _6212_/D sky130_fd_sc_hd__mux2_1
XFILLER_0_119 VGND VGND VPWR VPWR sky130_fd_sc_hd__decap_3
XFILLER_44_1412 VGND VGND VPWR VPWR sky130_fd_sc_hd__decap_3
X_5216_ _5216_/A _5216_/B VGND VGND VPWR VPWR _5216_/Y sky130_fd_sc_hd__nand2_2
XFILLER_69_440 VGND VGND VPWR VPWR sky130_fd_sc_hd__decap_3
XFILLER_9_1052 VGND VGND VPWR VPWR sky130_fd_sc_hd__decap_3
X_6196_ _7055_/CLK _6196_/D wire796/X VGND VGND VPWR VPWR _6196_/Q sky130_fd_sc_hd__dfrtp_2
XTAP_TAPCELL_ROW_32_1023 VGND VPWR sky130_fd_sc_hd__tapvpwrvgnd_1
XFILLER_44_1456 VGND VGND VPWR VPWR sky130_fd_sc_hd__decap_3
XTAP_TAPCELL_ROW_32_1034 VGND VPWR sky130_fd_sc_hd__tapvpwrvgnd_1
XFILLER_40_1309 VGND VGND VPWR VPWR sky130_fd_sc_hd__decap_3
X_5147_ _6382_/Q wire105/X _4950_/S _5146_/X VGND VGND VPWR VPWR _6382_/D sky130_fd_sc_hd__a22o_2
XFILLER_29_326 VGND VGND VPWR VPWR sky130_fd_sc_hd__decap_3
XTAP_TAPCELL_ROW_32_1045 VGND VPWR sky130_fd_sc_hd__tapvpwrvgnd_1
XFILLER_56_134 VGND VGND VPWR VPWR sky130_fd_sc_hd__decap_3
XFILLER_29_359 VGND VGND VPWR VPWR sky130_fd_sc_hd__decap_3
X_5078_ _6611_/Q _6651_/Q VGND VGND VPWR VPWR _5079_/B sky130_fd_sc_hd__xnor2_2
XFILLER_56_156 VGND VGND VPWR VPWR sky130_fd_sc_hd__fill_1
XFILLER_77_1210 VGND VGND VPWR VPWR sky130_fd_sc_hd__decap_3
XFILLER_56_178 VGND VGND VPWR VPWR sky130_fd_sc_hd__fill_2
XFILLER_56_189 VGND VGND VPWR VPWR sky130_fd_sc_hd__decap_3
X_4029_ _4077_/B _4572_/B VGND VGND VPWR VPWR _4029_/Y sky130_fd_sc_hd__nor2_2
XFILLER_71_137 VGND VGND VPWR VPWR sky130_fd_sc_hd__decap_3
XFILLER_77_1254 VGND VGND VPWR VPWR sky130_fd_sc_hd__decap_3
XFILLER_77_1287 VGND VGND VPWR VPWR sky130_fd_sc_hd__fill_1
XFILLER_73_1118 VGND VGND VPWR VPWR sky130_fd_sc_hd__fill_2
XFILLER_25_576 VGND VGND VPWR VPWR sky130_fd_sc_hd__decap_3
XFILLER_77_1298 VGND VGND VPWR VPWR sky130_fd_sc_hd__decap_3
XFILLER_52_395 VGND VGND VPWR VPWR sky130_fd_sc_hd__decap_3
XFILLER_51_1416 VGND VGND VPWR VPWR sky130_fd_sc_hd__decap_3
XFILLER_21_760 VGND VGND VPWR VPWR sky130_fd_sc_hd__decap_3
XTAP_TAPCELL_ROW_23_788 VGND VPWR sky130_fd_sc_hd__tapvpwrvgnd_1
XFILLER_51_1449 VGND VGND VPWR VPWR sky130_fd_sc_hd__decap_3
XTAP_TAPCELL_ROW_23_799 VGND VPWR sky130_fd_sc_hd__tapvpwrvgnd_1
XFILLER_21_793 VGND VGND VPWR VPWR sky130_fd_sc_hd__decap_3
XTAP_TAPCELL_ROW_10_449 VGND VPWR sky130_fd_sc_hd__tapvpwrvgnd_1
XFILLER_10_1102 VGND VGND VPWR VPWR sky130_fd_sc_hd__decap_3
XFILLER_14_1282 VGND VGND VPWR VPWR sky130_fd_sc_hd__decap_3
XFILLER_4_403 VGND VGND VPWR VPWR sky130_fd_sc_hd__decap_3
XFILLER_49_1301 VGND VGND VPWR VPWR sky130_fd_sc_hd__decap_3
XFILLER_10_1135 VGND VGND VPWR VPWR sky130_fd_sc_hd__decap_3
XFILLER_4_458 VGND VGND VPWR VPWR sky130_fd_sc_hd__decap_3
XFILLER_49_1334 VGND VGND VPWR VPWR sky130_fd_sc_hd__decap_3
XFILLER_49_1345 VGND VGND VPWR VPWR sky130_fd_sc_hd__decap_3
XFILLER_69_33 VGND VGND VPWR VPWR sky130_fd_sc_hd__decap_3
XFILLER_10_1179 VGND VGND VPWR VPWR sky130_fd_sc_hd__decap_3
XFILLER_49_1378 VGND VGND VPWR VPWR sky130_fd_sc_hd__decap_3
XFILLER_0_631 VGND VGND VPWR VPWR sky130_fd_sc_hd__decap_3
XFILLER_0_697 VGND VGND VPWR VPWR sky130_fd_sc_hd__decap_3
XFILLER_47_134 VGND VGND VPWR VPWR sky130_fd_sc_hd__decap_3
XFILLER_21_1220 VGND VGND VPWR VPWR sky130_fd_sc_hd__decap_3
XFILLER_36_819 VGND VGND VPWR VPWR sky130_fd_sc_hd__fill_1
XFILLER_76_999 VGND VGND VPWR VPWR sky130_fd_sc_hd__fill_1
XFILLER_21_1242 VGND VGND VPWR VPWR sky130_fd_sc_hd__decap_3
XFILLER_60_1291 VGND VGND VPWR VPWR sky130_fd_sc_hd__decap_3
XFILLER_75_487 VGND VGND VPWR VPWR sky130_fd_sc_hd__decap_3
XFILLER_1_1325 VGND VGND VPWR VPWR sky130_fd_sc_hd__decap_3
XFILLER_16_521 VGND VGND VPWR VPWR sky130_fd_sc_hd__decap_3
XFILLER_21_1275 VGND VGND VPWR VPWR sky130_fd_sc_hd__decap_3
XFILLER_44_830 VGND VGND VPWR VPWR sky130_fd_sc_hd__decap_3
XFILLER_1_1369 VGND VGND VPWR VPWR sky130_fd_sc_hd__decap_3
XFILLER_43_340 VGND VGND VPWR VPWR sky130_fd_sc_hd__decap_3
XFILLER_44_874 VGND VGND VPWR VPWR sky130_fd_sc_hd__fill_1
XFILLER_71_671 VGND VGND VPWR VPWR sky130_fd_sc_hd__fill_1
XFILLER_56_1338 VGND VGND VPWR VPWR sky130_fd_sc_hd__decap_3
XFILLER_44_896 VGND VGND VPWR VPWR sky130_fd_sc_hd__decap_3
XFILLER_71_682 VGND VGND VPWR VPWR sky130_fd_sc_hd__decap_3
XFILLER_16_598 VGND VGND VPWR VPWR sky130_fd_sc_hd__decap_3
XFILLER_70_181 VGND VGND VPWR VPWR sky130_fd_sc_hd__decap_3
XFILLER_70_192 VGND VGND VPWR VPWR sky130_fd_sc_hd__decap_3
XFILLER_34_80 VGND VGND VPWR VPWR sky130_fd_sc_hd__decap_3
XFILLER_12_760 VGND VGND VPWR VPWR sky130_fd_sc_hd__decap_3
XFILLER_79_6 VGND VGND VPWR VPWR sky130_fd_sc_hd__decap_3
XFILLER_8_753 VGND VGND VPWR VPWR sky130_fd_sc_hd__decap_3
XFILLER_11_281 VGND VGND VPWR VPWR sky130_fd_sc_hd__decap_3
XFILLER_15_1068 VGND VGND VPWR VPWR sky130_fd_sc_hd__decap_3
XFILLER_8_786 VGND VGND VPWR VPWR sky130_fd_sc_hd__fill_1
XFILLER_32_1371 VGND VGND VPWR VPWR sky130_fd_sc_hd__fill_1
XFILLER_32_1382 VGND VGND VPWR VPWR sky130_fd_sc_hd__decap_3
Xwire183 wire183/A VGND VGND VPWR VPWR _3447_/S sky130_fd_sc_hd__clkbuf_4
XFILLER_67_1401 VGND VGND VPWR VPWR sky130_fd_sc_hd__decap_3
X_3400_ _6319_/Q _6431_/Q VGND VGND VPWR VPWR _3400_/X sky130_fd_sc_hd__xor2_2
X_4380_ _6506_/Q _4405_/B VGND VGND VPWR VPWR _4380_/Y sky130_fd_sc_hd__nand2_2
XFILLER_67_1434 VGND VGND VPWR VPWR sky130_fd_sc_hd__decap_3
X_3331_ _5986_/A0 _3330_/X _3401_/S VGND VGND VPWR VPWR _6139_/D sky130_fd_sc_hd__mux2_1
XFILLER_28_1418 VGND VGND VPWR VPWR sky130_fd_sc_hd__decap_3
XFILLER_28_1429 VGND VGND VPWR VPWR sky130_fd_sc_hd__decap_3
XTAP_TAPCELL_ROW_72_2060 VGND VPWR sky130_fd_sc_hd__tapvpwrvgnd_1
XTAP_TAPCELL_ROW_72_2071 VGND VPWR sky130_fd_sc_hd__tapvpwrvgnd_1
XFILLER_3_480 VGND VGND VPWR VPWR sky130_fd_sc_hd__decap_3
XTAP_TAPCELL_ROW_72_2082 VGND VPWR sky130_fd_sc_hd__tapvpwrvgnd_1
X_6050_ hold905/X _7054_/Q _6050_/S VGND VGND VPWR VPWR _6050_/X sky130_fd_sc_hd__mux2_1
X_3262_ _6266_/Q _6362_/Q VGND VGND VPWR VPWR _3262_/X sky130_fd_sc_hd__xor2_2
XFILLER_26_1131 VGND VGND VPWR VPWR sky130_fd_sc_hd__decap_3
XFILLER_65_1180 VGND VGND VPWR VPWR sky130_fd_sc_hd__decap_3
XFILLER_67_900 VGND VGND VPWR VPWR sky130_fd_sc_hd__decap_3
XFILLER_6_1203 VGND VGND VPWR VPWR sky130_fd_sc_hd__fill_1
X_5001_ _6422_/Q _5001_/B VGND VGND VPWR VPWR _5240_/B sky130_fd_sc_hd__xnor2_2
XFILLER_6_1214 VGND VGND VPWR VPWR sky130_fd_sc_hd__decap_3
XFILLER_61_1044 VGND VGND VPWR VPWR sky130_fd_sc_hd__decap_3
XFILLER_6_1247 VGND VGND VPWR VPWR sky130_fd_sc_hd__decap_3
X_3193_ _3193_/A1 _3191_/X _3192_/X _3220_/C1 VGND VGND VPWR VPWR _3194_/C sky130_fd_sc_hd__a211o_2
Xload_slew199 _3269_/S VGND VGND VPWR VPWR _3461_/S sky130_fd_sc_hd__clkbuf_4
XFILLER_66_432 VGND VGND VPWR VPWR sky130_fd_sc_hd__decap_3
XFILLER_26_1197 VGND VGND VPWR VPWR sky130_fd_sc_hd__decap_3
XFILLER_26_307 VGND VGND VPWR VPWR sky130_fd_sc_hd__fill_1
XFILLER_38_178 VGND VGND VPWR VPWR sky130_fd_sc_hd__fill_1
X_6952_ clkload8/A _6952_/D load_slew637/X VGND VGND VPWR VPWR _6952_/Q sky130_fd_sc_hd__dfrtp_2
XFILLER_35_841 VGND VGND VPWR VPWR sky130_fd_sc_hd__fill_1
X_5903_ _5903_/A0 _5903_/A1 _5905_/S VGND VGND VPWR VPWR _6911_/D sky130_fd_sc_hd__mux2_1
X_6883_ _6889_/CLK _6883_/D fanout749/X VGND VGND VPWR VPWR _6883_/Q sky130_fd_sc_hd__dfrtp_2
XFILLER_50_800 VGND VGND VPWR VPWR sky130_fd_sc_hd__decap_3
XFILLER_74_1427 VGND VGND VPWR VPWR sky130_fd_sc_hd__fill_1
XFILLER_74_1438 VGND VGND VPWR VPWR sky130_fd_sc_hd__decap_3
XFILLER_34_362 VGND VGND VPWR VPWR sky130_fd_sc_hd__fill_2
XFILLER_62_682 VGND VGND VPWR VPWR sky130_fd_sc_hd__decap_3
X_5834_ _5908_/A0 _5834_/A1 _5840_/S VGND VGND VPWR VPWR _6851_/D sky130_fd_sc_hd__mux2_1
XFILLER_34_395 VGND VGND VPWR VPWR sky130_fd_sc_hd__decap_3
XFILLER_61_192 VGND VGND VPWR VPWR sky130_fd_sc_hd__decap_3
XFILLER_37_1260 VGND VGND VPWR VPWR sky130_fd_sc_hd__decap_3
X_5765_ _5904_/A0 _5765_/A1 _5766_/S VGND VGND VPWR VPWR _6808_/D sky130_fd_sc_hd__mux2_1
XFILLER_72_1173 VGND VGND VPWR VPWR sky130_fd_sc_hd__decap_3
XTAP_TAPCELL_ROW_20_714 VGND VPWR sky130_fd_sc_hd__tapvpwrvgnd_1
XTAP_TAPCELL_ROW_79_2247 VGND VPWR sky130_fd_sc_hd__tapvpwrvgnd_1
XTAP_TAPCELL_ROW_20_725 VGND VPWR sky130_fd_sc_hd__tapvpwrvgnd_1
X_4716_ _4738_/A _4345_/X _4665_/X _6559_/Q VGND VGND VPWR VPWR _4716_/X sky130_fd_sc_hd__a2bb2o_2
XTAP_TAPCELL_ROW_79_2258 VGND VPWR sky130_fd_sc_hd__tapvpwrvgnd_1
X_5696_ _5696_/A0 _5825_/A0 _5702_/S VGND VGND VPWR VPWR _6747_/D sky130_fd_sc_hd__mux2_1
XFILLER_11_1422 VGND VGND VPWR VPWR sky130_fd_sc_hd__decap_3
X_4647_ _4647_/A1 _4644_/X _4645_/Y _4646_/X _4683_/A VGND VGND VPWR VPWR _4647_/X
+ sky130_fd_sc_hd__o221a_2
XFILLER_11_1455 VGND VGND VPWR VPWR sky130_fd_sc_hd__fill_1
XFILLER_11_1466 VGND VGND VPWR VPWR sky130_fd_sc_hd__decap_3
X_4578_ _6540_/Q _4547_/X _3486_/B VGND VGND VPWR VPWR _4578_/X sky130_fd_sc_hd__a21o_2
X_6317_ _6863_/CLK _6317_/D load_slew754/X VGND VGND VPWR VPWR _6317_/Q sky130_fd_sc_hd__dfrtp_2
XFILLER_1_417 VGND VGND VPWR VPWR sky130_fd_sc_hd__decap_3
X_3529_ _3527_/X _3528_/X _4886_/A1 VGND VGND VPWR VPWR _3529_/X sky130_fd_sc_hd__o21a_2
XFILLER_77_708 VGND VGND VPWR VPWR sky130_fd_sc_hd__decap_3
X_6248_ _7073_/CLK _6248_/D load_slew674/X VGND VGND VPWR VPWR _6248_/Q sky130_fd_sc_hd__dfrtp_2
XFILLER_58_900 VGND VGND VPWR VPWR sky130_fd_sc_hd__fill_2
X_6179_ _7001_/CLK _6179_/D load_slew775/X VGND VGND VPWR VPWR _6179_/Q sky130_fd_sc_hd__dfrtp_2
XFILLER_44_1264 VGND VGND VPWR VPWR sky130_fd_sc_hd__decap_3
Xhold1420 _6549_/Q VGND VGND VPWR VPWR _5437_/A1 sky130_fd_sc_hd__dlygate4sd3_1
Xhold1431 _6555_/Q VGND VGND VPWR VPWR _5443_/A1 sky130_fd_sc_hd__dlygate4sd3_1
XFILLER_69_292 VGND VGND VPWR VPWR sky130_fd_sc_hd__decap_3
Xhold1442 _6931_/Q VGND VGND VPWR VPWR _5926_/A1 sky130_fd_sc_hd__dlygate4sd3_1
XFILLER_40_1128 VGND VGND VPWR VPWR sky130_fd_sc_hd__decap_3
XFILLER_44_1297 VGND VGND VPWR VPWR sky130_fd_sc_hd__decap_3
XFILLER_58_977 VGND VGND VPWR VPWR sky130_fd_sc_hd__decap_3
XFILLER_79_1316 VGND VGND VPWR VPWR sky130_fd_sc_hd__decap_3
Xhold1453 _6903_/Q VGND VGND VPWR VPWR _5894_/A1 sky130_fd_sc_hd__dlygate4sd3_1
XFILLER_73_925 VGND VGND VPWR VPWR sky130_fd_sc_hd__decap_3
XFILLER_17_307 VGND VGND VPWR VPWR sky130_fd_sc_hd__decap_3
Xhold1464 _6563_/Q VGND VGND VPWR VPWR _5451_/A1 sky130_fd_sc_hd__dlygate4sd3_1
Xhold1475 _6503_/Q VGND VGND VPWR VPWR _5391_/A1 sky130_fd_sc_hd__dlygate4sd3_1
XTAP_TAPCELL_ROW_4_299 VGND VPWR sky130_fd_sc_hd__tapvpwrvgnd_1
Xhold1486 _6488_/Q VGND VGND VPWR VPWR _5376_/A1 sky130_fd_sc_hd__dlygate4sd3_1
Xhold1497 _6742_/Q VGND VGND VPWR VPWR _5690_/A0 sky130_fd_sc_hd__dlygate4sd3_1
XFILLER_72_424 VGND VGND VPWR VPWR sky130_fd_sc_hd__decap_3
XFILLER_26_841 VGND VGND VPWR VPWR sky130_fd_sc_hd__decap_3
XTAP_TAPCELL_ROW_68_1962 VGND VPWR sky130_fd_sc_hd__tapvpwrvgnd_1
XFILLER_60_608 VGND VGND VPWR VPWR sky130_fd_sc_hd__fill_2
XTAP_TAPCELL_ROW_68_1973 VGND VPWR sky130_fd_sc_hd__tapvpwrvgnd_1
XFILLER_13_502 VGND VGND VPWR VPWR sky130_fd_sc_hd__fill_2
XFILLER_25_373 VGND VGND VPWR VPWR sky130_fd_sc_hd__decap_3
XFILLER_41_822 VGND VGND VPWR VPWR sky130_fd_sc_hd__decap_3
XFILLER_77_1095 VGND VGND VPWR VPWR sky130_fd_sc_hd__decap_3
XFILLER_71_12 VGND VGND VPWR VPWR sky130_fd_sc_hd__decap_3
XFILLER_38_1046 VGND VGND VPWR VPWR sky130_fd_sc_hd__decap_3
XFILLER_53_693 VGND VGND VPWR VPWR sky130_fd_sc_hd__decap_3
XFILLER_0_1391 VGND VGND VPWR VPWR sky130_fd_sc_hd__decap_3
XTAP_TAPCELL_ROW_64_1859 VGND VPWR sky130_fd_sc_hd__tapvpwrvgnd_1
XFILLER_40_321 VGND VGND VPWR VPWR sky130_fd_sc_hd__decap_3
XFILLER_71_45 VGND VGND VPWR VPWR sky130_fd_sc_hd__decap_3
XFILLER_13_557 VGND VGND VPWR VPWR sky130_fd_sc_hd__decap_3
XFILLER_16_1300 VGND VGND VPWR VPWR sky130_fd_sc_hd__decap_3
XFILLER_9_517 VGND VGND VPWR VPWR sky130_fd_sc_hd__decap_3
XFILLER_55_1360 VGND VGND VPWR VPWR sky130_fd_sc_hd__decap_3
XFILLER_51_1202 VGND VGND VPWR VPWR sky130_fd_sc_hd__decap_3
XFILLER_40_365 VGND VGND VPWR VPWR sky130_fd_sc_hd__decap_3
XFILLER_16_1344 VGND VGND VPWR VPWR sky130_fd_sc_hd__decap_3
XFILLER_55_1393 VGND VGND VPWR VPWR sky130_fd_sc_hd__decap_3
XFILLER_12_1208 VGND VGND VPWR VPWR sky130_fd_sc_hd__decap_3
XFILLER_51_1257 VGND VGND VPWR VPWR sky130_fd_sc_hd__decap_3
XFILLER_16_1388 VGND VGND VPWR VPWR sky130_fd_sc_hd__decap_3
XFILLER_5_745 VGND VGND VPWR VPWR sky130_fd_sc_hd__decap_3
XFILLER_45_1006 VGND VGND VPWR VPWR sky130_fd_sc_hd__fill_2
XFILLER_1_951 VGND VGND VPWR VPWR sky130_fd_sc_hd__fill_1
XFILLER_1_962 VGND VGND VPWR VPWR sky130_fd_sc_hd__decap_3
XFILLER_27_1440 VGND VGND VPWR VPWR sky130_fd_sc_hd__decap_3
XFILLER_62_1320 VGND VGND VPWR VPWR sky130_fd_sc_hd__decap_3
XFILLER_0_461 VGND VGND VPWR VPWR sky130_fd_sc_hd__decap_3
XFILLER_1_995 VGND VGND VPWR VPWR sky130_fd_sc_hd__decap_3
XFILLER_23_1304 VGND VGND VPWR VPWR sky130_fd_sc_hd__decap_3
XFILLER_62_1353 VGND VGND VPWR VPWR sky130_fd_sc_hd__decap_3
XFILLER_0_483 VGND VGND VPWR VPWR sky130_fd_sc_hd__decap_3
XFILLER_48_421 VGND VGND VPWR VPWR sky130_fd_sc_hd__decap_3
XFILLER_23_1337 VGND VGND VPWR VPWR sky130_fd_sc_hd__decap_3
XFILLER_23_1348 VGND VGND VPWR VPWR sky130_fd_sc_hd__decap_3
XFILLER_62_1397 VGND VGND VPWR VPWR sky130_fd_sc_hd__decap_3
XFILLER_75_240 VGND VGND VPWR VPWR sky130_fd_sc_hd__fill_1
XFILLER_48_465 VGND VGND VPWR VPWR sky130_fd_sc_hd__decap_3
XFILLER_21_1061 VGND VGND VPWR VPWR sky130_fd_sc_hd__decap_3
XFILLER_1_1133 VGND VGND VPWR VPWR sky130_fd_sc_hd__decap_3
XFILLER_35_137 VGND VGND VPWR VPWR sky130_fd_sc_hd__fill_2
XFILLER_51_608 VGND VGND VPWR VPWR sky130_fd_sc_hd__decap_3
XFILLER_1_1166 VGND VGND VPWR VPWR sky130_fd_sc_hd__decap_3
XFILLER_1_1177 VGND VGND VPWR VPWR sky130_fd_sc_hd__decap_3
XFILLER_16_351 VGND VGND VPWR VPWR sky130_fd_sc_hd__decap_3
XFILLER_17_885 VGND VGND VPWR VPWR sky130_fd_sc_hd__decap_3
XFILLER_56_1146 VGND VGND VPWR VPWR sky130_fd_sc_hd__fill_2
XFILLER_71_490 VGND VGND VPWR VPWR sky130_fd_sc_hd__fill_2
X_3880_ _3880_/A _3880_/B VGND VGND VPWR VPWR _3886_/A sky130_fd_sc_hd__xnor2_2
XTAP_TAPCELL_ROW_27_891 VGND VPWR sky130_fd_sc_hd__tapvpwrvgnd_1
Xclkbuf_leaf_70_clk clkbuf_4_8__f_clk/X VGND VGND VPWR VPWR _7054_/CLK sky130_fd_sc_hd__clkbuf_8
XFILLER_34_1400 VGND VGND VPWR VPWR sky130_fd_sc_hd__decap_3
XFILLER_56_1179 VGND VGND VPWR VPWR sky130_fd_sc_hd__decap_3
XFILLER_73_1460 VGND VGND VPWR VPWR sky130_fd_sc_hd__decap_3
XTAP_TAPCELL_ROW_14_552 VGND VPWR sky130_fd_sc_hd__tapvpwrvgnd_1
XTAP_TAPCELL_ROW_14_563 VGND VPWR sky130_fd_sc_hd__tapvpwrvgnd_1
XTAP_TAPCELL_ROW_14_574 VGND VPWR sky130_fd_sc_hd__tapvpwrvgnd_1
XFILLER_34_1444 VGND VGND VPWR VPWR sky130_fd_sc_hd__decap_3
X_5550_ _6351_/Q _5565_/A2 hold929/X _5502_/D VGND VGND VPWR VPWR _6633_/D sky130_fd_sc_hd__a22o_2
XFILLER_77_3 VGND VGND VPWR VPWR sky130_fd_sc_hd__decap_3
X_4501_ _6289_/Q _4863_/A2 _4498_/X _4500_/X VGND VGND VPWR VPWR _6289_/D sky130_fd_sc_hd__o22a_2
XFILLER_8_572 VGND VGND VPWR VPWR sky130_fd_sc_hd__decap_3
X_5481_ _5481_/A1 _5485_/A2 _4067_/X VGND VGND VPWR VPWR _6593_/D sky130_fd_sc_hd__a21o_2
XTAP_TAPCELL_ROW_74_2122 VGND VPWR sky130_fd_sc_hd__tapvpwrvgnd_1
XFILLER_32_1190 VGND VGND VPWR VPWR sky130_fd_sc_hd__decap_3
XTAP_TAPCELL_ROW_74_2133 VGND VPWR sky130_fd_sc_hd__tapvpwrvgnd_1
X_4432_ _4431_/B _4610_/B _4431_/Y _4787_/C1 VGND VGND VPWR VPWR _4433_/C sky130_fd_sc_hd__o211ai_2
XFILLER_67_1231 VGND VGND VPWR VPWR sky130_fd_sc_hd__fill_1
XFILLER_67_1242 VGND VGND VPWR VPWR sky130_fd_sc_hd__decap_3
XTAP_TAPCELL_ROW_70_2008 VGND VPWR sky130_fd_sc_hd__tapvpwrvgnd_1
XTAP_TAPCELL_ROW_70_2019 VGND VPWR sky130_fd_sc_hd__tapvpwrvgnd_1
X_4363_ _6504_/Q _4388_/A _4771_/C1 VGND VGND VPWR VPWR _4363_/X sky130_fd_sc_hd__a21bo_2
XFILLER_67_1275 VGND VGND VPWR VPWR sky130_fd_sc_hd__decap_3
XFILLER_8_1309 VGND VGND VPWR VPWR sky130_fd_sc_hd__decap_3
XFILLER_28_1237 VGND VGND VPWR VPWR sky130_fd_sc_hd__decap_3
X_6102_ _7025_/CLK _6102_/D wire764/X VGND VGND VPWR VPWR _6102_/Q sky130_fd_sc_hd__dfrtp_2
X_3314_ _6284_/Q _6388_/Q VGND VGND VPWR VPWR _3314_/X sky130_fd_sc_hd__xor2_2
Xfanout518 _5566_/A2 VGND VGND VPWR VPWR _5564_/A2 sky130_fd_sc_hd__clkdlybuf4s25_1
X_7082_ _7090_/CLK _7082_/D load_slew723/X VGND VGND VPWR VPWR _7082_/Q sky130_fd_sc_hd__dfrtp_2
X_4294_ _4294_/A _4294_/B VGND VGND VPWR VPWR _4294_/Y sky130_fd_sc_hd__xnor2_2
XFILLER_6_1011 VGND VGND VPWR VPWR sky130_fd_sc_hd__decap_3
X_6033_ _6033_/A0 _6033_/A1 _6033_/S VGND VGND VPWR VPWR _7037_/D sky130_fd_sc_hd__mux2_1
XFILLER_80_1453 VGND VGND VPWR VPWR sky130_fd_sc_hd__decap_3
XFILLER_41_1404 VGND VGND VPWR VPWR sky130_fd_sc_hd__decap_3
X_3245_ _5943_/A0 _3244_/X _3261_/S VGND VGND VPWR VPWR _6096_/D sky130_fd_sc_hd__mux2_1
XFILLER_41_1437 VGND VGND VPWR VPWR sky130_fd_sc_hd__decap_3
XFILLER_55_903 VGND VGND VPWR VPWR sky130_fd_sc_hd__decap_3
X_3176_ _6950_/Q _6958_/Q _3222_/A VGND VGND VPWR VPWR _3176_/X sky130_fd_sc_hd__mux2_1
XFILLER_67_774 VGND VGND VPWR VPWR sky130_fd_sc_hd__fill_2
XTAP_TAPCELL_ROW_1_214 VGND VPWR sky130_fd_sc_hd__tapvpwrvgnd_1
XFILLER_55_925 VGND VGND VPWR VPWR sky130_fd_sc_hd__fill_2
XFILLER_67_785 VGND VGND VPWR VPWR sky130_fd_sc_hd__decap_3
XTAP_TAPCELL_ROW_1_225 VGND VPWR sky130_fd_sc_hd__tapvpwrvgnd_1
XFILLER_66_262 VGND VGND VPWR VPWR sky130_fd_sc_hd__fill_1
XFILLER_6_1099 VGND VGND VPWR VPWR sky130_fd_sc_hd__decap_3
XTAP_TAPCELL_ROW_1_236 VGND VPWR sky130_fd_sc_hd__tapvpwrvgnd_1
XFILLER_54_424 VGND VGND VPWR VPWR sky130_fd_sc_hd__decap_3
XFILLER_78_1371 VGND VGND VPWR VPWR sky130_fd_sc_hd__fill_1
X_6935_ _7060_/CLK _6935_/D load_slew782/X VGND VGND VPWR VPWR _6935_/Q sky130_fd_sc_hd__dfrtp_2
XFILLER_39_1322 VGND VGND VPWR VPWR sky130_fd_sc_hd__decap_3
XFILLER_78_1382 VGND VGND VPWR VPWR sky130_fd_sc_hd__decap_3
XFILLER_63_980 VGND VGND VPWR VPWR sky130_fd_sc_hd__decap_3
XTAP_TAPCELL_ROW_25_839 VGND VPWR sky130_fd_sc_hd__tapvpwrvgnd_1
XFILLER_35_682 VGND VGND VPWR VPWR sky130_fd_sc_hd__decap_3
XFILLER_74_1235 VGND VGND VPWR VPWR sky130_fd_sc_hd__decap_3
XFILLER_39_1366 VGND VGND VPWR VPWR sky130_fd_sc_hd__decap_3
XFILLER_34_181 VGND VGND VPWR VPWR sky130_fd_sc_hd__decap_3
Xclkbuf_leaf_61_clk clkload5/A VGND VGND VPWR VPWR _7051_/CLK sky130_fd_sc_hd__clkbuf_8
X_6866_ _7037_/CLK _6866_/D load_slew694/X VGND VGND VPWR VPWR _6866_/Q sky130_fd_sc_hd__dfrtp_2
XFILLER_74_1279 VGND VGND VPWR VPWR sky130_fd_sc_hd__decap_3
XFILLER_39_1399 VGND VGND VPWR VPWR sky130_fd_sc_hd__fill_1
X_5817_ _5817_/A0 _5900_/A0 _5822_/S VGND VGND VPWR VPWR _6836_/D sky130_fd_sc_hd__mux2_1
XFILLER_10_516 VGND VGND VPWR VPWR sky130_fd_sc_hd__decap_3
X_6797_ clkload7/A _6797_/D wire641/X VGND VGND VPWR VPWR _6797_/Q sky130_fd_sc_hd__dfrtp_2
XFILLER_22_376 VGND VGND VPWR VPWR sky130_fd_sc_hd__fill_2
XFILLER_37_1090 VGND VGND VPWR VPWR sky130_fd_sc_hd__fill_2
XFILLER_41_15 VGND VGND VPWR VPWR sky130_fd_sc_hd__decap_3
XFILLER_10_549 VGND VGND VPWR VPWR sky130_fd_sc_hd__decap_3
X_5748_ _5923_/A1 _5748_/A1 _5748_/S VGND VGND VPWR VPWR _6793_/D sky130_fd_sc_hd__mux2_1
XFILLER_41_48 VGND VGND VPWR VPWR sky130_fd_sc_hd__decap_3
X_5679_ hold886/X _5909_/A0 wire90/X VGND VGND VPWR VPWR _6732_/D sky130_fd_sc_hd__mux2_1
XFILLER_11_1263 VGND VGND VPWR VPWR sky130_fd_sc_hd__decap_3
XFILLER_2_704 VGND VGND VPWR VPWR sky130_fd_sc_hd__decap_3
XFILLER_2_737 VGND VGND VPWR VPWR sky130_fd_sc_hd__decap_3
XFILLER_9_6 VGND VGND VPWR VPWR sky130_fd_sc_hd__decap_3
XFILLER_1_214 VGND VGND VPWR VPWR sky130_fd_sc_hd__decap_3
XFILLER_46_1315 VGND VGND VPWR VPWR sky130_fd_sc_hd__fill_1
XFILLER_1_225 VGND VGND VPWR VPWR sky130_fd_sc_hd__decap_3
XTAP_TAPCELL_ROW_57_1674 VGND VPWR sky130_fd_sc_hd__tapvpwrvgnd_1
XFILLER_46_1326 VGND VGND VPWR VPWR sky130_fd_sc_hd__decap_3
XTAP_TAPCELL_ROW_57_1685 VGND VPWR sky130_fd_sc_hd__tapvpwrvgnd_1
XFILLER_1_258 VGND VGND VPWR VPWR sky130_fd_sc_hd__decap_3
XFILLER_46_1359 VGND VGND VPWR VPWR sky130_fd_sc_hd__decap_3
XFILLER_77_538 VGND VGND VPWR VPWR sky130_fd_sc_hd__decap_3
XFILLER_66_12 VGND VGND VPWR VPWR sky130_fd_sc_hd__decap_3
XFILLER_44_1061 VGND VGND VPWR VPWR sky130_fd_sc_hd__decap_3
XFILLER_58_763 VGND VGND VPWR VPWR sky130_fd_sc_hd__decap_3
XFILLER_58_774 VGND VGND VPWR VPWR sky130_fd_sc_hd__decap_3
Xhold1250 _6808_/Q VGND VGND VPWR VPWR _5765_/A1 sky130_fd_sc_hd__dlygate4sd3_1
XFILLER_46_925 VGND VGND VPWR VPWR sky130_fd_sc_hd__decap_3
XFILLER_45_402 VGND VGND VPWR VPWR sky130_fd_sc_hd__decap_3
Xhold1261 _6783_/Q VGND VGND VPWR VPWR _5737_/A1 sky130_fd_sc_hd__dlygate4sd3_1
XFILLER_79_1124 VGND VGND VPWR VPWR sky130_fd_sc_hd__decap_3
Xhold1272 _6690_/Q VGND VGND VPWR VPWR _5631_/A1 sky130_fd_sc_hd__dlygate4sd3_1
Xhold1283 _5957_/X VGND VGND VPWR VPWR _6961_/D sky130_fd_sc_hd__dlygate4sd3_1
XFILLER_79_1157 VGND VGND VPWR VPWR sky130_fd_sc_hd__decap_3
XFILLER_46_969 VGND VGND VPWR VPWR sky130_fd_sc_hd__decap_3
Xhold1294 _6843_/Q VGND VGND VPWR VPWR _5825_/A1 sky130_fd_sc_hd__dlygate4sd3_1
XFILLER_73_755 VGND VGND VPWR VPWR sky130_fd_sc_hd__decap_3
XFILLER_2_1453 VGND VGND VPWR VPWR sky130_fd_sc_hd__decap_3
XFILLER_61_906 VGND VGND VPWR VPWR sky130_fd_sc_hd__decap_3
XFILLER_72_265 VGND VGND VPWR VPWR sky130_fd_sc_hd__fill_2
XFILLER_26_660 VGND VGND VPWR VPWR sky130_fd_sc_hd__decap_3
XFILLER_57_1422 VGND VGND VPWR VPWR sky130_fd_sc_hd__decap_3
XFILLER_60_438 VGND VGND VPWR VPWR sky130_fd_sc_hd__decap_3
XFILLER_18_1406 VGND VGND VPWR VPWR sky130_fd_sc_hd__decap_3
XFILLER_57_1455 VGND VGND VPWR VPWR sky130_fd_sc_hd__fill_1
Xclkbuf_leaf_52_clk clkload5/A VGND VGND VPWR VPWR _6987_/CLK sky130_fd_sc_hd__clkbuf_8
XFILLER_57_1466 VGND VGND VPWR VPWR sky130_fd_sc_hd__decap_3
XFILLER_53_1319 VGND VGND VPWR VPWR sky130_fd_sc_hd__decap_3
XFILLER_14_899 VGND VGND VPWR VPWR sky130_fd_sc_hd__fill_2
XFILLER_41_696 VGND VGND VPWR VPWR sky130_fd_sc_hd__decap_3
XFILLER_16_1163 VGND VGND VPWR VPWR sky130_fd_sc_hd__decap_3
XFILLER_51_1076 VGND VGND VPWR VPWR sky130_fd_sc_hd__fill_2
XFILLER_63_9 VGND VGND VPWR VPWR sky130_fd_sc_hd__decap_3
XFILLER_5_520 VGND VGND VPWR VPWR sky130_fd_sc_hd__decap_3
XFILLER_31_70 VGND VGND VPWR VPWR sky130_fd_sc_hd__fill_2
XFILLER_31_81 VGND VGND VPWR VPWR sky130_fd_sc_hd__fill_1
XFILLER_5_564 VGND VGND VPWR VPWR sky130_fd_sc_hd__decap_3
XFILLER_5_597 VGND VGND VPWR VPWR sky130_fd_sc_hd__fill_1
XFILLER_64_1415 VGND VGND VPWR VPWR sky130_fd_sc_hd__decap_3
XFILLER_68_505 VGND VGND VPWR VPWR sky130_fd_sc_hd__fill_1
XFILLER_64_1459 VGND VGND VPWR VPWR sky130_fd_sc_hd__decap_3
XFILLER_7_1331 VGND VGND VPWR VPWR sky130_fd_sc_hd__decap_3
XFILLER_27_1281 VGND VGND VPWR VPWR sky130_fd_sc_hd__decap_3
XFILLER_49_741 VGND VGND VPWR VPWR sky130_fd_sc_hd__decap_3
XFILLER_27_1292 VGND VGND VPWR VPWR sky130_fd_sc_hd__decap_3
XFILLER_37_903 VGND VGND VPWR VPWR sky130_fd_sc_hd__decap_3
XFILLER_7_1375 VGND VGND VPWR VPWR sky130_fd_sc_hd__decap_3
XFILLER_49_774 VGND VGND VPWR VPWR sky130_fd_sc_hd__fill_1
XFILLER_3_1228 VGND VGND VPWR VPWR sky130_fd_sc_hd__decap_3
XFILLER_48_262 VGND VGND VPWR VPWR sky130_fd_sc_hd__fill_2
XFILLER_3_1239 VGND VGND VPWR VPWR sky130_fd_sc_hd__decap_3
XFILLER_49_796 VGND VGND VPWR VPWR sky130_fd_sc_hd__decap_3
XFILLER_36_435 VGND VGND VPWR VPWR sky130_fd_sc_hd__fill_1
XFILLER_64_777 VGND VGND VPWR VPWR sky130_fd_sc_hd__decap_3
X_4981_ _6387_/Q _5231_/B VGND VGND VPWR VPWR _4981_/X sky130_fd_sc_hd__or2_2
XFILLER_23_107 VGND VGND VPWR VPWR sky130_fd_sc_hd__decap_3
XTAP_TAPCELL_ROW_19_688 VGND VPWR sky130_fd_sc_hd__tapvpwrvgnd_1
XTAP_TAPCELL_ROW_19_699 VGND VPWR sky130_fd_sc_hd__tapvpwrvgnd_1
XFILLER_23_129 VGND VGND VPWR VPWR sky130_fd_sc_hd__decap_3
X_3932_ _4258_/A _3932_/B VGND VGND VPWR VPWR _4095_/B sky130_fd_sc_hd__xnor2_2
X_6720_ _6752_/CLK _6720_/D load_slew669/X VGND VGND VPWR VPWR _6720_/Q sky130_fd_sc_hd__dfrtp_2
XFILLER_51_449 VGND VGND VPWR VPWR sky130_fd_sc_hd__decap_3
Xclkbuf_leaf_43_clk clkbuf_leaf_47_clk/A VGND VGND VPWR VPWR _6999_/CLK sky130_fd_sc_hd__clkbuf_8
XFILLER_71_1419 VGND VGND VPWR VPWR sky130_fd_sc_hd__decap_3
X_6651_ _6807_/CLK _6651_/D fanout787/X VGND VGND VPWR VPWR _6651_/Q sky130_fd_sc_hd__dfrtp_2
XFILLER_31_140 VGND VGND VPWR VPWR sky130_fd_sc_hd__decap_3
X_3863_ _6227_/Q _3960_/B _3921_/B1 _6219_/Q _3921_/C1 VGND VGND VPWR VPWR _3863_/X
+ sky130_fd_sc_hd__a221o_2
X_5602_ _5607_/A1 _5607_/A2 _5602_/B1 VGND VGND VPWR VPWR _5602_/Y sky130_fd_sc_hd__a21oi_4
XFILLER_34_1230 VGND VGND VPWR VPWR sky130_fd_sc_hd__decap_3
X_6582_ _7024_/CLK _6582_/D load_slew658/X VGND VGND VPWR VPWR _6582_/Q sky130_fd_sc_hd__dfrtp_2
X_3794_ _3888_/A _3888_/B _3794_/C VGND VGND VPWR VPWR _3796_/A sky130_fd_sc_hd__and3_2
XFILLER_20_869 VGND VGND VPWR VPWR sky130_fd_sc_hd__fill_2
X_5533_ _6615_/Q _3097_/B _5534_/B1 _5534_/A1 VGND VGND VPWR VPWR _6616_/D sky130_fd_sc_hd__a22o_2
XFILLER_34_1285 VGND VGND VPWR VPWR sky130_fd_sc_hd__decap_3
XFILLER_9_892 VGND VGND VPWR VPWR sky130_fd_sc_hd__decap_3
XFILLER_69_1304 VGND VGND VPWR VPWR sky130_fd_sc_hd__decap_3
XFILLER_11_18 VGND VGND VPWR VPWR sky130_fd_sc_hd__decap_3
XFILLER_30_1149 VGND VGND VPWR VPWR sky130_fd_sc_hd__decap_3
XFILLER_69_1337 VGND VGND VPWR VPWR sky130_fd_sc_hd__decap_3
X_5464_ _5464_/A1 _5464_/A2 _4788_/X VGND VGND VPWR VPWR _6576_/D sky130_fd_sc_hd__a21o_2
XFILLER_69_1348 VGND VGND VPWR VPWR sky130_fd_sc_hd__decap_3
X_4415_ _4771_/C1 _4412_/X _4413_/Y _4414_/X _4597_/A VGND VGND VPWR VPWR _4415_/X
+ sky130_fd_sc_hd__o221a_2
X_5395_ _5395_/A1 _5456_/A2 _4390_/X VGND VGND VPWR VPWR _6507_/D sky130_fd_sc_hd__a21o_2
X_4346_ _4444_/A _4345_/X _4267_/X _6495_/Q VGND VGND VPWR VPWR _4346_/X sky130_fd_sc_hd__a2bb2o_2
Xfanout304 _3743_/X VGND VGND VPWR VPWR fanout304/X sky130_fd_sc_hd__clkdlybuf4s25_1
XFILLER_8_1117 VGND VGND VPWR VPWR sky130_fd_sc_hd__decap_3
Xfanout315 _4261_/A2 VGND VGND VPWR VPWR _3483_/A sky130_fd_sc_hd__clkdlybuf4s25_1
XFILLER_59_505 VGND VGND VPWR VPWR sky130_fd_sc_hd__fill_1
Xfanout326 _5501_/Y VGND VGND VPWR VPWR _5502_/D sky130_fd_sc_hd__clkdlybuf4s25_1
Xfanout348 _3903_/A2 VGND VGND VPWR VPWR _3897_/A2 sky130_fd_sc_hd__clkdlybuf4s25_1
X_7065_ _7065_/CLK _7065_/D load_slew736/X VGND VGND VPWR VPWR _7065_/Q sky130_fd_sc_hd__dfrtp_2
XFILLER_28_1089 VGND VGND VPWR VPWR sky130_fd_sc_hd__decap_3
X_4277_ _4394_/A _4277_/B _4562_/C VGND VGND VPWR VPWR _4277_/X sky130_fd_sc_hd__and3_2
Xfanout359 _5610_/A1 VGND VGND VPWR VPWR _5607_/A2 sky130_fd_sc_hd__clkdlybuf4s25_1
XTAP_TAPCELL_ROW_52_1560 VGND VPWR sky130_fd_sc_hd__tapvpwrvgnd_1
XFILLER_80_1261 VGND VGND VPWR VPWR sky130_fd_sc_hd__decap_3
XFILLER_45_1381 VGND VGND VPWR VPWR sky130_fd_sc_hd__decap_3
X_6016_ hold878/X _7020_/Q _6048_/S VGND VGND VPWR VPWR _6016_/X sky130_fd_sc_hd__mux2_1
XFILLER_39_240 VGND VGND VPWR VPWR sky130_fd_sc_hd__decap_3
X_3228_ _6249_/Q _6345_/Q VGND VGND VPWR VPWR _3228_/X sky130_fd_sc_hd__xor2_2
XFILLER_41_1245 VGND VGND VPWR VPWR sky130_fd_sc_hd__decap_3
XFILLER_55_700 VGND VGND VPWR VPWR sky130_fd_sc_hd__decap_3
XFILLER_27_402 VGND VGND VPWR VPWR sky130_fd_sc_hd__decap_3
XFILLER_39_262 VGND VGND VPWR VPWR sky130_fd_sc_hd__fill_1
XFILLER_39_284 VGND VGND VPWR VPWR sky130_fd_sc_hd__decap_3
XFILLER_41_1278 VGND VGND VPWR VPWR sky130_fd_sc_hd__decap_3
XFILLER_41_1289 VGND VGND VPWR VPWR sky130_fd_sc_hd__decap_3
X_3159_ _6997_/Q _3108_/A _3205_/B1 _3158_/X VGND VGND VPWR VPWR _3160_/C sky130_fd_sc_hd__a211o_2
XFILLER_55_788 VGND VGND VPWR VPWR sky130_fd_sc_hd__fill_2
XFILLER_42_427 VGND VGND VPWR VPWR sky130_fd_sc_hd__decap_3
XFILLER_54_298 VGND VGND VPWR VPWR sky130_fd_sc_hd__decap_3
X_6918_ _6918_/CLK _6918_/D load_slew742/X VGND VGND VPWR VPWR _6918_/Q sky130_fd_sc_hd__dfrtp_2
XFILLER_74_1043 VGND VGND VPWR VPWR sky130_fd_sc_hd__decap_3
XFILLER_70_769 VGND VGND VPWR VPWR sky130_fd_sc_hd__fill_2
Xclkbuf_leaf_34_clk clkbuf_leaf_56_clk/A VGND VGND VPWR VPWR _7025_/CLK sky130_fd_sc_hd__clkbuf_8
XFILLER_35_1005 VGND VGND VPWR VPWR sky130_fd_sc_hd__decap_3
XFILLER_51_961 VGND VGND VPWR VPWR sky130_fd_sc_hd__decap_3
XFILLER_23_663 VGND VGND VPWR VPWR sky130_fd_sc_hd__fill_1
XFILLER_74_1076 VGND VGND VPWR VPWR sky130_fd_sc_hd__decap_3
XFILLER_11_825 VGND VGND VPWR VPWR sky130_fd_sc_hd__decap_3
XTAP_TAPCELL_ROW_46_1386 VGND VPWR sky130_fd_sc_hd__tapvpwrvgnd_1
X_6849_ _6913_/CLK _6849_/D load_slew728/X VGND VGND VPWR VPWR _6849_/Q sky130_fd_sc_hd__dfrtp_2
XFILLER_10_302 VGND VGND VPWR VPWR sky130_fd_sc_hd__decap_3
XTAP_TAPCELL_ROW_46_1397 VGND VPWR sky130_fd_sc_hd__tapvpwrvgnd_1
XFILLER_23_696 VGND VGND VPWR VPWR sky130_fd_sc_hd__decap_3
XFILLER_10_335 VGND VGND VPWR VPWR sky130_fd_sc_hd__decap_3
XFILLER_52_1341 VGND VGND VPWR VPWR sky130_fd_sc_hd__decap_3
Xwire738 wire738/A VGND VGND VPWR VPWR wire738/X sky130_fd_sc_hd__clkbuf_4
XFILLER_13_1325 VGND VGND VPWR VPWR sky130_fd_sc_hd__decap_3
XFILLER_10_368 VGND VGND VPWR VPWR sky130_fd_sc_hd__decap_3
XFILLER_52_1385 VGND VGND VPWR VPWR sky130_fd_sc_hd__decap_3
XFILLER_13_1369 VGND VGND VPWR VPWR sky130_fd_sc_hd__decap_3
XTAP_TAPCELL_ROW_59_1725 VGND VPWR sky130_fd_sc_hd__tapvpwrvgnd_1
XTAP_TAPCELL_ROW_59_1736 VGND VPWR sky130_fd_sc_hd__tapvpwrvgnd_1
XTAP_TAPCELL_ROW_59_1747 VGND VPWR sky130_fd_sc_hd__tapvpwrvgnd_1
XFILLER_11_1093 VGND VGND VPWR VPWR sky130_fd_sc_hd__decap_3
XFILLER_7_3 VGND VGND VPWR VPWR sky130_fd_sc_hd__decap_3
XFILLER_77_33 VGND VGND VPWR VPWR sky130_fd_sc_hd__decap_3
XFILLER_46_1178 VGND VGND VPWR VPWR sky130_fd_sc_hd__fill_1
XFILLER_77_66 VGND VGND VPWR VPWR sky130_fd_sc_hd__decap_3
XFILLER_78_869 VGND VGND VPWR VPWR sky130_fd_sc_hd__decap_3
XFILLER_24_1421 VGND VGND VPWR VPWR sky130_fd_sc_hd__decap_3
XFILLER_24_1432 VGND VGND VPWR VPWR sky130_fd_sc_hd__decap_3
XFILLER_19_903 VGND VGND VPWR VPWR sky130_fd_sc_hd__decap_3
XFILLER_65_508 VGND VGND VPWR VPWR sky130_fd_sc_hd__fill_1
XFILLER_24_1465 VGND VGND VPWR VPWR sky130_fd_sc_hd__decap_3
XFILLER_19_936 VGND VGND VPWR VPWR sky130_fd_sc_hd__decap_3
XFILLER_58_571 VGND VGND VPWR VPWR sky130_fd_sc_hd__fill_2
XFILLER_46_722 VGND VGND VPWR VPWR sky130_fd_sc_hd__decap_3
XFILLER_18_424 VGND VGND VPWR VPWR sky130_fd_sc_hd__fill_1
XFILLER_20_1329 VGND VGND VPWR VPWR sky130_fd_sc_hd__decap_3
XFILLER_18_446 VGND VGND VPWR VPWR sky130_fd_sc_hd__decap_3
XTAP_TAPCELL_ROW_29_942 VGND VPWR sky130_fd_sc_hd__tapvpwrvgnd_1
Xhold1080 _6781_/Q VGND VGND VPWR VPWR _5735_/A1 sky130_fd_sc_hd__dlygate4sd3_1
XTAP_TAPCELL_ROW_29_953 VGND VPWR sky130_fd_sc_hd__tapvpwrvgnd_1
Xhold1091 _6964_/Q VGND VGND VPWR VPWR _5960_/A1 sky130_fd_sc_hd__dlygate4sd3_1
XFILLER_46_766 VGND VGND VPWR VPWR sky130_fd_sc_hd__decap_3
XFILLER_2_1250 VGND VGND VPWR VPWR sky130_fd_sc_hd__decap_3
XTAP_TAPCELL_ROW_29_964 VGND VPWR sky130_fd_sc_hd__tapvpwrvgnd_1
XFILLER_2_1261 VGND VGND VPWR VPWR sky130_fd_sc_hd__decap_3
XFILLER_33_405 VGND VGND VPWR VPWR sky130_fd_sc_hd__decap_3
XFILLER_46_799 VGND VGND VPWR VPWR sky130_fd_sc_hd__fill_2
XFILLER_61_725 VGND VGND VPWR VPWR sky130_fd_sc_hd__decap_3
XFILLER_73_585 VGND VGND VPWR VPWR sky130_fd_sc_hd__decap_3
XTAP_TAPCELL_ROW_16_614 VGND VPWR sky130_fd_sc_hd__tapvpwrvgnd_1
XFILLER_2_1294 VGND VGND VPWR VPWR sky130_fd_sc_hd__decap_3
XTAP_TAPCELL_ROW_16_625 VGND VPWR sky130_fd_sc_hd__tapvpwrvgnd_1
XFILLER_45_298 VGND VGND VPWR VPWR sky130_fd_sc_hd__decap_3
XFILLER_33_449 VGND VGND VPWR VPWR sky130_fd_sc_hd__decap_3
XFILLER_18_1203 VGND VGND VPWR VPWR sky130_fd_sc_hd__fill_1
Xclkbuf_leaf_25_clk clkload3/A VGND VGND VPWR VPWR _7000_/CLK sky130_fd_sc_hd__clkbuf_8
XFILLER_18_1214 VGND VGND VPWR VPWR sky130_fd_sc_hd__decap_3
XFILLER_57_1263 VGND VGND VPWR VPWR sky130_fd_sc_hd__decap_3
XFILLER_42_961 VGND VGND VPWR VPWR sky130_fd_sc_hd__decap_3
XFILLER_14_663 VGND VGND VPWR VPWR sky130_fd_sc_hd__decap_3
XFILLER_13_151 VGND VGND VPWR VPWR sky130_fd_sc_hd__decap_3
XFILLER_18_1247 VGND VGND VPWR VPWR sky130_fd_sc_hd__decap_3
XFILLER_9_111 VGND VGND VPWR VPWR sky130_fd_sc_hd__fill_1
XFILLER_13_184 VGND VGND VPWR VPWR sky130_fd_sc_hd__fill_2
XFILLER_70_1441 VGND VGND VPWR VPWR sky130_fd_sc_hd__decap_3
XFILLER_9_166 VGND VGND VPWR VPWR sky130_fd_sc_hd__fill_2
XFILLER_31_1425 VGND VGND VPWR VPWR sky130_fd_sc_hd__decap_3
XFILLER_42_80 VGND VGND VPWR VPWR sky130_fd_sc_hd__decap_3
XFILLER_42_91 VGND VGND VPWR VPWR sky130_fd_sc_hd__decap_3
XFILLER_61_6 VGND VGND VPWR VPWR sky130_fd_sc_hd__decap_3
XFILLER_29_1310 VGND VGND VPWR VPWR sky130_fd_sc_hd__decap_3
XFILLER_9_1404 VGND VGND VPWR VPWR sky130_fd_sc_hd__decap_3
X_4200_ _4200_/A _4230_/B VGND VGND VPWR VPWR _4271_/A sky130_fd_sc_hd__xnor2_2
XFILLER_29_1343 VGND VGND VPWR VPWR sky130_fd_sc_hd__fill_1
XFILLER_64_1223 VGND VGND VPWR VPWR sky130_fd_sc_hd__decap_3
X_5180_ _6737_/Q _5338_/S VGND VGND VPWR VPWR _5180_/X sky130_fd_sc_hd__or2_2
XFILLER_29_1354 VGND VGND VPWR VPWR sky130_fd_sc_hd__decap_3
XFILLER_9_1437 VGND VGND VPWR VPWR sky130_fd_sc_hd__decap_3
XFILLER_3_30 VGND VGND VPWR VPWR sky130_fd_sc_hd__decap_3
XFILLER_64_1256 VGND VGND VPWR VPWR sky130_fd_sc_hd__decap_3
XPHY_EDGE_ROW_79_Left_160 VGND VGND VPWR VPWR sky130_fd_sc_hd__decap_3
XFILLER_29_1387 VGND VGND VPWR VPWR sky130_fd_sc_hd__decap_3
X_4131_ _4292_/B _4131_/B VGND VGND VPWR VPWR _4132_/B sky130_fd_sc_hd__xnor2_2
XFILLER_64_1267 VGND VGND VPWR VPWR sky130_fd_sc_hd__decap_3
XFILLER_25_1229 VGND VGND VPWR VPWR sky130_fd_sc_hd__decap_3
XFILLER_69_858 VGND VGND VPWR VPWR sky130_fd_sc_hd__decap_3
XFILLER_3_63 VGND VGND VPWR VPWR sky130_fd_sc_hd__decap_3
XFILLER_68_368 VGND VGND VPWR VPWR sky130_fd_sc_hd__fill_1
X_4062_ _3466_/X _4080_/A2 _4080_/B1 _6930_/Q _4080_/C1 VGND VGND VPWR VPWR _4062_/X
+ sky130_fd_sc_hd__a221o_2
XFILLER_3_96 VGND VGND VPWR VPWR sky130_fd_sc_hd__decap_3
XFILLER_7_1172 VGND VGND VPWR VPWR sky130_fd_sc_hd__decap_3
XFILLER_37_711 VGND VGND VPWR VPWR sky130_fd_sc_hd__decap_3
XFILLER_7_1183 VGND VGND VPWR VPWR sky130_fd_sc_hd__decap_3
XFILLER_3_1036 VGND VGND VPWR VPWR sky130_fd_sc_hd__decap_3
XFILLER_36_221 VGND VGND VPWR VPWR sky130_fd_sc_hd__decap_3
XFILLER_36_232 VGND VGND VPWR VPWR sky130_fd_sc_hd__decap_3
Xwire25 wire25/A VGND VGND VPWR VPWR wire25/X sky130_fd_sc_hd__buf_4
XFILLER_37_777 VGND VGND VPWR VPWR sky130_fd_sc_hd__decap_3
Xwire36 wire36/A VGND VGND VPWR VPWR wire36/X sky130_fd_sc_hd__clkbuf_4
XFILLER_64_563 VGND VGND VPWR VPWR sky130_fd_sc_hd__decap_3
XFILLER_36_265 VGND VGND VPWR VPWR sky130_fd_sc_hd__decap_3
Xwire69 wire69/A VGND VGND VPWR VPWR wire69/X sky130_fd_sc_hd__buf_2
XFILLER_24_438 VGND VGND VPWR VPWR sky130_fd_sc_hd__decap_3
XFILLER_36_298 VGND VGND VPWR VPWR sky130_fd_sc_hd__fill_2
XFILLER_52_747 VGND VGND VPWR VPWR sky130_fd_sc_hd__decap_3
X_4964_ _6352_/Q _4963_/X _4964_/S VGND VGND VPWR VPWR _6352_/D sky130_fd_sc_hd__mux2_1
XFILLER_33_950 VGND VGND VPWR VPWR sky130_fd_sc_hd__fill_2
XFILLER_36_1303 VGND VGND VPWR VPWR sky130_fd_sc_hd__decap_3
Xclkbuf_leaf_16_clk clkbuf_4_4__f_clk/X VGND VGND VPWR VPWR _6970_/CLK sky130_fd_sc_hd__clkbuf_8
XFILLER_75_1363 VGND VGND VPWR VPWR sky130_fd_sc_hd__decap_3
XFILLER_33_961 VGND VGND VPWR VPWR sky130_fd_sc_hd__decap_3
XFILLER_51_268 VGND VGND VPWR VPWR sky130_fd_sc_hd__decap_3
XFILLER_71_1216 VGND VGND VPWR VPWR sky130_fd_sc_hd__decap_3
X_6703_ _7054_/CLK _6703_/D load_slew757/X VGND VGND VPWR VPWR _6703_/Q sky130_fd_sc_hd__dfrtp_2
X_3915_ _3915_/A _3915_/B VGND VGND VPWR VPWR _3915_/X sky130_fd_sc_hd__or2_2
XFILLER_20_600 VGND VGND VPWR VPWR sky130_fd_sc_hd__fill_1
XFILLER_75_1396 VGND VGND VPWR VPWR sky130_fd_sc_hd__decap_3
X_4895_ _6591_/Q _4894_/A _4896_/A1 VGND VGND VPWR VPWR _4895_/X sky130_fd_sc_hd__a21bo_2
XFILLER_36_1347 VGND VGND VPWR VPWR sky130_fd_sc_hd__decap_3
X_6634_ _6954_/CLK _6634_/D load_slew650/X VGND VGND VPWR VPWR _6634_/Q sky130_fd_sc_hd__dfrtp_2
X_3846_ _6323_/Q _4829_/A _3844_/X _3845_/X VGND VGND VPWR VPWR _4222_/A sky130_fd_sc_hd__o22a_2
XFILLER_20_655 VGND VGND VPWR VPWR sky130_fd_sc_hd__decap_3
XTAP_TAPCELL_ROW_41_1261 VGND VPWR sky130_fd_sc_hd__tapvpwrvgnd_1
XFILLER_34_1082 VGND VGND VPWR VPWR sky130_fd_sc_hd__decap_3
XFILLER_34_1093 VGND VGND VPWR VPWR sky130_fd_sc_hd__decap_3
X_3777_ _3927_/A_N _6313_/Q VGND VGND VPWR VPWR _3777_/X sky130_fd_sc_hd__and2b_2
XTAP_TAPCELL_ROW_41_1272 VGND VPWR sky130_fd_sc_hd__tapvpwrvgnd_1
X_6565_ _6999_/CLK _6565_/D load_slew786/X VGND VGND VPWR VPWR _6565_/Q sky130_fd_sc_hd__dfrtp_2
X_5516_ _3098_/A _5359_/C _6608_/Q VGND VGND VPWR VPWR _6608_/D sky130_fd_sc_hd__mux2_1
X_6496_ _7090_/CLK _6496_/D fanout716/X VGND VGND VPWR VPWR _6496_/Q sky130_fd_sc_hd__dfrtp_2
XFILLER_69_1156 VGND VGND VPWR VPWR sky130_fd_sc_hd__decap_3
XFILLER_12_1391 VGND VGND VPWR VPWR sky130_fd_sc_hd__decap_3
X_5447_ _5447_/A1 _5479_/A2 _4719_/X VGND VGND VPWR VPWR _6559_/D sky130_fd_sc_hd__a21o_2
XFILLER_47_1410 VGND VGND VPWR VPWR sky130_fd_sc_hd__decap_3
XTAP_TAPCELL_ROW_54_1600 VGND VPWR sky130_fd_sc_hd__tapvpwrvgnd_1
XFILLER_69_1189 VGND VGND VPWR VPWR sky130_fd_sc_hd__decap_3
XTAP_TAPCELL_ROW_54_1611 VGND VPWR sky130_fd_sc_hd__tapvpwrvgnd_1
XFILLER_47_1443 VGND VGND VPWR VPWR sky130_fd_sc_hd__decap_3
X_5378_ _5378_/A1 _5477_/A2 _4296_/X VGND VGND VPWR VPWR _6490_/D sky130_fd_sc_hd__a21o_2
Xfanout101 _5248_/A2 VGND VGND VPWR VPWR _5151_/A2 sky130_fd_sc_hd__clkdlybuf4s25_1
XFILLER_43_1307 VGND VGND VPWR VPWR sky130_fd_sc_hd__decap_3
Xfanout134 wire137/A VGND VGND VPWR VPWR _5286_/B1 sky130_fd_sc_hd__clkdlybuf4s25_1
X_4329_ _4283_/A _4703_/B _4796_/A VGND VGND VPWR VPWR _4329_/Y sky130_fd_sc_hd__a21oi_2
XTAP_TAPCELL_ROW_50_1508 VGND VPWR sky130_fd_sc_hd__tapvpwrvgnd_1
XFILLER_59_335 VGND VGND VPWR VPWR sky130_fd_sc_hd__fill_1
XFILLER_59_357 VGND VGND VPWR VPWR sky130_fd_sc_hd__decap_3
X_7048_ _7048_/CLK _7048_/D load_slew658/X VGND VGND VPWR VPWR _7048_/Q sky130_fd_sc_hd__dfrtp_2
XTAP_TAPCELL_ROW_35_1098 VGND VPWR sky130_fd_sc_hd__tapvpwrvgnd_1
Xfanout178 _3447_/S VGND VGND VPWR VPWR _3355_/S sky130_fd_sc_hd__clkdlybuf4s25_1
XFILLER_74_305 VGND VGND VPWR VPWR sky130_fd_sc_hd__decap_3
XFILLER_41_1020 VGND VGND VPWR VPWR sky130_fd_sc_hd__decap_3
XFILLER_59_379 VGND VGND VPWR VPWR sky130_fd_sc_hd__fill_1
XFILLER_80_1080 VGND VGND VPWR VPWR sky130_fd_sc_hd__decap_3
XFILLER_74_338 VGND VGND VPWR VPWR sky130_fd_sc_hd__decap_3
XFILLER_28_766 VGND VGND VPWR VPWR sky130_fd_sc_hd__fill_2
XFILLER_76_1105 VGND VGND VPWR VPWR sky130_fd_sc_hd__decap_3
XFILLER_16_928 VGND VGND VPWR VPWR sky130_fd_sc_hd__fill_2
XFILLER_43_725 VGND VGND VPWR VPWR sky130_fd_sc_hd__decap_3
XTAP_TAPCELL_ROW_48_1437 VGND VPWR sky130_fd_sc_hd__tapvpwrvgnd_1
XFILLER_76_1138 VGND VGND VPWR VPWR sky130_fd_sc_hd__decap_3
XFILLER_15_427 VGND VGND VPWR VPWR sky130_fd_sc_hd__decap_3
XFILLER_76_1149 VGND VGND VPWR VPWR sky130_fd_sc_hd__decap_3
XTAP_TAPCELL_ROW_48_1448 VGND VPWR sky130_fd_sc_hd__tapvpwrvgnd_1
XFILLER_70_533 VGND VGND VPWR VPWR sky130_fd_sc_hd__fill_1
XFILLER_15_438 VGND VGND VPWR VPWR sky130_fd_sc_hd__fill_1
XTAP_TAPCELL_ROW_48_1459 VGND VPWR sky130_fd_sc_hd__tapvpwrvgnd_1
XFILLER_42_246 VGND VGND VPWR VPWR sky130_fd_sc_hd__decap_3
XFILLER_54_1403 VGND VGND VPWR VPWR sky130_fd_sc_hd__decap_3
XFILLER_70_566 VGND VGND VPWR VPWR sky130_fd_sc_hd__decap_3
XFILLER_63_79 VGND VGND VPWR VPWR sky130_fd_sc_hd__fill_2
XFILLER_42_279 VGND VGND VPWR VPWR sky130_fd_sc_hd__decap_3
XFILLER_11_611 VGND VGND VPWR VPWR sky130_fd_sc_hd__decap_3
XFILLER_54_1447 VGND VGND VPWR VPWR sky130_fd_sc_hd__decap_3
XFILLER_51_791 VGND VGND VPWR VPWR sky130_fd_sc_hd__decap_3
XFILLER_50_290 VGND VGND VPWR VPWR sky130_fd_sc_hd__fill_1
XFILLER_7_615 VGND VGND VPWR VPWR sky130_fd_sc_hd__fill_1
XFILLER_13_1133 VGND VGND VPWR VPWR sky130_fd_sc_hd__decap_3
XFILLER_52_1182 VGND VGND VPWR VPWR sky130_fd_sc_hd__decap_3
XFILLER_13_1177 VGND VGND VPWR VPWR sky130_fd_sc_hd__fill_2
XFILLER_12_72 VGND VGND VPWR VPWR sky130_fd_sc_hd__decap_3
XFILLER_3_821 VGND VGND VPWR VPWR sky130_fd_sc_hd__decap_3
XFILLER_3_865 VGND VGND VPWR VPWR sky130_fd_sc_hd__decap_3
XFILLER_2_342 VGND VGND VPWR VPWR sky130_fd_sc_hd__decap_3
Xload_slew529 _5194_/B VGND VGND VPWR VPWR _5342_/S sky130_fd_sc_hd__clkbuf_4
XFILLER_61_1407 VGND VGND VPWR VPWR sky130_fd_sc_hd__decap_3
XFILLER_2_386 VGND VGND VPWR VPWR sky130_fd_sc_hd__decap_3
XFILLER_26_9 VGND VGND VPWR VPWR sky130_fd_sc_hd__fill_2
XFILLER_77_154 VGND VGND VPWR VPWR sky130_fd_sc_hd__decap_3
XFILLER_77_165 VGND VGND VPWR VPWR sky130_fd_sc_hd__decap_3
XFILLER_4_1312 VGND VGND VPWR VPWR sky130_fd_sc_hd__decap_3
XFILLER_4_1323 VGND VGND VPWR VPWR sky130_fd_sc_hd__decap_3
XFILLER_24_1273 VGND VGND VPWR VPWR sky130_fd_sc_hd__decap_3
XFILLER_4_1356 VGND VGND VPWR VPWR sky130_fd_sc_hd__decap_3
XFILLER_20_1137 VGND VGND VPWR VPWR sky130_fd_sc_hd__decap_3
XFILLER_74_872 VGND VGND VPWR VPWR sky130_fd_sc_hd__decap_3
XFILLER_59_1325 VGND VGND VPWR VPWR sky130_fd_sc_hd__decap_3
XFILLER_34_714 VGND VGND VPWR VPWR sky130_fd_sc_hd__decap_3
XFILLER_18_276 VGND VGND VPWR VPWR sky130_fd_sc_hd__decap_3
XFILLER_33_213 VGND VGND VPWR VPWR sky130_fd_sc_hd__fill_1
XFILLER_73_393 VGND VGND VPWR VPWR sky130_fd_sc_hd__decap_3
XFILLER_59_1369 VGND VGND VPWR VPWR sky130_fd_sc_hd__decap_3
XFILLER_2_1091 VGND VGND VPWR VPWR sky130_fd_sc_hd__fill_1
XFILLER_15_972 VGND VGND VPWR VPWR sky130_fd_sc_hd__fill_1
XFILLER_21_408 VGND VGND VPWR VPWR sky130_fd_sc_hd__decap_3
XFILLER_57_1060 VGND VGND VPWR VPWR sky130_fd_sc_hd__decap_3
XFILLER_57_1071 VGND VGND VPWR VPWR sky130_fd_sc_hd__fill_1
XFILLER_15_994 VGND VGND VPWR VPWR sky130_fd_sc_hd__fill_2
XFILLER_30_920 VGND VGND VPWR VPWR sky130_fd_sc_hd__decap_3
XFILLER_57_1093 VGND VGND VPWR VPWR sky130_fd_sc_hd__fill_1
X_3700_ _3829_/A _3762_/A VGND VGND VPWR VPWR _3701_/B sky130_fd_sc_hd__xor2_2
X_4680_ _4694_/B _4289_/X _4665_/X _6554_/Q _4680_/C1 VGND VGND VPWR VPWR _4683_/B
+ sky130_fd_sc_hd__a221o_2
X_3631_ _6618_/Q _3631_/A2 _3630_/X VGND VGND VPWR VPWR _3631_/X sky130_fd_sc_hd__a21o_2
XFILLER_70_1282 VGND VGND VPWR VPWR sky130_fd_sc_hd__decap_3
XFILLER_31_1233 VGND VGND VPWR VPWR sky130_fd_sc_hd__decap_3
X_6350_ _6752_/CLK _6350_/D load_slew669/X VGND VGND VPWR VPWR _6350_/Q sky130_fd_sc_hd__dfrtp_2
X_3562_ _3663_/A _3637_/B VGND VGND VPWR VPWR _3652_/A sky130_fd_sc_hd__xor2_2
XFILLER_31_1266 VGND VGND VPWR VPWR sky130_fd_sc_hd__decap_3
X_5301_ _6443_/Q _5300_/X _5307_/S VGND VGND VPWR VPWR _6443_/D sky130_fd_sc_hd__mux2_1
X_6281_ _7011_/CLK _6281_/D fanout811/X VGND VGND VPWR VPWR _6281_/Q sky130_fd_sc_hd__dfrtp_2
X_3493_ _3601_/A _3550_/B VGND VGND VPWR VPWR _3493_/Y sky130_fd_sc_hd__nor2_2
XFILLER_66_1329 VGND VGND VPWR VPWR sky130_fd_sc_hd__decap_3
X_5232_ _6757_/Q _5332_/S _5333_/S _5231_/Y VGND VGND VPWR VPWR _5232_/X sky130_fd_sc_hd__o211a_2
XFILLER_9_1201 VGND VGND VPWR VPWR sky130_fd_sc_hd__decap_3
Xclkbuf_leaf_5_clk clkload0/A VGND VGND VPWR VPWR _7050_/CLK sky130_fd_sc_hd__clkbuf_8
XFILLER_29_1151 VGND VGND VPWR VPWR sky130_fd_sc_hd__decap_3
XFILLER_69_611 VGND VGND VPWR VPWR sky130_fd_sc_hd__decap_3
XFILLER_25_1004 VGND VGND VPWR VPWR sky130_fd_sc_hd__decap_3
XFILLER_9_1245 VGND VGND VPWR VPWR sky130_fd_sc_hd__decap_3
X_5163_ _6390_/Q _5248_/A2 _5006_/S _5162_/X VGND VGND VPWR VPWR _6390_/D sky130_fd_sc_hd__a22o_2
XFILLER_25_1015 VGND VGND VPWR VPWR sky130_fd_sc_hd__decap_3
XFILLER_68_132 VGND VGND VPWR VPWR sky130_fd_sc_hd__decap_3
XFILLER_9_1278 VGND VGND VPWR VPWR sky130_fd_sc_hd__decap_3
X_4114_ _6472_/Q _4174_/A2 _4109_/X _4113_/Y VGND VGND VPWR VPWR _4114_/X sky130_fd_sc_hd__o211a_2
XFILLER_57_817 VGND VGND VPWR VPWR sky130_fd_sc_hd__decap_3
XFILLER_9_1289 VGND VGND VPWR VPWR sky130_fd_sc_hd__decap_3
X_5094_ _6613_/Q _6653_/Q VGND VGND VPWR VPWR _5095_/B sky130_fd_sc_hd__xnor2_2
XFILLER_42_1362 VGND VGND VPWR VPWR sky130_fd_sc_hd__decap_3
XFILLER_42_1373 VGND VGND VPWR VPWR sky130_fd_sc_hd__decap_3
X_4045_ _6237_/Q _4069_/A2 _4043_/X _4044_/X VGND VGND VPWR VPWR _6237_/D sky130_fd_sc_hd__o22a_2
XFILLER_72_809 VGND VGND VPWR VPWR sky130_fd_sc_hd__decap_3
XFILLER_77_1425 VGND VGND VPWR VPWR sky130_fd_sc_hd__decap_3
XFILLER_37_574 VGND VGND VPWR VPWR sky130_fd_sc_hd__fill_1
XFILLER_65_894 VGND VGND VPWR VPWR sky130_fd_sc_hd__fill_2
XFILLER_38_1409 VGND VGND VPWR VPWR sky130_fd_sc_hd__decap_3
XFILLER_52_533 VGND VGND VPWR VPWR sky130_fd_sc_hd__fill_2
X_5996_ _5996_/A0 _7000_/Q _6052_/S VGND VGND VPWR VPWR _5996_/X sky130_fd_sc_hd__mux2_1
XFILLER_40_717 VGND VGND VPWR VPWR sky130_fd_sc_hd__fill_2
XFILLER_75_1160 VGND VGND VPWR VPWR sky130_fd_sc_hd__decap_3
XFILLER_71_1002 VGND VGND VPWR VPWR sky130_fd_sc_hd__decap_3
XTAP_TAPCELL_ROW_43_1312 VGND VPWR sky130_fd_sc_hd__tapvpwrvgnd_1
XFILLER_40_739 VGND VGND VPWR VPWR sky130_fd_sc_hd__decap_3
XTAP_TAPCELL_ROW_43_1323 VGND VPWR sky130_fd_sc_hd__tapvpwrvgnd_1
X_4947_ _6382_/Q _5216_/B _5075_/A VGND VGND VPWR VPWR _4947_/Y sky130_fd_sc_hd__a21oi_2
XFILLER_21_953 VGND VGND VPWR VPWR sky130_fd_sc_hd__decap_3
X_4878_ _4487_/A _4524_/X _4842_/X _6589_/Q _4880_/C1 VGND VGND VPWR VPWR _4881_/B
+ sky130_fd_sc_hd__a221o_2
X_6617_ _6617_/CLK _6617_/D load_slew732/X VGND VGND VPWR VPWR _6617_/Q sky130_fd_sc_hd__dfrtp_2
X_3829_ _3829_/A _3829_/B VGND VGND VPWR VPWR _3830_/B sky130_fd_sc_hd__xnor2_2
XFILLER_14_1453 VGND VGND VPWR VPWR sky130_fd_sc_hd__decap_3
XFILLER_20_496 VGND VGND VPWR VPWR sky130_fd_sc_hd__decap_3
XFILLER_10_1306 VGND VGND VPWR VPWR sky130_fd_sc_hd__decap_3
XFILLER_10_1317 VGND VGND VPWR VPWR sky130_fd_sc_hd__decap_3
XFILLER_4_607 VGND VGND VPWR VPWR sky130_fd_sc_hd__decap_3
X_6548_ _7022_/CLK _6548_/D load_slew751/X VGND VGND VPWR VPWR _6548_/Q sky130_fd_sc_hd__dfrtp_2
XFILLER_3_128 VGND VGND VPWR VPWR sky130_fd_sc_hd__decap_3
X_6479_ _7057_/CLK _6479_/D load_slew726/X VGND VGND VPWR VPWR _6479_/Q sky130_fd_sc_hd__dfrtp_2
XFILLER_0_813 VGND VGND VPWR VPWR sky130_fd_sc_hd__decap_3
XFILLER_47_1251 VGND VGND VPWR VPWR sky130_fd_sc_hd__decap_3
XFILLER_59_110 VGND VGND VPWR VPWR sky130_fd_sc_hd__fill_2
XFILLER_47_1284 VGND VGND VPWR VPWR sky130_fd_sc_hd__decap_3
XFILLER_47_1295 VGND VGND VPWR VPWR sky130_fd_sc_hd__decap_3
XFILLER_48_806 VGND VGND VPWR VPWR sky130_fd_sc_hd__fill_1
XFILLER_43_1137 VGND VGND VPWR VPWR sky130_fd_sc_hd__decap_3
XFILLER_58_79 VGND VGND VPWR VPWR sky130_fd_sc_hd__decap_3
XFILLER_59_187 VGND VGND VPWR VPWR sky130_fd_sc_hd__fill_1
XFILLER_21_1413 VGND VGND VPWR VPWR sky130_fd_sc_hd__decap_3
XFILLER_60_1462 VGND VGND VPWR VPWR sky130_fd_sc_hd__decap_3
XFILLER_74_12 VGND VGND VPWR VPWR sky130_fd_sc_hd__decap_3
XFILLER_28_530 VGND VGND VPWR VPWR sky130_fd_sc_hd__fill_2
XFILLER_21_1446 VGND VGND VPWR VPWR sky130_fd_sc_hd__decap_3
XFILLER_21_1457 VGND VGND VPWR VPWR sky130_fd_sc_hd__decap_3
XFILLER_56_872 VGND VGND VPWR VPWR sky130_fd_sc_hd__decap_3
XFILLER_74_56 VGND VGND VPWR VPWR sky130_fd_sc_hd__decap_3
XFILLER_15_213 VGND VGND VPWR VPWR sky130_fd_sc_hd__decap_3
XFILLER_55_393 VGND VGND VPWR VPWR sky130_fd_sc_hd__decap_3
XFILLER_71_864 VGND VGND VPWR VPWR sky130_fd_sc_hd__decap_3
XFILLER_16_769 VGND VGND VPWR VPWR sky130_fd_sc_hd__decap_3
XFILLER_54_1200 VGND VGND VPWR VPWR sky130_fd_sc_hd__decap_3
XFILLER_71_897 VGND VGND VPWR VPWR sky130_fd_sc_hd__decap_3
XFILLER_15_279 VGND VGND VPWR VPWR sky130_fd_sc_hd__fill_1
XFILLER_19_1331 VGND VGND VPWR VPWR sky130_fd_sc_hd__decap_3
XFILLER_58_1391 VGND VGND VPWR VPWR sky130_fd_sc_hd__decap_3
XFILLER_70_385 VGND VGND VPWR VPWR sky130_fd_sc_hd__decap_3
XFILLER_30_227 VGND VGND VPWR VPWR sky130_fd_sc_hd__decap_3
XFILLER_54_1244 VGND VGND VPWR VPWR sky130_fd_sc_hd__decap_3
XFILLER_19_1375 VGND VGND VPWR VPWR sky130_fd_sc_hd__decap_3
XFILLER_12_964 VGND VGND VPWR VPWR sky130_fd_sc_hd__fill_2
XFILLER_23_290 VGND VGND VPWR VPWR sky130_fd_sc_hd__decap_3
XFILLER_8_913 VGND VGND VPWR VPWR sky130_fd_sc_hd__decap_3
XFILLER_15_1228 VGND VGND VPWR VPWR sky130_fd_sc_hd__decap_3
XFILLER_12_975 VGND VGND VPWR VPWR sky130_fd_sc_hd__decap_3
XFILLER_15_1239 VGND VGND VPWR VPWR sky130_fd_sc_hd__decap_3
XFILLER_50_1119 VGND VGND VPWR VPWR sky130_fd_sc_hd__decap_3
XFILLER_54_1288 VGND VGND VPWR VPWR sky130_fd_sc_hd__decap_3
XFILLER_12_997 VGND VGND VPWR VPWR sky130_fd_sc_hd__decap_3
XFILLER_11_474 VGND VGND VPWR VPWR sky130_fd_sc_hd__decap_3
XFILLER_7_423 VGND VGND VPWR VPWR sky130_fd_sc_hd__decap_3
XFILLER_11_496 VGND VGND VPWR VPWR sky130_fd_sc_hd__decap_3
XFILLER_7_467 VGND VGND VPWR VPWR sky130_fd_sc_hd__decap_3
XFILLER_48_1037 VGND VGND VPWR VPWR sky130_fd_sc_hd__decap_3
XFILLER_3_673 VGND VGND VPWR VPWR sky130_fd_sc_hd__decap_3
XFILLER_65_1340 VGND VGND VPWR VPWR sky130_fd_sc_hd__decap_3
XFILLER_2_150 VGND VGND VPWR VPWR sky130_fd_sc_hd__decap_3
XFILLER_65_1351 VGND VGND VPWR VPWR sky130_fd_sc_hd__decap_3
XFILLER_2_183 VGND VGND VPWR VPWR sky130_fd_sc_hd__decap_3
Xload_slew337 _4770_/B VGND VGND VPWR VPWR _4747_/A sky130_fd_sc_hd__buf_4
XFILLER_26_1335 VGND VGND VPWR VPWR sky130_fd_sc_hd__decap_3
XFILLER_65_1384 VGND VGND VPWR VPWR sky130_fd_sc_hd__decap_3
XFILLER_6_1418 VGND VGND VPWR VPWR sky130_fd_sc_hd__decap_3
XFILLER_24_6 VGND VGND VPWR VPWR sky130_fd_sc_hd__decap_3
XFILLER_39_817 VGND VGND VPWR VPWR sky130_fd_sc_hd__decap_3
XFILLER_78_463 VGND VGND VPWR VPWR sky130_fd_sc_hd__decap_3
XFILLER_6_1429 VGND VGND VPWR VPWR sky130_fd_sc_hd__decap_3
XFILLER_66_603 VGND VGND VPWR VPWR sky130_fd_sc_hd__decap_3
XFILLER_26_1368 VGND VGND VPWR VPWR sky130_fd_sc_hd__decap_3
XFILLER_61_1248 VGND VGND VPWR VPWR sky130_fd_sc_hd__decap_3
XFILLER_26_1379 VGND VGND VPWR VPWR sky130_fd_sc_hd__decap_3
XFILLER_78_496 VGND VGND VPWR VPWR sky130_fd_sc_hd__fill_1
XFILLER_65_113 VGND VGND VPWR VPWR sky130_fd_sc_hd__fill_1
XFILLER_4_1120 VGND VGND VPWR VPWR sky130_fd_sc_hd__decap_3
XFILLER_19_530 VGND VGND VPWR VPWR sky130_fd_sc_hd__fill_1
XFILLER_54_809 VGND VGND VPWR VPWR sky130_fd_sc_hd__decap_3
XFILLER_4_1164 VGND VGND VPWR VPWR sky130_fd_sc_hd__decap_3
XFILLER_47_872 VGND VGND VPWR VPWR sky130_fd_sc_hd__decap_3
XFILLER_0_53 VGND VGND VPWR VPWR sky130_fd_sc_hd__decap_3
XFILLER_80_116 VGND VGND VPWR VPWR sky130_fd_sc_hd__decap_3
XFILLER_4_1197 VGND VGND VPWR VPWR sky130_fd_sc_hd__decap_3
XFILLER_47_894 VGND VGND VPWR VPWR sky130_fd_sc_hd__fill_2
XFILLER_59_1133 VGND VGND VPWR VPWR sky130_fd_sc_hd__fill_1
XFILLER_0_75 VGND VGND VPWR VPWR sky130_fd_sc_hd__decap_3
XFILLER_0_97 VGND VGND VPWR VPWR sky130_fd_sc_hd__decap_3
X_5850_ _5924_/A _5850_/B _5924_/B VGND VGND VPWR VPWR wire97/A sky130_fd_sc_hd__nor3_4
XFILLER_59_1177 VGND VGND VPWR VPWR sky130_fd_sc_hd__decap_3
XFILLER_34_566 VGND VGND VPWR VPWR sky130_fd_sc_hd__decap_3
XFILLER_72_1300 VGND VGND VPWR VPWR sky130_fd_sc_hd__decap_3
X_4801_ _6578_/Q _4822_/A VGND VGND VPWR VPWR _4801_/Y sky130_fd_sc_hd__nand2_2
XFILLER_22_739 VGND VGND VPWR VPWR sky130_fd_sc_hd__fill_1
XFILLER_37_1431 VGND VGND VPWR VPWR sky130_fd_sc_hd__decap_3
XFILLER_15_780 VGND VGND VPWR VPWR sky130_fd_sc_hd__decap_3
X_5781_ _5781_/A0 _5931_/A0 _5781_/S VGND VGND VPWR VPWR _6816_/D sky130_fd_sc_hd__mux2_1
XFILLER_61_396 VGND VGND VPWR VPWR sky130_fd_sc_hd__decap_3
XFILLER_72_1344 VGND VGND VPWR VPWR sky130_fd_sc_hd__decap_3
X_4732_ _4732_/A _4732_/B VGND VGND VPWR VPWR _4732_/Y sky130_fd_sc_hd__nor2_2
XFILLER_30_750 VGND VGND VPWR VPWR sky130_fd_sc_hd__decap_3
XFILLER_9_73 VGND VGND VPWR VPWR sky130_fd_sc_hd__fill_1
XFILLER_33_1328 VGND VGND VPWR VPWR sky130_fd_sc_hd__decap_3
XFILLER_72_1388 VGND VGND VPWR VPWR sky130_fd_sc_hd__decap_3
X_4663_ _6889_/Q wire295/A _4661_/X _4662_/X VGND VGND VPWR VPWR _4663_/X sky130_fd_sc_hd__a211o_2
X_6402_ _6772_/CLK _6402_/D load_slew831/X VGND VGND VPWR VPWR _6402_/Q sky130_fd_sc_hd__dfrtp_2
X_3614_ _3665_/A _3665_/B _3673_/A _3649_/B VGND VGND VPWR VPWR _3614_/X sky130_fd_sc_hd__a211o_2
XFILLER_31_1041 VGND VGND VPWR VPWR sky130_fd_sc_hd__decap_3
XFILLER_31_1063 VGND VGND VPWR VPWR sky130_fd_sc_hd__fill_1
X_4594_ _4768_/C _4444_/Y _4547_/X _6542_/Q _4771_/C1 VGND VGND VPWR VPWR _4597_/B
+ sky130_fd_sc_hd__a221o_2
Xhold902 _6126_/Q VGND VGND VPWR VPWR hold902/X sky130_fd_sc_hd__dlygate4sd3_1
Xhold913 _6102_/Q VGND VGND VPWR VPWR hold913/X sky130_fd_sc_hd__dlygate4sd3_1
XTAP_TAPCELL_ROW_77_2197 VGND VPWR sky130_fd_sc_hd__tapvpwrvgnd_1
X_6333_ _7055_/CLK _6333_/D fanout797/X VGND VGND VPWR VPWR _6333_/Q sky130_fd_sc_hd__dfrtp_2
X_3545_ _6235_/Q _3631_/A2 _3630_/C1 _6299_/Q _3544_/X VGND VGND VPWR VPWR _3545_/X
+ sky130_fd_sc_hd__a221o_2
Xhold924 _6120_/Q VGND VGND VPWR VPWR hold924/X sky130_fd_sc_hd__dlygate4sd3_1
Xhold935 _6734_/Q VGND VGND VPWR VPWR hold935/X sky130_fd_sc_hd__dlygate4sd3_1
Xhold946 _5937_/X VGND VGND VPWR VPWR _6941_/D sky130_fd_sc_hd__dlygate4sd3_1
Xhold957 _6171_/Q VGND VGND VPWR VPWR hold957/X sky130_fd_sc_hd__dlygate4sd3_1
XFILLER_66_1137 VGND VGND VPWR VPWR sky130_fd_sc_hd__decap_3
Xhold968 _6144_/Q VGND VGND VPWR VPWR hold968/X sky130_fd_sc_hd__dlygate4sd3_1
X_6264_ _6882_/CLK _6264_/D fanout665/X VGND VGND VPWR VPWR _6264_/Q sky130_fd_sc_hd__dfrtp_2
X_3476_ _6245_/Q _6469_/Q VGND VGND VPWR VPWR _3476_/X sky130_fd_sc_hd__xor2_2
XFILLER_0_109 VGND VGND VPWR VPWR sky130_fd_sc_hd__decap_3
Xhold979 _6191_/Q VGND VGND VPWR VPWR hold979/X sky130_fd_sc_hd__dlygate4sd3_1
X_5215_ _6413_/Q _5215_/A2 _5214_/X VGND VGND VPWR VPWR _6413_/D sky130_fd_sc_hd__a21o_2
X_6195_ _7046_/CLK _6195_/D load_slew744/X VGND VGND VPWR VPWR _6195_/Q sky130_fd_sc_hd__dfrtp_2
XFILLER_44_1424 VGND VGND VPWR VPWR sky130_fd_sc_hd__decap_3
XFILLER_44_1435 VGND VGND VPWR VPWR sky130_fd_sc_hd__decap_3
XTAP_TAPCELL_ROW_32_1024 VGND VPWR sky130_fd_sc_hd__tapvpwrvgnd_1
X_5146_ _6720_/Q _5216_/A VGND VGND VPWR VPWR _5146_/X sky130_fd_sc_hd__or2_2
XFILLER_57_614 VGND VGND VPWR VPWR sky130_fd_sc_hd__fill_2
XTAP_TAPCELL_ROW_32_1035 VGND VPWR sky130_fd_sc_hd__tapvpwrvgnd_1
XFILLER_44_1468 VGND VGND VPWR VPWR sky130_fd_sc_hd__fill_1
X_5077_ _6368_/Q _5074_/X _5076_/X _5307_/S VGND VGND VPWR VPWR _6368_/D sky130_fd_sc_hd__a22o_2
XFILLER_38_861 VGND VGND VPWR VPWR sky130_fd_sc_hd__decap_3
XFILLER_42_1181 VGND VGND VPWR VPWR sky130_fd_sc_hd__fill_1
XFILLER_38_872 VGND VGND VPWR VPWR sky130_fd_sc_hd__decap_3
XFILLER_72_628 VGND VGND VPWR VPWR sky130_fd_sc_hd__fill_2
X_4028_ _4008_/B _3717_/A _4300_/B _4008_/Y _6563_/Q VGND VGND VPWR VPWR _4028_/X
+ sky130_fd_sc_hd__a32o_2
XFILLER_77_1222 VGND VGND VPWR VPWR sky130_fd_sc_hd__decap_3
XFILLER_25_511 VGND VGND VPWR VPWR sky130_fd_sc_hd__decap_3
XFILLER_77_1233 VGND VGND VPWR VPWR sky130_fd_sc_hd__decap_3
XFILLER_44_15 VGND VGND VPWR VPWR sky130_fd_sc_hd__decap_3
XFILLER_71_149 VGND VGND VPWR VPWR sky130_fd_sc_hd__fill_1
XFILLER_77_1266 VGND VGND VPWR VPWR sky130_fd_sc_hd__decap_3
XFILLER_53_875 VGND VGND VPWR VPWR sky130_fd_sc_hd__decap_3
XFILLER_13_717 VGND VGND VPWR VPWR sky130_fd_sc_hd__decap_3
XFILLER_38_1239 VGND VGND VPWR VPWR sky130_fd_sc_hd__decap_3
XFILLER_52_363 VGND VGND VPWR VPWR sky130_fd_sc_hd__fill_1
XFILLER_80_694 VGND VGND VPWR VPWR sky130_fd_sc_hd__decap_3
X_5979_ _5979_/A0 _6983_/Q _6051_/S VGND VGND VPWR VPWR _5979_/X sky130_fd_sc_hd__mux2_1
XFILLER_51_1428 VGND VGND VPWR VPWR sky130_fd_sc_hd__decap_3
XFILLER_21_772 VGND VGND VPWR VPWR sky130_fd_sc_hd__decap_3
XTAP_TAPCELL_ROW_23_789 VGND VPWR sky130_fd_sc_hd__tapvpwrvgnd_1
XFILLER_60_58 VGND VGND VPWR VPWR sky130_fd_sc_hd__decap_3
XFILLER_14_1250 VGND VGND VPWR VPWR sky130_fd_sc_hd__decap_3
XFILLER_14_1261 VGND VGND VPWR VPWR sky130_fd_sc_hd__decap_3
XFILLER_14_1294 VGND VGND VPWR VPWR sky130_fd_sc_hd__decap_3
XFILLER_4_415 VGND VGND VPWR VPWR sky130_fd_sc_hd__decap_3
XFILLER_49_1313 VGND VGND VPWR VPWR sky130_fd_sc_hd__decap_3
XFILLER_10_1147 VGND VGND VPWR VPWR sky130_fd_sc_hd__fill_1
XFILLER_69_12 VGND VGND VPWR VPWR sky130_fd_sc_hd__decap_3
XFILLER_10_1158 VGND VGND VPWR VPWR sky130_fd_sc_hd__decap_3
XFILLER_49_1357 VGND VGND VPWR VPWR sky130_fd_sc_hd__decap_3
XFILLER_69_45 VGND VGND VPWR VPWR sky130_fd_sc_hd__decap_3
XFILLER_79_205 VGND VGND VPWR VPWR sky130_fd_sc_hd__decap_3
XFILLER_0_610 VGND VGND VPWR VPWR sky130_fd_sc_hd__decap_3
XFILLER_0_643 VGND VGND VPWR VPWR sky130_fd_sc_hd__fill_1
XFILLER_0_654 VGND VGND VPWR VPWR sky130_fd_sc_hd__decap_3
XFILLER_76_912 VGND VGND VPWR VPWR sky130_fd_sc_hd__decap_3
XFILLER_0_676 VGND VGND VPWR VPWR sky130_fd_sc_hd__decap_3
XFILLER_75_411 VGND VGND VPWR VPWR sky130_fd_sc_hd__decap_3
XFILLER_48_636 VGND VGND VPWR VPWR sky130_fd_sc_hd__decap_3
XFILLER_5_1440 VGND VGND VPWR VPWR sky130_fd_sc_hd__decap_3
XFILLER_75_455 VGND VGND VPWR VPWR sky130_fd_sc_hd__decap_3
XFILLER_47_146 VGND VGND VPWR VPWR sky130_fd_sc_hd__decap_3
XFILLER_60_1270 VGND VGND VPWR VPWR sky130_fd_sc_hd__decap_3
XFILLER_25_1390 VGND VGND VPWR VPWR sky130_fd_sc_hd__decap_3
XFILLER_1_1304 VGND VGND VPWR VPWR sky130_fd_sc_hd__decap_3
XFILLER_21_1254 VGND VGND VPWR VPWR sky130_fd_sc_hd__decap_3
XFILLER_1_1337 VGND VGND VPWR VPWR sky130_fd_sc_hd__decap_3
XFILLER_62_127 VGND VGND VPWR VPWR sky130_fd_sc_hd__decap_3
XFILLER_1_1348 VGND VGND VPWR VPWR sky130_fd_sc_hd__decap_3
XFILLER_16_533 VGND VGND VPWR VPWR sky130_fd_sc_hd__decap_3
XFILLER_21_1287 VGND VGND VPWR VPWR sky130_fd_sc_hd__fill_1
XFILLER_21_1298 VGND VGND VPWR VPWR sky130_fd_sc_hd__decap_3
XFILLER_56_1306 VGND VGND VPWR VPWR sky130_fd_sc_hd__decap_3
XFILLER_16_555 VGND VGND VPWR VPWR sky130_fd_sc_hd__decap_3
XFILLER_56_1317 VGND VGND VPWR VPWR sky130_fd_sc_hd__decap_3
XFILLER_43_352 VGND VGND VPWR VPWR sky130_fd_sc_hd__fill_2
XFILLER_31_503 VGND VGND VPWR VPWR sky130_fd_sc_hd__fill_1
XFILLER_31_514 VGND VGND VPWR VPWR sky130_fd_sc_hd__decap_3
XFILLER_19_1172 VGND VGND VPWR VPWR sky130_fd_sc_hd__decap_3
XFILLER_54_1052 VGND VGND VPWR VPWR sky130_fd_sc_hd__decap_3
XFILLER_12_772 VGND VGND VPWR VPWR sky130_fd_sc_hd__decap_3
XFILLER_54_1096 VGND VGND VPWR VPWR sky130_fd_sc_hd__fill_2
XFILLER_32_1350 VGND VGND VPWR VPWR sky130_fd_sc_hd__decap_3
Xwire151 _3775_/Y VGND VGND VPWR VPWR _4121_/B sky130_fd_sc_hd__buf_2
XFILLER_32_1394 VGND VGND VPWR VPWR sky130_fd_sc_hd__decap_3
XFILLER_67_1413 VGND VGND VPWR VPWR sky130_fd_sc_hd__decap_3
XFILLER_67_1446 VGND VGND VPWR VPWR sky130_fd_sc_hd__decap_3
X_3330_ _6292_/Q _6396_/Q VGND VGND VPWR VPWR _3330_/X sky130_fd_sc_hd__xor2_2
XFILLER_4_971 VGND VGND VPWR VPWR sky130_fd_sc_hd__decap_3
XFILLER_67_1457 VGND VGND VPWR VPWR sky130_fd_sc_hd__decap_3
XTAP_TAPCELL_ROW_72_2061 VGND VPWR sky130_fd_sc_hd__tapvpwrvgnd_1
XTAP_TAPCELL_ROW_72_2072 VGND VPWR sky130_fd_sc_hd__tapvpwrvgnd_1
XTAP_TAPCELL_ROW_72_2083 VGND VPWR sky130_fd_sc_hd__tapvpwrvgnd_1
Xload_slew123 _5271_/B1 VGND VGND VPWR VPWR _5307_/S sky130_fd_sc_hd__clkbuf_4
XFILLER_3_492 VGND VGND VPWR VPWR sky130_fd_sc_hd__decap_3
X_3261_ _5951_/A0 _3260_/X _3261_/S VGND VGND VPWR VPWR _6104_/D sky130_fd_sc_hd__mux2_1
XFILLER_79_750 VGND VGND VPWR VPWR sky130_fd_sc_hd__decap_3
XFILLER_65_1170 VGND VGND VPWR VPWR sky130_fd_sc_hd__decap_3
X_5000_ _6454_/Q _6672_/Q VGND VGND VPWR VPWR _5001_/B sky130_fd_sc_hd__xor2_2
XFILLER_79_772 VGND VGND VPWR VPWR sky130_fd_sc_hd__decap_3
XFILLER_26_1143 VGND VGND VPWR VPWR sky130_fd_sc_hd__decap_3
XFILLER_39_603 VGND VGND VPWR VPWR sky130_fd_sc_hd__fill_1
Xload_slew156 _4335_/A2 VGND VGND VPWR VPWR _4002_/A2 sky130_fd_sc_hd__buf_4
XFILLER_67_912 VGND VGND VPWR VPWR sky130_fd_sc_hd__decap_3
XFILLER_22_3 VGND VGND VPWR VPWR sky130_fd_sc_hd__decap_3
XFILLER_6_1226 VGND VGND VPWR VPWR sky130_fd_sc_hd__decap_3
X_3192_ _7076_/Q _7031_/Q _7039_/Q _3136_/A VGND VGND VPWR VPWR _3192_/X sky130_fd_sc_hd__a22o_2
Xload_slew189 _3379_/S VGND VGND VPWR VPWR _3401_/S sky130_fd_sc_hd__buf_4
XFILLER_6_1259 VGND VGND VPWR VPWR sky130_fd_sc_hd__fill_1
XFILLER_38_135 VGND VGND VPWR VPWR sky130_fd_sc_hd__decap_3
XFILLER_61_1078 VGND VGND VPWR VPWR sky130_fd_sc_hd__decap_3
XFILLER_39_669 VGND VGND VPWR VPWR sky130_fd_sc_hd__decap_3
XFILLER_54_617 VGND VGND VPWR VPWR sky130_fd_sc_hd__decap_3
XFILLER_66_477 VGND VGND VPWR VPWR sky130_fd_sc_hd__decap_3
Xclkbuf_3_4_0_clk clkbuf_0_clk/X VGND VGND VPWR VPWR clkbuf_3_4_0_clk/X sky130_fd_sc_hd__clkbuf_8
X_6951_ _6959_/CLK _6951_/D load_slew799/X VGND VGND VPWR VPWR _6951_/Q sky130_fd_sc_hd__dfrtp_2
XFILLER_53_116 VGND VGND VPWR VPWR sky130_fd_sc_hd__decap_3
XFILLER_19_382 VGND VGND VPWR VPWR sky130_fd_sc_hd__decap_3
XFILLER_47_691 VGND VGND VPWR VPWR sky130_fd_sc_hd__fill_1
XFILLER_19_393 VGND VGND VPWR VPWR sky130_fd_sc_hd__fill_1
X_5902_ _5902_/A0 _5902_/A1 _5905_/S VGND VGND VPWR VPWR _6910_/D sky130_fd_sc_hd__mux2_1
XFILLER_74_1406 VGND VGND VPWR VPWR sky130_fd_sc_hd__decap_3
X_6882_ _6882_/CLK _6882_/D fanout663/X VGND VGND VPWR VPWR _6882_/Q sky130_fd_sc_hd__dfrtp_2
XFILLER_34_341 VGND VGND VPWR VPWR sky130_fd_sc_hd__decap_3
XFILLER_34_374 VGND VGND VPWR VPWR sky130_fd_sc_hd__decap_3
X_5833_ _5907_/A0 _5833_/A1 _5839_/S VGND VGND VPWR VPWR _6850_/D sky130_fd_sc_hd__mux2_1
XFILLER_14_18 VGND VGND VPWR VPWR sky130_fd_sc_hd__fill_2
XFILLER_14_29 VGND VGND VPWR VPWR sky130_fd_sc_hd__decap_3
XFILLER_22_558 VGND VGND VPWR VPWR sky130_fd_sc_hd__decap_3
XFILLER_50_867 VGND VGND VPWR VPWR sky130_fd_sc_hd__fill_1
XFILLER_72_1141 VGND VGND VPWR VPWR sky130_fd_sc_hd__decap_3
X_5764_ wire608/A _5764_/A1 _5766_/S VGND VGND VPWR VPWR _6807_/D sky130_fd_sc_hd__mux2_1
XFILLER_72_1152 VGND VGND VPWR VPWR sky130_fd_sc_hd__decap_3
XFILLER_37_1272 VGND VGND VPWR VPWR sky130_fd_sc_hd__decap_3
XFILLER_72_1185 VGND VGND VPWR VPWR sky130_fd_sc_hd__decap_3
XTAP_TAPCELL_ROW_20_715 VGND VPWR sky130_fd_sc_hd__tapvpwrvgnd_1
XFILLER_33_1136 VGND VGND VPWR VPWR sky130_fd_sc_hd__decap_3
XTAP_TAPCELL_ROW_79_2248 VGND VPWR sky130_fd_sc_hd__tapvpwrvgnd_1
X_4715_ _6318_/Q wire52/X _4712_/X _4714_/X VGND VGND VPWR VPWR _6318_/D sky130_fd_sc_hd__o22a_2
XTAP_TAPCELL_ROW_20_726 VGND VPWR sky130_fd_sc_hd__tapvpwrvgnd_1
XTAP_TAPCELL_ROW_79_2259 VGND VPWR sky130_fd_sc_hd__tapvpwrvgnd_1
X_5695_ _5695_/A0 _5889_/A0 _5701_/S VGND VGND VPWR VPWR _6746_/D sky130_fd_sc_hd__mux2_1
XFILLER_11_1401 VGND VGND VPWR VPWR sky130_fd_sc_hd__decap_3
XFILLER_50_1450 VGND VGND VPWR VPWR sky130_fd_sc_hd__decap_3
X_4646_ _6549_/Q _4645_/A _4859_/C1 VGND VGND VPWR VPWR _4646_/X sky130_fd_sc_hd__a21bo_2
XFILLER_11_1434 VGND VGND VPWR VPWR sky130_fd_sc_hd__decap_3
XTAP_TAPCELL_ROW_38_1200 VGND VPWR sky130_fd_sc_hd__tapvpwrvgnd_1
X_4577_ _6299_/Q _4576_/X wire54/X VGND VGND VPWR VPWR _6299_/D sky130_fd_sc_hd__mux2_1
XFILLER_2_908 VGND VGND VPWR VPWR sky130_fd_sc_hd__decap_3
X_6316_ _6982_/CLK _6316_/D fanout755/X VGND VGND VPWR VPWR _6316_/Q sky130_fd_sc_hd__dfrtp_2
X_3528_ _6342_/Q _5600_/A2 _3533_/B1 _6326_/Q _4783_/B VGND VGND VPWR VPWR _3528_/X
+ sky130_fd_sc_hd__a221o_2
X_6247_ _7065_/CLK _6247_/D fanout735/X VGND VGND VPWR VPWR _6247_/Q sky130_fd_sc_hd__dfrtp_2
X_3459_ hold905/X _3458_/X _3459_/S VGND VGND VPWR VPWR _6203_/D sky130_fd_sc_hd__mux2_1
XFILLER_44_1243 VGND VGND VPWR VPWR sky130_fd_sc_hd__decap_3
XFILLER_58_934 VGND VGND VPWR VPWR sky130_fd_sc_hd__decap_3
Xhold1410 _6545_/Q VGND VGND VPWR VPWR _5433_/A1 sky130_fd_sc_hd__dlygate4sd3_1
XFILLER_57_411 VGND VGND VPWR VPWR sky130_fd_sc_hd__decap_3
X_6178_ _7032_/CLK _6178_/D load_slew692/X VGND VGND VPWR VPWR _6178_/Q sky130_fd_sc_hd__dfrtp_2
XPHY_EDGE_ROW_24_Left_105 VGND VGND VPWR VPWR sky130_fd_sc_hd__decap_3
XFILLER_44_1276 VGND VGND VPWR VPWR sky130_fd_sc_hd__decap_3
Xhold1421 _6547_/Q VGND VGND VPWR VPWR _5435_/A1 sky130_fd_sc_hd__dlygate4sd3_1
Xload_slew690 fanout689/X VGND VGND VPWR VPWR load_slew690/X sky130_fd_sc_hd__buf_2
Xhold1432 _6582_/Q VGND VGND VPWR VPWR _5470_/A1 sky130_fd_sc_hd__dlygate4sd3_1
X_5129_ _6407_/Q _5291_/B VGND VGND VPWR VPWR _5131_/B sky130_fd_sc_hd__xor2_2
Xhold1443 _6595_/Q VGND VGND VPWR VPWR _5483_/A1 sky130_fd_sc_hd__dlygate4sd3_1
XFILLER_18_809 VGND VGND VPWR VPWR sky130_fd_sc_hd__decap_3
XFILLER_57_455 VGND VGND VPWR VPWR sky130_fd_sc_hd__decap_3
Xhold1454 _6497_/Q VGND VGND VPWR VPWR _5385_/A1 sky130_fd_sc_hd__dlygate4sd3_1
Xhold1465 _6511_/Q VGND VGND VPWR VPWR _5399_/A1 sky130_fd_sc_hd__dlygate4sd3_1
XFILLER_79_1328 VGND VGND VPWR VPWR sky130_fd_sc_hd__decap_3
XFILLER_17_319 VGND VGND VPWR VPWR sky130_fd_sc_hd__decap_3
Xhold1476 _6637_/Q VGND VGND VPWR VPWR _5554_/B1 sky130_fd_sc_hd__dlygate4sd3_1
Xhold1487 _6599_/Q VGND VGND VPWR VPWR _5487_/A1 sky130_fd_sc_hd__dlygate4sd3_1
Xhold1498 _6594_/Q VGND VGND VPWR VPWR _5482_/A1 sky130_fd_sc_hd__dlygate4sd3_1
XFILLER_72_436 VGND VGND VPWR VPWR sky130_fd_sc_hd__fill_2
XFILLER_44_138 VGND VGND VPWR VPWR sky130_fd_sc_hd__fill_2
XTAP_TAPCELL_ROW_68_1963 VGND VPWR sky130_fd_sc_hd__tapvpwrvgnd_1
XTAP_TAPCELL_ROW_68_1974 VGND VPWR sky130_fd_sc_hd__tapvpwrvgnd_1
XFILLER_77_1063 VGND VGND VPWR VPWR sky130_fd_sc_hd__fill_1
XFILLER_41_801 VGND VGND VPWR VPWR sky130_fd_sc_hd__decap_3
XFILLER_77_1074 VGND VGND VPWR VPWR sky130_fd_sc_hd__decap_3
XFILLER_26_886 VGND VGND VPWR VPWR sky130_fd_sc_hd__decap_3
XFILLER_13_514 VGND VGND VPWR VPWR sky130_fd_sc_hd__decap_3
XFILLER_52_160 VGND VGND VPWR VPWR sky130_fd_sc_hd__decap_3
XFILLER_80_480 VGND VGND VPWR VPWR sky130_fd_sc_hd__fill_1
XFILLER_25_385 VGND VGND VPWR VPWR sky130_fd_sc_hd__decap_3
XFILLER_71_24 VGND VGND VPWR VPWR sky130_fd_sc_hd__decap_3
XFILLER_25_396 VGND VGND VPWR VPWR sky130_fd_sc_hd__decap_3
XFILLER_52_193 VGND VGND VPWR VPWR sky130_fd_sc_hd__decap_3
XFILLER_16_1312 VGND VGND VPWR VPWR sky130_fd_sc_hd__decap_3
XFILLER_41_867 VGND VGND VPWR VPWR sky130_fd_sc_hd__decap_3
XFILLER_71_57 VGND VGND VPWR VPWR sky130_fd_sc_hd__decap_3
XFILLER_9_529 VGND VGND VPWR VPWR sky130_fd_sc_hd__decap_3
XFILLER_16_1323 VGND VGND VPWR VPWR sky130_fd_sc_hd__decap_3
XFILLER_55_1372 VGND VGND VPWR VPWR sky130_fd_sc_hd__decap_3
XPHY_EDGE_ROW_33_Left_114 VGND VGND VPWR VPWR sky130_fd_sc_hd__decap_3
XFILLER_16_1356 VGND VGND VPWR VPWR sky130_fd_sc_hd__decap_3
XFILLER_40_388 VGND VGND VPWR VPWR sky130_fd_sc_hd__decap_3
XFILLER_51_1236 VGND VGND VPWR VPWR sky130_fd_sc_hd__decap_3
Xclkbuf_4_7__f_clk clkbuf_3_3_0_clk/X VGND VGND VPWR VPWR clkload3/A sky130_fd_sc_hd__clkbuf_16
XFILLER_51_1269 VGND VGND VPWR VPWR sky130_fd_sc_hd__decap_3
XFILLER_4_212 VGND VGND VPWR VPWR sky130_fd_sc_hd__fill_1
XFILLER_4_245 VGND VGND VPWR VPWR sky130_fd_sc_hd__decap_3
XFILLER_49_1121 VGND VGND VPWR VPWR sky130_fd_sc_hd__decap_3
XFILLER_20_61 VGND VGND VPWR VPWR sky130_fd_sc_hd__fill_2
XFILLER_1_930 VGND VGND VPWR VPWR sky130_fd_sc_hd__decap_3
XFILLER_20_94 VGND VGND VPWR VPWR sky130_fd_sc_hd__decap_3
XFILLER_45_1029 VGND VGND VPWR VPWR sky130_fd_sc_hd__decap_3
XFILLER_49_1198 VGND VGND VPWR VPWR sky130_fd_sc_hd__decap_3
XFILLER_1_974 VGND VGND VPWR VPWR sky130_fd_sc_hd__decap_3
XPHY_EDGE_ROW_42_Left_123 VGND VGND VPWR VPWR sky130_fd_sc_hd__decap_3
XFILLER_62_1332 VGND VGND VPWR VPWR sky130_fd_sc_hd__decap_3
XFILLER_27_1452 VGND VGND VPWR VPWR sky130_fd_sc_hd__decap_3
XFILLER_27_1463 VGND VGND VPWR VPWR sky130_fd_sc_hd__decap_3
XFILLER_0_473 VGND VGND VPWR VPWR sky130_fd_sc_hd__decap_3
XFILLER_23_1316 VGND VGND VPWR VPWR sky130_fd_sc_hd__decap_3
XFILLER_62_1365 VGND VGND VPWR VPWR sky130_fd_sc_hd__decap_3
XFILLER_0_495 VGND VGND VPWR VPWR sky130_fd_sc_hd__decap_3
XFILLER_49_956 VGND VGND VPWR VPWR sky130_fd_sc_hd__decap_3
XFILLER_62_1376 VGND VGND VPWR VPWR sky130_fd_sc_hd__decap_3
XFILLER_48_433 VGND VGND VPWR VPWR sky130_fd_sc_hd__fill_2
XFILLER_48_477 VGND VGND VPWR VPWR sky130_fd_sc_hd__fill_1
XFILLER_1_1101 VGND VGND VPWR VPWR sky130_fd_sc_hd__decap_3
XFILLER_5_1281 VGND VGND VPWR VPWR sky130_fd_sc_hd__decap_3
XFILLER_48_499 VGND VGND VPWR VPWR sky130_fd_sc_hd__decap_3
XFILLER_5_1292 VGND VGND VPWR VPWR sky130_fd_sc_hd__decap_3
XFILLER_17_831 VGND VGND VPWR VPWR sky130_fd_sc_hd__decap_3
XFILLER_63_436 VGND VGND VPWR VPWR sky130_fd_sc_hd__decap_3
XFILLER_1_1145 VGND VGND VPWR VPWR sky130_fd_sc_hd__decap_3
XFILLER_32_801 VGND VGND VPWR VPWR sky130_fd_sc_hd__decap_3
XFILLER_44_661 VGND VGND VPWR VPWR sky130_fd_sc_hd__decap_3
XFILLER_1_1189 VGND VGND VPWR VPWR sky130_fd_sc_hd__decap_3
XFILLER_16_363 VGND VGND VPWR VPWR sky130_fd_sc_hd__fill_1
XFILLER_17_897 VGND VGND VPWR VPWR sky130_fd_sc_hd__decap_3
XFILLER_44_694 VGND VGND VPWR VPWR sky130_fd_sc_hd__decap_3
XTAP_TAPCELL_ROW_27_892 VGND VPWR sky130_fd_sc_hd__tapvpwrvgnd_1
XFILLER_31_322 VGND VGND VPWR VPWR sky130_fd_sc_hd__decap_3
XFILLER_43_193 VGND VGND VPWR VPWR sky130_fd_sc_hd__decap_3
XPHY_EDGE_ROW_51_Left_132 VGND VGND VPWR VPWR sky130_fd_sc_hd__decap_3
XFILLER_31_355 VGND VGND VPWR VPWR sky130_fd_sc_hd__decap_3
XFILLER_32_878 VGND VGND VPWR VPWR sky130_fd_sc_hd__fill_1
XFILLER_34_1412 VGND VGND VPWR VPWR sky130_fd_sc_hd__decap_3
XTAP_TAPCELL_ROW_14_553 VGND VPWR sky130_fd_sc_hd__tapvpwrvgnd_1
XTAP_TAPCELL_ROW_14_564 VGND VPWR sky130_fd_sc_hd__tapvpwrvgnd_1
XTAP_TAPCELL_ROW_14_575 VGND VPWR sky130_fd_sc_hd__tapvpwrvgnd_1
XFILLER_31_399 VGND VGND VPWR VPWR sky130_fd_sc_hd__decap_3
XFILLER_34_1456 VGND VGND VPWR VPWR sky130_fd_sc_hd__decap_3
XFILLER_30_1309 VGND VGND VPWR VPWR sky130_fd_sc_hd__decap_3
XFILLER_8_551 VGND VGND VPWR VPWR sky130_fd_sc_hd__decap_3
X_4500_ _6859_/Q _4855_/A2 _4862_/B1 _4499_/X VGND VGND VPWR VPWR _4500_/X sky130_fd_sc_hd__a211o_2
X_5480_ _5480_/A1 _5480_/A2 _4061_/X VGND VGND VPWR VPWR _6592_/D sky130_fd_sc_hd__a21o_2
XFILLER_8_584 VGND VGND VPWR VPWR sky130_fd_sc_hd__decap_3
XTAP_TAPCELL_ROW_74_2112 VGND VPWR sky130_fd_sc_hd__tapvpwrvgnd_1
XFILLER_8_595 VGND VGND VPWR VPWR sky130_fd_sc_hd__decap_3
XTAP_TAPCELL_ROW_74_2123 VGND VPWR sky130_fd_sc_hd__tapvpwrvgnd_1
XFILLER_6_41 VGND VGND VPWR VPWR sky130_fd_sc_hd__fill_2
XANTENNA_1 _3078_/Y VGND VGND VPWR VPWR sky130_fd_sc_hd__diode_2
X_4431_ _6512_/Q _4431_/B VGND VGND VPWR VPWR _4431_/Y sky130_fd_sc_hd__nand2_2
XFILLER_6_52 VGND VGND VPWR VPWR sky130_fd_sc_hd__decap_3
XTAP_TAPCELL_ROW_74_2134 VGND VPWR sky130_fd_sc_hd__tapvpwrvgnd_1
XFILLER_67_1210 VGND VGND VPWR VPWR sky130_fd_sc_hd__decap_3
XFILLER_6_85 VGND VGND VPWR VPWR sky130_fd_sc_hd__decap_3
X_4362_ _4388_/A _4725_/B VGND VGND VPWR VPWR _4362_/Y sky130_fd_sc_hd__nor2_2
XTAP_TAPCELL_ROW_70_2009 VGND VPWR sky130_fd_sc_hd__tapvpwrvgnd_1
XFILLER_28_1205 VGND VGND VPWR VPWR sky130_fd_sc_hd__fill_2
XFILLER_67_1254 VGND VGND VPWR VPWR sky130_fd_sc_hd__decap_3
XFILLER_28_1216 VGND VGND VPWR VPWR sky130_fd_sc_hd__fill_1
X_3313_ _5977_/A0 _3312_/X _3457_/S VGND VGND VPWR VPWR _6130_/D sky130_fd_sc_hd__mux2_1
X_6101_ clkload8/A _6101_/D fanout636/X VGND VGND VPWR VPWR _6101_/Q sky130_fd_sc_hd__dfrtp_2
XPHY_EDGE_ROW_60_Left_141 VGND VGND VPWR VPWR sky130_fd_sc_hd__decap_3
X_7081_ _7092_/CLK _7081_/D fanout682/X VGND VGND VPWR VPWR _7081_/Q sky130_fd_sc_hd__dfstp_2
Xfanout508 _4854_/A2 VGND VGND VPWR VPWR _4861_/A2 sky130_fd_sc_hd__clkdlybuf4s25_1
XFILLER_67_1287 VGND VGND VPWR VPWR sky130_fd_sc_hd__fill_1
XFILLER_28_1249 VGND VGND VPWR VPWR sky130_fd_sc_hd__decap_3
X_4293_ _4293_/A _4293_/B VGND VGND VPWR VPWR _4294_/B sky130_fd_sc_hd__xnor2_2
Xfanout519 _7084_/Q VGND VGND VPWR VPWR _5566_/A2 sky130_fd_sc_hd__clkdlybuf4s25_1
XFILLER_63_1129 VGND VGND VPWR VPWR sky130_fd_sc_hd__decap_3
XFILLER_67_1298 VGND VGND VPWR VPWR sky130_fd_sc_hd__decap_3
XFILLER_80_1410 VGND VGND VPWR VPWR sky130_fd_sc_hd__decap_3
XFILLER_80_1432 VGND VGND VPWR VPWR sky130_fd_sc_hd__decap_3
X_3244_ _6257_/Q _6353_/Q VGND VGND VPWR VPWR _3244_/X sky130_fd_sc_hd__xor2_2
X_6032_ hold948/X _7036_/Q _6032_/S VGND VGND VPWR VPWR _6032_/X sky130_fd_sc_hd__mux2_1
XFILLER_39_422 VGND VGND VPWR VPWR sky130_fd_sc_hd__decap_3
XFILLER_41_1416 VGND VGND VPWR VPWR sky130_fd_sc_hd__decap_3
XFILLER_6_1045 VGND VGND VPWR VPWR sky130_fd_sc_hd__decap_3
XFILLER_39_455 VGND VGND VPWR VPWR sky130_fd_sc_hd__fill_2
X_3175_ _3217_/A _3175_/B _3175_/C VGND VGND VPWR VPWR _3175_/X sky130_fd_sc_hd__and3_2
XFILLER_41_1449 VGND VGND VPWR VPWR sky130_fd_sc_hd__decap_3
XFILLER_66_241 VGND VGND VPWR VPWR sky130_fd_sc_hd__decap_3
XFILLER_6_1078 VGND VGND VPWR VPWR sky130_fd_sc_hd__decap_3
XTAP_TAPCELL_ROW_1_215 VGND VPWR sky130_fd_sc_hd__tapvpwrvgnd_1
XTAP_TAPCELL_ROW_1_226 VGND VPWR sky130_fd_sc_hd__tapvpwrvgnd_1
XTAP_TAPCELL_ROW_1_237 VGND VPWR sky130_fd_sc_hd__tapvpwrvgnd_1
XFILLER_39_499 VGND VGND VPWR VPWR sky130_fd_sc_hd__decap_3
XFILLER_66_296 VGND VGND VPWR VPWR sky130_fd_sc_hd__decap_3
XFILLER_78_1350 VGND VGND VPWR VPWR sky130_fd_sc_hd__decap_3
XFILLER_39_1301 VGND VGND VPWR VPWR sky130_fd_sc_hd__decap_3
X_6934_ _7001_/CLK _6934_/D fanout768/A VGND VGND VPWR VPWR _6934_/Q sky130_fd_sc_hd__dfrtp_2
XFILLER_42_609 VGND VGND VPWR VPWR sky130_fd_sc_hd__fill_2
XFILLER_74_1203 VGND VGND VPWR VPWR sky130_fd_sc_hd__fill_1
XFILLER_35_661 VGND VGND VPWR VPWR sky130_fd_sc_hd__decap_3
XFILLER_74_1214 VGND VGND VPWR VPWR sky130_fd_sc_hd__decap_3
XFILLER_39_1334 VGND VGND VPWR VPWR sky130_fd_sc_hd__decap_3
XFILLER_78_1394 VGND VGND VPWR VPWR sky130_fd_sc_hd__decap_3
XFILLER_39_1345 VGND VGND VPWR VPWR sky130_fd_sc_hd__decap_3
XFILLER_74_1247 VGND VGND VPWR VPWR sky130_fd_sc_hd__decap_3
X_6865_ _6865_/CLK _6865_/D wire712/X VGND VGND VPWR VPWR _6865_/Q sky130_fd_sc_hd__dfrtp_2
XFILLER_50_631 VGND VGND VPWR VPWR sky130_fd_sc_hd__decap_3
XFILLER_22_333 VGND VGND VPWR VPWR sky130_fd_sc_hd__decap_3
XFILLER_39_1378 VGND VGND VPWR VPWR sky130_fd_sc_hd__decap_3
XFILLER_34_193 VGND VGND VPWR VPWR sky130_fd_sc_hd__decap_3
X_5816_ _5816_/A0 _5899_/A0 _5822_/S VGND VGND VPWR VPWR _6835_/D sky130_fd_sc_hd__mux2_1
X_6796_ _7052_/CLK _6796_/D fanout804/X VGND VGND VPWR VPWR _6796_/Q sky130_fd_sc_hd__dfrtp_2
XFILLER_10_528 VGND VGND VPWR VPWR sky130_fd_sc_hd__decap_3
X_5747_ _5913_/A0 _5747_/A1 _5747_/S VGND VGND VPWR VPWR _6792_/D sky130_fd_sc_hd__mux2_1
X_5678_ _5678_/A0 _5908_/A0 wire90/X VGND VGND VPWR VPWR _6731_/D sky130_fd_sc_hd__mux2_1
XFILLER_11_1231 VGND VGND VPWR VPWR sky130_fd_sc_hd__fill_1
XFILLER_11_1242 VGND VGND VPWR VPWR sky130_fd_sc_hd__decap_3
X_4629_ _6306_/Q wire63/X _4626_/X _4628_/X VGND VGND VPWR VPWR _6306_/D sky130_fd_sc_hd__o22a_2
XFILLER_50_1291 VGND VGND VPWR VPWR sky130_fd_sc_hd__decap_3
XFILLER_11_1275 VGND VGND VPWR VPWR sky130_fd_sc_hd__decap_3
XFILLER_2_716 VGND VGND VPWR VPWR sky130_fd_sc_hd__decap_3
XFILLER_2_749 VGND VGND VPWR VPWR sky130_fd_sc_hd__decap_3
XTAP_TAPCELL_ROW_57_1675 VGND VPWR sky130_fd_sc_hd__tapvpwrvgnd_1
XFILLER_1_237 VGND VGND VPWR VPWR sky130_fd_sc_hd__decap_3
XTAP_TAPCELL_ROW_57_1686 VGND VPWR sky130_fd_sc_hd__tapvpwrvgnd_1
XFILLER_46_1338 VGND VGND VPWR VPWR sky130_fd_sc_hd__decap_3
Xclkbuf_4_15__f_clk clkbuf_3_7_0_clk/X VGND VGND VPWR VPWR clkbuf_leaf_47_clk/A sky130_fd_sc_hd__clkbuf_16
XFILLER_44_1040 VGND VGND VPWR VPWR sky130_fd_sc_hd__decap_3
XFILLER_66_24 VGND VGND VPWR VPWR sky130_fd_sc_hd__decap_3
XFILLER_44_1073 VGND VGND VPWR VPWR sky130_fd_sc_hd__decap_3
XFILLER_66_35 VGND VGND VPWR VPWR sky130_fd_sc_hd__decap_3
XFILLER_79_1103 VGND VGND VPWR VPWR sky130_fd_sc_hd__decap_3
Xhold1240 _5953_/X VGND VGND VPWR VPWR _6957_/D sky130_fd_sc_hd__dlygate4sd3_1
XFILLER_46_915 VGND VGND VPWR VPWR sky130_fd_sc_hd__decap_3
XFILLER_57_252 VGND VGND VPWR VPWR sky130_fd_sc_hd__decap_3
XFILLER_66_68 VGND VGND VPWR VPWR sky130_fd_sc_hd__decap_3
Xhold1251 _6803_/Q VGND VGND VPWR VPWR _5760_/A1 sky130_fd_sc_hd__dlygate4sd3_1
XFILLER_73_723 VGND VGND VPWR VPWR sky130_fd_sc_hd__decap_3
Xhold1262 _6979_/Q VGND VGND VPWR VPWR _5975_/A1 sky130_fd_sc_hd__dlygate4sd3_1
XFILLER_79_1136 VGND VGND VPWR VPWR sky130_fd_sc_hd__decap_3
XFILLER_2_1421 VGND VGND VPWR VPWR sky130_fd_sc_hd__decap_3
Xhold1273 _6631_/Q VGND VGND VPWR VPWR _5548_/B1 sky130_fd_sc_hd__dlygate4sd3_1
Xhold1284 _6768_/Q VGND VGND VPWR VPWR _5720_/A1 sky130_fd_sc_hd__dlygate4sd3_1
XFILLER_72_222 VGND VGND VPWR VPWR sky130_fd_sc_hd__fill_1
XFILLER_2_1432 VGND VGND VPWR VPWR sky130_fd_sc_hd__decap_3
XFILLER_22_1371 VGND VGND VPWR VPWR sky130_fd_sc_hd__fill_1
XFILLER_45_436 VGND VGND VPWR VPWR sky130_fd_sc_hd__decap_3
Xhold1295 _6853_/Q VGND VGND VPWR VPWR _5836_/A1 sky130_fd_sc_hd__dlygate4sd3_1
XFILLER_79_1169 VGND VGND VPWR VPWR sky130_fd_sc_hd__decap_3
XFILLER_22_1382 VGND VGND VPWR VPWR sky130_fd_sc_hd__decap_3
XFILLER_45_458 VGND VGND VPWR VPWR sky130_fd_sc_hd__fill_1
XFILLER_2_1465 VGND VGND VPWR VPWR sky130_fd_sc_hd__decap_3
XFILLER_57_1401 VGND VGND VPWR VPWR sky130_fd_sc_hd__decap_3
XFILLER_57_1434 VGND VGND VPWR VPWR sky130_fd_sc_hd__decap_3
XFILLER_14_845 VGND VGND VPWR VPWR sky130_fd_sc_hd__decap_3
XFILLER_13_322 VGND VGND VPWR VPWR sky130_fd_sc_hd__decap_3
XFILLER_18_1418 VGND VGND VPWR VPWR sky130_fd_sc_hd__decap_3
XFILLER_15_50 VGND VGND VPWR VPWR sky130_fd_sc_hd__decap_3
XFILLER_18_1429 VGND VGND VPWR VPWR sky130_fd_sc_hd__decap_3
XFILLER_40_141 VGND VGND VPWR VPWR sky130_fd_sc_hd__decap_3
XFILLER_9_337 VGND VGND VPWR VPWR sky130_fd_sc_hd__decap_3
XFILLER_40_185 VGND VGND VPWR VPWR sky130_fd_sc_hd__decap_3
XFILLER_51_1044 VGND VGND VPWR VPWR sky130_fd_sc_hd__decap_3
XFILLER_5_532 VGND VGND VPWR VPWR sky130_fd_sc_hd__decap_3
XFILLER_5_554 VGND VGND VPWR VPWR sky130_fd_sc_hd__decap_3
XFILLER_31_93 VGND VGND VPWR VPWR sky130_fd_sc_hd__decap_3
XFILLER_56_9 VGND VGND VPWR VPWR sky130_fd_sc_hd__decap_3
XFILLER_5_576 VGND VGND VPWR VPWR sky130_fd_sc_hd__decap_3
XFILLER_64_1427 VGND VGND VPWR VPWR sky130_fd_sc_hd__fill_1
XFILLER_64_1438 VGND VGND VPWR VPWR sky130_fd_sc_hd__decap_3
XFILLER_7_1310 VGND VGND VPWR VPWR sky130_fd_sc_hd__decap_3
XFILLER_1_771 VGND VGND VPWR VPWR sky130_fd_sc_hd__decap_3
XFILLER_27_1260 VGND VGND VPWR VPWR sky130_fd_sc_hd__decap_3
XFILLER_7_1343 VGND VGND VPWR VPWR sky130_fd_sc_hd__fill_1
XFILLER_7_1354 VGND VGND VPWR VPWR sky130_fd_sc_hd__decap_3
XFILLER_0_281 VGND VGND VPWR VPWR sky130_fd_sc_hd__decap_3
XFILLER_49_753 VGND VGND VPWR VPWR sky130_fd_sc_hd__decap_3
XFILLER_3_1207 VGND VGND VPWR VPWR sky130_fd_sc_hd__decap_3
XFILLER_23_1135 VGND VGND VPWR VPWR sky130_fd_sc_hd__fill_1
XFILLER_37_915 VGND VGND VPWR VPWR sky130_fd_sc_hd__decap_3
XFILLER_7_1387 VGND VGND VPWR VPWR sky130_fd_sc_hd__decap_3
X_4980_ _6419_/Q _4980_/B VGND VGND VPWR VPWR _5231_/B sky130_fd_sc_hd__xnor2_2
XFILLER_63_266 VGND VGND VPWR VPWR sky130_fd_sc_hd__decap_3
XFILLER_64_789 VGND VGND VPWR VPWR sky130_fd_sc_hd__decap_3
XTAP_TAPCELL_ROW_19_689 VGND VPWR sky130_fd_sc_hd__tapvpwrvgnd_1
XFILLER_45_992 VGND VGND VPWR VPWR sky130_fd_sc_hd__decap_3
X_3931_ _4347_/B _3931_/B VGND VGND VPWR VPWR _3932_/B sky130_fd_sc_hd__xnor2_2
XFILLER_32_620 VGND VGND VPWR VPWR sky130_fd_sc_hd__decap_3
XFILLER_16_193 VGND VGND VPWR VPWR sky130_fd_sc_hd__decap_3
X_6650_ _7064_/CLK _6650_/D load_slew723/X VGND VGND VPWR VPWR _6650_/Q sky130_fd_sc_hd__dfrtp_2
X_3862_ _3960_/A _6235_/Q VGND VGND VPWR VPWR _3862_/X sky130_fd_sc_hd__and2b_2
X_5601_ _4312_/A _5582_/Y _5601_/B1 _5601_/B2 VGND VGND VPWR VPWR _6673_/D sky130_fd_sc_hd__a22o_2
X_6581_ _7055_/CLK _6581_/D fanout791/A VGND VGND VPWR VPWR _6581_/Q sky130_fd_sc_hd__dfrtp_2
XFILLER_31_185 VGND VGND VPWR VPWR sky130_fd_sc_hd__decap_3
XFILLER_34_1242 VGND VGND VPWR VPWR sky130_fd_sc_hd__decap_3
X_3793_ _3793_/A _3793_/B VGND VGND VPWR VPWR _3794_/C sky130_fd_sc_hd__xor2_2
XFILLER_34_1264 VGND VGND VPWR VPWR sky130_fd_sc_hd__decap_3
X_5532_ _6614_/Q _3097_/B _5534_/B1 _6615_/Q VGND VGND VPWR VPWR _6615_/D sky130_fd_sc_hd__a22o_2
XFILLER_9_871 VGND VGND VPWR VPWR sky130_fd_sc_hd__decap_3
XFILLER_34_1297 VGND VGND VPWR VPWR sky130_fd_sc_hd__decap_3
XFILLER_69_1316 VGND VGND VPWR VPWR sky130_fd_sc_hd__decap_3
X_5463_ _5463_/A1 _5487_/A2 _4779_/X VGND VGND VPWR VPWR _6575_/D sky130_fd_sc_hd__a21o_2
X_4414_ _6510_/Q _4413_/A _4771_/C1 VGND VGND VPWR VPWR _4414_/X sky130_fd_sc_hd__a21bo_2
X_5394_ _5394_/A1 _5453_/A2 _4382_/X VGND VGND VPWR VPWR _6506_/D sky130_fd_sc_hd__a21o_2
XFILLER_67_1051 VGND VGND VPWR VPWR sky130_fd_sc_hd__decap_3
X_4345_ _5508_/A _4420_/B _4608_/B _4344_/B VGND VGND VPWR VPWR _4345_/X sky130_fd_sc_hd__or4b_2
Xfanout316 _4261_/A2 VGND VGND VPWR VPWR _4174_/A2 sky130_fd_sc_hd__clkdlybuf4s25_1
XFILLER_59_517 VGND VGND VPWR VPWR sky130_fd_sc_hd__fill_2
XFILLER_8_1129 VGND VGND VPWR VPWR sky130_fd_sc_hd__decap_3
Xfanout327 _5567_/B VGND VGND VPWR VPWR _5552_/B2 sky130_fd_sc_hd__clkdlybuf4s25_1
XFILLER_28_1068 VGND VGND VPWR VPWR sky130_fd_sc_hd__decap_3
Xfanout338 _4771_/A1 VGND VGND VPWR VPWR wire339/A sky130_fd_sc_hd__clkdlybuf4s25_1
X_7064_ _7064_/CLK _7064_/D load_slew720/X VGND VGND VPWR VPWR _7064_/Q sky130_fd_sc_hd__dfrtp_2
X_4276_ _6264_/Q wire49/X _4273_/X _4275_/X VGND VGND VPWR VPWR _6264_/D sky130_fd_sc_hd__o22a_2
XFILLER_45_1360 VGND VGND VPWR VPWR sky130_fd_sc_hd__decap_3
XFILLER_80_1251 VGND VGND VPWR VPWR sky130_fd_sc_hd__decap_3
XTAP_TAPCELL_ROW_52_1550 VGND VPWR sky130_fd_sc_hd__tapvpwrvgnd_1
XTAP_TAPCELL_ROW_52_1561 VGND VPWR sky130_fd_sc_hd__tapvpwrvgnd_1
X_3227_ hold917/X _3226_/X _3355_/S VGND VGND VPWR VPWR _6087_/D sky130_fd_sc_hd__mux2_1
X_6015_ _6015_/A0 _6015_/A1 _6015_/S VGND VGND VPWR VPWR _7019_/D sky130_fd_sc_hd__mux2_1
XFILLER_80_1273 VGND VGND VPWR VPWR sky130_fd_sc_hd__decap_3
XFILLER_45_1393 VGND VGND VPWR VPWR sky130_fd_sc_hd__decap_3
XFILLER_80_1295 VGND VGND VPWR VPWR sky130_fd_sc_hd__decap_3
XFILLER_41_1257 VGND VGND VPWR VPWR sky130_fd_sc_hd__decap_3
XFILLER_28_937 VGND VGND VPWR VPWR sky130_fd_sc_hd__fill_2
X_3158_ _7005_/Q _3207_/B2 _6076_/A1 _3157_/X VGND VGND VPWR VPWR _3158_/X sky130_fd_sc_hd__a22o_2
XFILLER_39_296 VGND VGND VPWR VPWR sky130_fd_sc_hd__decap_3
XFILLER_76_1309 VGND VGND VPWR VPWR sky130_fd_sc_hd__decap_3
XTAP_TAPCELL_ROW_65_1900 VGND VPWR sky130_fd_sc_hd__tapvpwrvgnd_1
X_3089_ _5569_/A _3089_/B VGND VGND VPWR VPWR _7083_/D sky130_fd_sc_hd__nor2_2
XFILLER_70_715 VGND VGND VPWR VPWR sky130_fd_sc_hd__decap_3
XFILLER_54_277 VGND VGND VPWR VPWR sky130_fd_sc_hd__decap_3
X_6917_ clkload7/A _6917_/D load_slew643/X VGND VGND VPWR VPWR _6917_/Q sky130_fd_sc_hd__dfrtp_2
XFILLER_78_1191 VGND VGND VPWR VPWR sky130_fd_sc_hd__decap_3
XFILLER_23_642 VGND VGND VPWR VPWR sky130_fd_sc_hd__decap_3
XFILLER_51_951 VGND VGND VPWR VPWR sky130_fd_sc_hd__fill_1
XFILLER_22_130 VGND VGND VPWR VPWR sky130_fd_sc_hd__fill_1
XFILLER_39_1186 VGND VGND VPWR VPWR sky130_fd_sc_hd__fill_1
X_6848_ _7073_/CLK _6848_/D wire687/X VGND VGND VPWR VPWR _6848_/Q sky130_fd_sc_hd__dfrtp_2
XTAP_TAPCELL_ROW_46_1387 VGND VPWR sky130_fd_sc_hd__tapvpwrvgnd_1
XFILLER_74_1088 VGND VGND VPWR VPWR sky130_fd_sc_hd__decap_3
XFILLER_22_163 VGND VGND VPWR VPWR sky130_fd_sc_hd__decap_3
XTAP_TAPCELL_ROW_46_1398 VGND VPWR sky130_fd_sc_hd__tapvpwrvgnd_1
XFILLER_50_472 VGND VGND VPWR VPWR sky130_fd_sc_hd__decap_3
XFILLER_51_995 VGND VGND VPWR VPWR sky130_fd_sc_hd__decap_3
XFILLER_74_1099 VGND VGND VPWR VPWR sky130_fd_sc_hd__decap_3
XFILLER_11_837 VGND VGND VPWR VPWR sky130_fd_sc_hd__decap_3
XFILLER_17_1440 VGND VGND VPWR VPWR sky130_fd_sc_hd__decap_3
XFILLER_52_1320 VGND VGND VPWR VPWR sky130_fd_sc_hd__decap_3
XFILLER_50_483 VGND VGND VPWR VPWR sky130_fd_sc_hd__fill_2
X_6779_ _7035_/CLK _6779_/D load_slew831/X VGND VGND VPWR VPWR _6779_/Q sky130_fd_sc_hd__dfrtp_2
XFILLER_13_1304 VGND VGND VPWR VPWR sky130_fd_sc_hd__decap_3
XFILLER_10_347 VGND VGND VPWR VPWR sky130_fd_sc_hd__decap_3
XFILLER_52_1353 VGND VGND VPWR VPWR sky130_fd_sc_hd__decap_3
XFILLER_13_1337 VGND VGND VPWR VPWR sky130_fd_sc_hd__decap_3
XFILLER_13_1348 VGND VGND VPWR VPWR sky130_fd_sc_hd__decap_3
XFILLER_52_1397 VGND VGND VPWR VPWR sky130_fd_sc_hd__decap_3
XTAP_TAPCELL_ROW_59_1726 VGND VPWR sky130_fd_sc_hd__tapvpwrvgnd_1
XTAP_TAPCELL_ROW_59_1737 VGND VPWR sky130_fd_sc_hd__tapvpwrvgnd_1
XFILLER_2_524 VGND VGND VPWR VPWR sky130_fd_sc_hd__decap_3
XFILLER_77_12 VGND VGND VPWR VPWR sky130_fd_sc_hd__decap_3
XFILLER_2_568 VGND VGND VPWR VPWR sky130_fd_sc_hd__decap_3
XFILLER_77_45 VGND VGND VPWR VPWR sky130_fd_sc_hd__decap_3
XFILLER_24_1400 VGND VGND VPWR VPWR sky130_fd_sc_hd__decap_3
XFILLER_77_78 VGND VGND VPWR VPWR sky130_fd_sc_hd__decap_3
XFILLER_63_1460 VGND VGND VPWR VPWR sky130_fd_sc_hd__decap_3
XTAP_TAPCELL_ROW_5_340 VGND VPWR sky130_fd_sc_hd__tapvpwrvgnd_1
XFILLER_24_1444 VGND VGND VPWR VPWR sky130_fd_sc_hd__decap_3
XFILLER_19_915 VGND VGND VPWR VPWR sky130_fd_sc_hd__decap_3
XFILLER_46_701 VGND VGND VPWR VPWR sky130_fd_sc_hd__decap_3
Xhold1070 _6686_/Q VGND VGND VPWR VPWR _5624_/A0 sky130_fd_sc_hd__dlygate4sd3_1
XTAP_TAPCELL_ROW_29_943 VGND VPWR sky130_fd_sc_hd__tapvpwrvgnd_1
Xhold1081 _7019_/Q VGND VGND VPWR VPWR _6015_/A1 sky130_fd_sc_hd__dlygate4sd3_1
XTAP_TAPCELL_ROW_29_954 VGND VPWR sky130_fd_sc_hd__tapvpwrvgnd_1
Xhold1092 _6840_/Q VGND VGND VPWR VPWR _5821_/A0 sky130_fd_sc_hd__dlygate4sd3_1
XFILLER_18_469 VGND VGND VPWR VPWR sky130_fd_sc_hd__decap_3
XTAP_TAPCELL_ROW_29_965 VGND VPWR sky130_fd_sc_hd__tapvpwrvgnd_1
XFILLER_2_1273 VGND VGND VPWR VPWR sky130_fd_sc_hd__decap_3
XTAP_TAPCELL_ROW_16_604 VGND VPWR sky130_fd_sc_hd__tapvpwrvgnd_1
XTAP_TAPCELL_ROW_16_615 VGND VPWR sky130_fd_sc_hd__tapvpwrvgnd_1
XFILLER_73_597 VGND VGND VPWR VPWR sky130_fd_sc_hd__decap_3
XTAP_TAPCELL_ROW_16_626 VGND VPWR sky130_fd_sc_hd__tapvpwrvgnd_1
XFILLER_26_82 VGND VGND VPWR VPWR sky130_fd_sc_hd__fill_2
XFILLER_57_1242 VGND VGND VPWR VPWR sky130_fd_sc_hd__decap_3
XFILLER_26_491 VGND VGND VPWR VPWR sky130_fd_sc_hd__decap_3
XFILLER_18_1226 VGND VGND VPWR VPWR sky130_fd_sc_hd__decap_3
XFILLER_57_1275 VGND VGND VPWR VPWR sky130_fd_sc_hd__decap_3
XFILLER_53_1117 VGND VGND VPWR VPWR sky130_fd_sc_hd__decap_3
XFILLER_14_675 VGND VGND VPWR VPWR sky130_fd_sc_hd__fill_1
XFILLER_18_1259 VGND VGND VPWR VPWR sky130_fd_sc_hd__fill_1
XFILLER_53_1139 VGND VGND VPWR VPWR sky130_fd_sc_hd__decap_3
XFILLER_41_494 VGND VGND VPWR VPWR sky130_fd_sc_hd__fill_1
XFILLER_70_1453 VGND VGND VPWR VPWR sky130_fd_sc_hd__decap_3
XFILLER_31_1404 VGND VGND VPWR VPWR sky130_fd_sc_hd__decap_3
XFILLER_9_178 VGND VGND VPWR VPWR sky130_fd_sc_hd__decap_3
XFILLER_31_1437 VGND VGND VPWR VPWR sky130_fd_sc_hd__decap_3
XFILLER_5_340 VGND VGND VPWR VPWR sky130_fd_sc_hd__fill_2
XFILLER_54_6 VGND VGND VPWR VPWR sky130_fd_sc_hd__decap_3
XFILLER_29_1322 VGND VGND VPWR VPWR sky130_fd_sc_hd__decap_3
XFILLER_68_1371 VGND VGND VPWR VPWR sky130_fd_sc_hd__fill_1
XFILLER_68_1382 VGND VGND VPWR VPWR sky130_fd_sc_hd__decap_3
XFILLER_9_1416 VGND VGND VPWR VPWR sky130_fd_sc_hd__decap_3
XFILLER_64_1235 VGND VGND VPWR VPWR sky130_fd_sc_hd__decap_3
XFILLER_29_1366 VGND VGND VPWR VPWR sky130_fd_sc_hd__decap_3
XFILLER_68_303 VGND VGND VPWR VPWR sky130_fd_sc_hd__decap_3
XFILLER_69_826 VGND VGND VPWR VPWR sky130_fd_sc_hd__decap_3
X_4130_ _4281_/B _4279_/B VGND VGND VPWR VPWR _4131_/B sky130_fd_sc_hd__xor2_2
XFILLER_9_1449 VGND VGND VPWR VPWR sky130_fd_sc_hd__decap_3
XFILLER_3_42 VGND VGND VPWR VPWR sky130_fd_sc_hd__decap_3
XFILLER_29_1399 VGND VGND VPWR VPWR sky130_fd_sc_hd__fill_1
XFILLER_64_1279 VGND VGND VPWR VPWR sky130_fd_sc_hd__decap_3
XFILLER_3_75 VGND VGND VPWR VPWR sky130_fd_sc_hd__decap_3
XTAP_TAPCELL_ROW_69_2000 VGND VPWR sky130_fd_sc_hd__tapvpwrvgnd_1
XFILLER_56_509 VGND VGND VPWR VPWR sky130_fd_sc_hd__decap_3
X_4061_ _4061_/A1 _4058_/X _4059_/Y _4060_/X _4013_/A VGND VGND VPWR VPWR _4061_/X
+ sky130_fd_sc_hd__o221a_2
XFILLER_7_1151 VGND VGND VPWR VPWR sky130_fd_sc_hd__decap_3
XFILLER_49_561 VGND VGND VPWR VPWR sky130_fd_sc_hd__fill_2
XFILLER_3_1015 VGND VGND VPWR VPWR sky130_fd_sc_hd__decap_3
XFILLER_7_1195 VGND VGND VPWR VPWR sky130_fd_sc_hd__decap_3
XFILLER_3_1048 VGND VGND VPWR VPWR sky130_fd_sc_hd__decap_3
Xwire26 wire26/A VGND VGND VPWR VPWR wire26/X sky130_fd_sc_hd__buf_2
XFILLER_36_244 VGND VGND VPWR VPWR sky130_fd_sc_hd__decap_3
XFILLER_52_704 VGND VGND VPWR VPWR sky130_fd_sc_hd__decap_3
XFILLER_24_406 VGND VGND VPWR VPWR sky130_fd_sc_hd__decap_3
XFILLER_18_981 VGND VGND VPWR VPWR sky130_fd_sc_hd__decap_3
XFILLER_75_1331 VGND VGND VPWR VPWR sky130_fd_sc_hd__decap_3
XFILLER_51_225 VGND VGND VPWR VPWR sky130_fd_sc_hd__decap_3
X_4963_ _6690_/Q _3056_/Y _4963_/S VGND VGND VPWR VPWR _4963_/X sky130_fd_sc_hd__mux2_1
XFILLER_17_491 VGND VGND VPWR VPWR sky130_fd_sc_hd__decap_3
X_6702_ _7046_/CLK _6702_/D load_slew744/X VGND VGND VPWR VPWR _6702_/Q sky130_fd_sc_hd__dfrtp_2
XFILLER_36_1315 VGND VGND VPWR VPWR sky130_fd_sc_hd__fill_1
XFILLER_75_1375 VGND VGND VPWR VPWR sky130_fd_sc_hd__decap_3
X_3914_ _3913_/A _3913_/B _3913_/C VGND VGND VPWR VPWR _3915_/B sky130_fd_sc_hd__a21oi_2
XFILLER_36_1326 VGND VGND VPWR VPWR sky130_fd_sc_hd__decap_3
XFILLER_71_1228 VGND VGND VPWR VPWR sky130_fd_sc_hd__decap_3
X_4894_ _4894_/A _4894_/B VGND VGND VPWR VPWR _4894_/Y sky130_fd_sc_hd__nor2_2
XFILLER_71_1239 VGND VGND VPWR VPWR sky130_fd_sc_hd__decap_3
XFILLER_36_1359 VGND VGND VPWR VPWR sky130_fd_sc_hd__decap_3
X_6633_ _7025_/CLK _6633_/D load_slew728/X VGND VGND VPWR VPWR _6633_/Q sky130_fd_sc_hd__dfrtp_2
X_3845_ _6275_/Q _3960_/B _3921_/B1 _6251_/Q _3921_/C1 VGND VGND VPWR VPWR _3845_/X
+ sky130_fd_sc_hd__a221o_2
XFILLER_20_645 VGND VGND VPWR VPWR sky130_fd_sc_hd__fill_2
XFILLER_22_18 VGND VGND VPWR VPWR sky130_fd_sc_hd__fill_1
XTAP_TAPCELL_ROW_41_1262 VGND VPWR sky130_fd_sc_hd__tapvpwrvgnd_1
X_6564_ _7001_/CLK _6564_/D load_slew773/X VGND VGND VPWR VPWR _6564_/Q sky130_fd_sc_hd__dfrtp_2
X_3776_ _4211_/A _4121_/B VGND VGND VPWR VPWR _3781_/A sky130_fd_sc_hd__xor2_2
XTAP_TAPCELL_ROW_41_1273 VGND VPWR sky130_fd_sc_hd__tapvpwrvgnd_1
X_5515_ _5515_/A1 _5504_/Y _5513_/A _5514_/Y VGND VGND VPWR VPWR _6607_/D sky130_fd_sc_hd__o211a_2
X_6495_ _6929_/CLK _6495_/D fanout706/X VGND VGND VPWR VPWR _6495_/Q sky130_fd_sc_hd__dfrtp_2
XFILLER_69_1135 VGND VGND VPWR VPWR sky130_fd_sc_hd__decap_3
X_5446_ _5446_/A1 _5478_/A2 _4712_/X VGND VGND VPWR VPWR _6558_/D sky130_fd_sc_hd__a21o_2
XFILLER_69_1168 VGND VGND VPWR VPWR sky130_fd_sc_hd__decap_3
XTAP_TAPCELL_ROW_54_1601 VGND VPWR sky130_fd_sc_hd__tapvpwrvgnd_1
XFILLER_47_1422 VGND VGND VPWR VPWR sky130_fd_sc_hd__decap_3
XTAP_TAPCELL_ROW_54_1612 VGND VPWR sky130_fd_sc_hd__tapvpwrvgnd_1
X_5377_ _5377_/A1 _5465_/A2 _4285_/X VGND VGND VPWR VPWR _6489_/D sky130_fd_sc_hd__a21o_2
XFILLER_47_1455 VGND VGND VPWR VPWR sky130_fd_sc_hd__fill_1
XFILLER_47_1466 VGND VGND VPWR VPWR sky130_fd_sc_hd__decap_3
Xfanout113 fanout121/X VGND VGND VPWR VPWR _5284_/A2 sky130_fd_sc_hd__clkdlybuf4s25_1
Xfanout124 _5355_/S VGND VGND VPWR VPWR _5327_/S sky130_fd_sc_hd__clkdlybuf4s25_1
X_4328_ _4328_/A _4328_/B VGND VGND VPWR VPWR _4703_/B sky130_fd_sc_hd__xnor2_2
XFILLER_43_1319 VGND VGND VPWR VPWR sky130_fd_sc_hd__decap_3
XTAP_TAPCELL_ROW_50_1509 VGND VPWR sky130_fd_sc_hd__tapvpwrvgnd_1
X_7047_ _7055_/CLK _7047_/D wire796/X VGND VGND VPWR VPWR _7047_/Q sky130_fd_sc_hd__dfrtp_2
XFILLER_75_829 VGND VGND VPWR VPWR sky130_fd_sc_hd__fill_2
XTAP_TAPCELL_ROW_35_1099 VGND VPWR sky130_fd_sc_hd__tapvpwrvgnd_1
X_4259_ _4259_/A _4259_/B VGND VGND VPWR VPWR _4836_/B sky130_fd_sc_hd__xnor2_2
XFILLER_28_701 VGND VGND VPWR VPWR sky130_fd_sc_hd__decap_3
XFILLER_27_200 VGND VGND VPWR VPWR sky130_fd_sc_hd__decap_3
XFILLER_68_892 VGND VGND VPWR VPWR sky130_fd_sc_hd__decap_3
XFILLER_41_1065 VGND VGND VPWR VPWR sky130_fd_sc_hd__decap_3
XFILLER_55_520 VGND VGND VPWR VPWR sky130_fd_sc_hd__decap_3
XFILLER_67_391 VGND VGND VPWR VPWR sky130_fd_sc_hd__fill_1
XFILLER_76_1117 VGND VGND VPWR VPWR sky130_fd_sc_hd__decap_3
XFILLER_42_203 VGND VGND VPWR VPWR sky130_fd_sc_hd__decap_3
XTAP_TAPCELL_ROW_48_1438 VGND VPWR sky130_fd_sc_hd__tapvpwrvgnd_1
XTAP_TAPCELL_ROW_48_1449 VGND VPWR sky130_fd_sc_hd__tapvpwrvgnd_1
XFILLER_63_36 VGND VGND VPWR VPWR sky130_fd_sc_hd__decap_3
XFILLER_42_225 VGND VGND VPWR VPWR sky130_fd_sc_hd__decap_3
XFILLER_24_962 VGND VGND VPWR VPWR sky130_fd_sc_hd__decap_3
XFILLER_70_578 VGND VGND VPWR VPWR sky130_fd_sc_hd__decap_3
XFILLER_54_1415 VGND VGND VPWR VPWR sky130_fd_sc_hd__decap_3
XFILLER_24_984 VGND VGND VPWR VPWR sky130_fd_sc_hd__decap_3
XFILLER_54_1459 VGND VGND VPWR VPWR sky130_fd_sc_hd__decap_3
XFILLER_10_100 VGND VGND VPWR VPWR sky130_fd_sc_hd__decap_3
Xwire503 _3489_/A VGND VGND VPWR VPWR wire503/X sky130_fd_sc_hd__clkbuf_4
XFILLER_17_1281 VGND VGND VPWR VPWR sky130_fd_sc_hd__decap_3
XFILLER_17_1292 VGND VGND VPWR VPWR sky130_fd_sc_hd__decap_3
XFILLER_7_649 VGND VGND VPWR VPWR sky130_fd_sc_hd__decap_3
XFILLER_6_137 VGND VGND VPWR VPWR sky130_fd_sc_hd__decap_3
XFILLER_3_800 VGND VGND VPWR VPWR sky130_fd_sc_hd__decap_3
XFILLER_3_833 VGND VGND VPWR VPWR sky130_fd_sc_hd__decap_3
XFILLER_3_844 VGND VGND VPWR VPWR sky130_fd_sc_hd__decap_3
XFILLER_3_877 VGND VGND VPWR VPWR sky130_fd_sc_hd__decap_3
XFILLER_2_354 VGND VGND VPWR VPWR sky130_fd_sc_hd__decap_3
XFILLER_2_365 VGND VGND VPWR VPWR sky130_fd_sc_hd__decap_3
XFILLER_2_398 VGND VGND VPWR VPWR sky130_fd_sc_hd__decap_3
XFILLER_61_1419 VGND VGND VPWR VPWR sky130_fd_sc_hd__decap_3
XFILLER_78_645 VGND VGND VPWR VPWR sky130_fd_sc_hd__decap_3
XFILLER_38_509 VGND VGND VPWR VPWR sky130_fd_sc_hd__fill_1
Xfanout680 fanout682/X VGND VGND VPWR VPWR fanout680/X sky130_fd_sc_hd__clkdlybuf4s25_1
XFILLER_19_701 VGND VGND VPWR VPWR sky130_fd_sc_hd__decap_3
XFILLER_24_1241 VGND VGND VPWR VPWR sky130_fd_sc_hd__decap_3
XFILLER_77_177 VGND VGND VPWR VPWR sky130_fd_sc_hd__fill_1
XFILLER_19_9 VGND VGND VPWR VPWR sky130_fd_sc_hd__decap_3
Xfanout691 fanout698/X VGND VGND VPWR VPWR fanout691/X sky130_fd_sc_hd__clkdlybuf4s25_1
XFILLER_4_1335 VGND VGND VPWR VPWR sky130_fd_sc_hd__decap_3
XFILLER_18_200 VGND VGND VPWR VPWR sky130_fd_sc_hd__fill_1
XFILLER_24_1285 VGND VGND VPWR VPWR sky130_fd_sc_hd__decap_3
XFILLER_18_233 VGND VGND VPWR VPWR sky130_fd_sc_hd__decap_3
XFILLER_20_1127 VGND VGND VPWR VPWR sky130_fd_sc_hd__fill_2
XFILLER_46_542 VGND VGND VPWR VPWR sky130_fd_sc_hd__decap_3
XFILLER_4_1368 VGND VGND VPWR VPWR sky130_fd_sc_hd__decap_3
XFILLER_59_1304 VGND VGND VPWR VPWR sky130_fd_sc_hd__decap_3
XFILLER_80_309 VGND VGND VPWR VPWR sky130_fd_sc_hd__decap_3
XFILLER_4_1379 VGND VGND VPWR VPWR sky130_fd_sc_hd__decap_3
XFILLER_20_1149 VGND VGND VPWR VPWR sky130_fd_sc_hd__decap_3
XFILLER_59_1337 VGND VGND VPWR VPWR sky130_fd_sc_hd__decap_3
XFILLER_61_501 VGND VGND VPWR VPWR sky130_fd_sc_hd__decap_3
XFILLER_59_1348 VGND VGND VPWR VPWR sky130_fd_sc_hd__decap_3
XFILLER_2_1070 VGND VGND VPWR VPWR sky130_fd_sc_hd__decap_3
XFILLER_33_225 VGND VGND VPWR VPWR sky130_fd_sc_hd__fill_1
XFILLER_14_461 VGND VGND VPWR VPWR sky130_fd_sc_hd__decap_3
XFILLER_42_770 VGND VGND VPWR VPWR sky130_fd_sc_hd__decap_3
XFILLER_14_483 VGND VGND VPWR VPWR sky130_fd_sc_hd__decap_3
XFILLER_30_932 VGND VGND VPWR VPWR sky130_fd_sc_hd__fill_1
XFILLER_70_1250 VGND VGND VPWR VPWR sky130_fd_sc_hd__decap_3
XFILLER_70_1261 VGND VGND VPWR VPWR sky130_fd_sc_hd__decap_3
XFILLER_30_987 VGND VGND VPWR VPWR sky130_fd_sc_hd__decap_3
XFILLER_35_1381 VGND VGND VPWR VPWR sky130_fd_sc_hd__decap_3
X_3630_ _6626_/Q _5600_/A2 _5606_/A2 _6634_/Q _3630_/C1 VGND VGND VPWR VPWR _3630_/X
+ sky130_fd_sc_hd__a221o_2
XFILLER_70_1294 VGND VGND VPWR VPWR sky130_fd_sc_hd__decap_3
XFILLER_31_1245 VGND VGND VPWR VPWR sky130_fd_sc_hd__decap_3
X_3561_ _3486_/A _3560_/X _3552_/X VGND VGND VPWR VPWR _3561_/Y sky130_fd_sc_hd__a21oi_2
XFILLER_31_1278 VGND VGND VPWR VPWR sky130_fd_sc_hd__decap_3
XFILLER_6_671 VGND VGND VPWR VPWR sky130_fd_sc_hd__fill_1
XFILLER_31_1289 VGND VGND VPWR VPWR sky130_fd_sc_hd__decap_3
X_5300_ _6781_/Q _4924_/B _5306_/S VGND VGND VPWR VPWR _5300_/X sky130_fd_sc_hd__mux2_1
XFILLER_52_3 VGND VGND VPWR VPWR sky130_fd_sc_hd__decap_3
X_3492_ _5508_/A _4369_/B VGND VGND VPWR VPWR _4842_/C sky130_fd_sc_hd__or2_2
X_6280_ _6986_/CLK _6280_/D load_slew650/X VGND VGND VPWR VPWR _6280_/Q sky130_fd_sc_hd__dfrtp_2
XFILLER_6_693 VGND VGND VPWR VPWR sky130_fd_sc_hd__decap_3
X_5231_ _5332_/S _5231_/B VGND VGND VPWR VPWR _5231_/Y sky130_fd_sc_hd__nand2_2
XFILLER_68_1190 VGND VGND VPWR VPWR sky130_fd_sc_hd__decap_3
XFILLER_9_1213 VGND VGND VPWR VPWR sky130_fd_sc_hd__decap_3
XFILLER_64_1032 VGND VGND VPWR VPWR sky130_fd_sc_hd__decap_3
XFILLER_29_1163 VGND VGND VPWR VPWR sky130_fd_sc_hd__decap_3
XFILLER_64_1043 VGND VGND VPWR VPWR sky130_fd_sc_hd__fill_2
X_5162_ _6728_/Q _5322_/S VGND VGND VPWR VPWR _5162_/X sky130_fd_sc_hd__or2_2
XFILLER_29_1174 VGND VGND VPWR VPWR sky130_fd_sc_hd__fill_2
XFILLER_9_1257 VGND VGND VPWR VPWR sky130_fd_sc_hd__decap_3
XFILLER_25_1027 VGND VGND VPWR VPWR sky130_fd_sc_hd__decap_3
XFILLER_64_1087 VGND VGND VPWR VPWR sky130_fd_sc_hd__decap_3
X_4113_ _4338_/A _4725_/B _4796_/A VGND VGND VPWR VPWR _4113_/Y sky130_fd_sc_hd__a21oi_2
X_5093_ _6370_/Q _5090_/X _5092_/X _5305_/S VGND VGND VPWR VPWR _6370_/D sky130_fd_sc_hd__a22o_2
XFILLER_42_1341 VGND VGND VPWR VPWR sky130_fd_sc_hd__decap_3
XFILLER_56_339 VGND VGND VPWR VPWR sky130_fd_sc_hd__decap_3
X_4044_ _3412_/X _4765_/B2 _4766_/A2 _6903_/Q _4068_/C1 VGND VGND VPWR VPWR _4044_/X
+ sky130_fd_sc_hd__a221o_2
XFILLER_42_1385 VGND VGND VPWR VPWR sky130_fd_sc_hd__decap_3
XFILLER_77_1404 VGND VGND VPWR VPWR sky130_fd_sc_hd__decap_3
XFILLER_71_309 VGND VGND VPWR VPWR sky130_fd_sc_hd__fill_1
XFILLER_77_1437 VGND VGND VPWR VPWR sky130_fd_sc_hd__decap_3
XFILLER_25_726 VGND VGND VPWR VPWR sky130_fd_sc_hd__fill_2
XFILLER_24_236 VGND VGND VPWR VPWR sky130_fd_sc_hd__fill_1
X_5995_ hold939/X _6999_/Q _6035_/S VGND VGND VPWR VPWR _5995_/X sky130_fd_sc_hd__mux2_1
X_4946_ _6382_/Q _5216_/B VGND VGND VPWR VPWR _4946_/X sky130_fd_sc_hd__or2_2
XFILLER_52_589 VGND VGND VPWR VPWR sky130_fd_sc_hd__fill_2
XFILLER_75_1172 VGND VGND VPWR VPWR sky130_fd_sc_hd__decap_3
XTAP_TAPCELL_ROW_43_1313 VGND VPWR sky130_fd_sc_hd__tapvpwrvgnd_1
XFILLER_75_1183 VGND VGND VPWR VPWR sky130_fd_sc_hd__decap_3
XFILLER_21_921 VGND VGND VPWR VPWR sky130_fd_sc_hd__decap_3
XTAP_TAPCELL_ROW_43_1324 VGND VPWR sky130_fd_sc_hd__tapvpwrvgnd_1
XFILLER_36_1145 VGND VGND VPWR VPWR sky130_fd_sc_hd__decap_3
XFILLER_71_1036 VGND VGND VPWR VPWR sky130_fd_sc_hd__decap_3
XFILLER_32_280 VGND VGND VPWR VPWR sky130_fd_sc_hd__decap_3
X_4877_ _6340_/Q wire60/X _4874_/X _4876_/X VGND VGND VPWR VPWR _6340_/D sky130_fd_sc_hd__o22a_2
XFILLER_21_965 VGND VGND VPWR VPWR sky130_fd_sc_hd__decap_3
X_6616_ _6617_/CLK _6616_/D load_slew732/X VGND VGND VPWR VPWR _6616_/Q sky130_fd_sc_hd__dfrtp_2
XFILLER_14_1421 VGND VGND VPWR VPWR sky130_fd_sc_hd__decap_3
XFILLER_14_1432 VGND VGND VPWR VPWR sky130_fd_sc_hd__decap_3
X_3828_ _3855_/B _3855_/C VGND VGND VPWR VPWR _3830_/A sky130_fd_sc_hd__and2_2
XFILLER_20_475 VGND VGND VPWR VPWR sky130_fd_sc_hd__fill_1
XFILLER_14_1465 VGND VGND VPWR VPWR sky130_fd_sc_hd__decap_3
X_6547_ _7016_/CLK _6547_/D load_slew664/X VGND VGND VPWR VPWR _6547_/Q sky130_fd_sc_hd__dfrtp_2
X_3759_ _3760_/A _3760_/B _3760_/C VGND VGND VPWR VPWR _3789_/A sky130_fd_sc_hd__a21oi_2
XFILLER_10_1329 VGND VGND VPWR VPWR sky130_fd_sc_hd__decap_3
XFILLER_4_619 VGND VGND VPWR VPWR sky130_fd_sc_hd__decap_3
X_6478_ _6912_/CLK _6478_/D wire715/X VGND VGND VPWR VPWR _6478_/Q sky130_fd_sc_hd__dfrtp_2
X_5429_ _5429_/A1 _5461_/A2 _4590_/X VGND VGND VPWR VPWR _6541_/D sky130_fd_sc_hd__a21o_2
XFILLER_0_803 VGND VGND VPWR VPWR sky130_fd_sc_hd__decap_3
XFILLER_47_1230 VGND VGND VPWR VPWR sky130_fd_sc_hd__fill_2
XFILLER_0_825 VGND VGND VPWR VPWR sky130_fd_sc_hd__decap_3
XFILLER_47_1263 VGND VGND VPWR VPWR sky130_fd_sc_hd__decap_3
XFILLER_0_847 VGND VGND VPWR VPWR sky130_fd_sc_hd__decap_3
XFILLER_59_122 VGND VGND VPWR VPWR sky130_fd_sc_hd__decap_3
XFILLER_0_869 VGND VGND VPWR VPWR sky130_fd_sc_hd__decap_3
XFILLER_43_1149 VGND VGND VPWR VPWR sky130_fd_sc_hd__fill_2
XFILLER_47_306 VGND VGND VPWR VPWR sky130_fd_sc_hd__decap_3
XFILLER_75_626 VGND VGND VPWR VPWR sky130_fd_sc_hd__fill_2
XFILLER_60_1441 VGND VGND VPWR VPWR sky130_fd_sc_hd__decap_3
XFILLER_74_114 VGND VGND VPWR VPWR sky130_fd_sc_hd__decap_3
XFILLER_21_1425 VGND VGND VPWR VPWR sky130_fd_sc_hd__decap_3
XFILLER_28_520 VGND VGND VPWR VPWR sky130_fd_sc_hd__fill_2
XFILLER_74_24 VGND VGND VPWR VPWR sky130_fd_sc_hd__decap_3
XFILLER_74_35 VGND VGND VPWR VPWR sky130_fd_sc_hd__decap_3
XFILLER_16_704 VGND VGND VPWR VPWR sky130_fd_sc_hd__decap_3
XFILLER_62_309 VGND VGND VPWR VPWR sky130_fd_sc_hd__decap_3
XFILLER_16_715 VGND VGND VPWR VPWR sky130_fd_sc_hd__decap_3
XFILLER_74_68 VGND VGND VPWR VPWR sky130_fd_sc_hd__decap_3
XFILLER_55_372 VGND VGND VPWR VPWR sky130_fd_sc_hd__decap_3
XFILLER_71_832 VGND VGND VPWR VPWR sky130_fd_sc_hd__fill_1
XFILLER_15_225 VGND VGND VPWR VPWR sky130_fd_sc_hd__decap_3
XFILLER_3_1390 VGND VGND VPWR VPWR sky130_fd_sc_hd__decap_3
XFILLER_43_534 VGND VGND VPWR VPWR sky130_fd_sc_hd__decap_3
XFILLER_15_258 VGND VGND VPWR VPWR sky130_fd_sc_hd__decap_3
XFILLER_19_1310 VGND VGND VPWR VPWR sky130_fd_sc_hd__decap_3
XFILLER_31_729 VGND VGND VPWR VPWR sky130_fd_sc_hd__decap_3
XFILLER_19_1343 VGND VGND VPWR VPWR sky130_fd_sc_hd__fill_1
XFILLER_19_1354 VGND VGND VPWR VPWR sky130_fd_sc_hd__decap_3
XFILLER_12_943 VGND VGND VPWR VPWR sky130_fd_sc_hd__decap_3
XFILLER_15_1207 VGND VGND VPWR VPWR sky130_fd_sc_hd__decap_3
XFILLER_54_1256 VGND VGND VPWR VPWR sky130_fd_sc_hd__decap_3
XFILLER_11_431 VGND VGND VPWR VPWR sky130_fd_sc_hd__decap_3
XFILLER_19_1387 VGND VGND VPWR VPWR sky130_fd_sc_hd__decap_3
XFILLER_54_1267 VGND VGND VPWR VPWR sky130_fd_sc_hd__decap_3
XFILLER_7_402 VGND VGND VPWR VPWR sky130_fd_sc_hd__decap_3
XFILLER_7_479 VGND VGND VPWR VPWR sky130_fd_sc_hd__decap_3
XFILLER_3_652 VGND VGND VPWR VPWR sky130_fd_sc_hd__decap_3
Xload_slew305 fanout304/X VGND VGND VPWR VPWR _4758_/A2 sky130_fd_sc_hd__buf_4
XFILLER_3_685 VGND VGND VPWR VPWR sky130_fd_sc_hd__decap_3
XFILLER_2_162 VGND VGND VPWR VPWR sky130_fd_sc_hd__decap_3
XFILLER_26_1303 VGND VGND VPWR VPWR sky130_fd_sc_hd__decap_3
XFILLER_65_1363 VGND VGND VPWR VPWR sky130_fd_sc_hd__decap_3
XFILLER_2_195 VGND VGND VPWR VPWR sky130_fd_sc_hd__fill_1
Xload_slew349 _3897_/A2 VGND VGND VPWR VPWR _4879_/B sky130_fd_sc_hd__buf_4
XFILLER_26_1347 VGND VGND VPWR VPWR sky130_fd_sc_hd__decap_3
XFILLER_65_1396 VGND VGND VPWR VPWR sky130_fd_sc_hd__decap_3
XFILLER_38_328 VGND VGND VPWR VPWR sky130_fd_sc_hd__fill_2
XFILLER_38_339 VGND VGND VPWR VPWR sky130_fd_sc_hd__fill_1
XFILLER_48_91 VGND VGND VPWR VPWR sky130_fd_sc_hd__decap_3
XFILLER_4_1132 VGND VGND VPWR VPWR sky130_fd_sc_hd__decap_3
XFILLER_0_21 VGND VGND VPWR VPWR sky130_fd_sc_hd__decap_3
XFILLER_24_1082 VGND VGND VPWR VPWR sky130_fd_sc_hd__fill_2
XFILLER_65_158 VGND VGND VPWR VPWR sky130_fd_sc_hd__decap_3
XFILLER_0_32 VGND VGND VPWR VPWR sky130_fd_sc_hd__decap_3
XFILLER_4_1176 VGND VGND VPWR VPWR sky130_fd_sc_hd__decap_3
XFILLER_19_564 VGND VGND VPWR VPWR sky130_fd_sc_hd__decap_3
XFILLER_80_106 VGND VGND VPWR VPWR sky130_fd_sc_hd__decap_3
XFILLER_0_1018 VGND VGND VPWR VPWR sky130_fd_sc_hd__decap_3
XFILLER_47_884 VGND VGND VPWR VPWR sky130_fd_sc_hd__decap_3
XFILLER_34_512 VGND VGND VPWR VPWR sky130_fd_sc_hd__decap_3
XFILLER_74_681 VGND VGND VPWR VPWR sky130_fd_sc_hd__decap_3
XFILLER_46_394 VGND VGND VPWR VPWR sky130_fd_sc_hd__decap_3
XFILLER_61_331 VGND VGND VPWR VPWR sky130_fd_sc_hd__decap_3
XFILLER_62_854 VGND VGND VPWR VPWR sky130_fd_sc_hd__decap_3
XFILLER_55_1009 VGND VGND VPWR VPWR sky130_fd_sc_hd__decap_3
X_4800_ _5605_/A3 _6578_/Q _4835_/S VGND VGND VPWR VPWR _4800_/X sky130_fd_sc_hd__mux2_1
XFILLER_37_1410 VGND VGND VPWR VPWR sky130_fd_sc_hd__decap_3
XFILLER_59_1189 VGND VGND VPWR VPWR sky130_fd_sc_hd__decap_3
XFILLER_61_353 VGND VGND VPWR VPWR sky130_fd_sc_hd__decap_3
XFILLER_61_364 VGND VGND VPWR VPWR sky130_fd_sc_hd__fill_2
XFILLER_62_887 VGND VGND VPWR VPWR sky130_fd_sc_hd__decap_3
XFILLER_72_1312 VGND VGND VPWR VPWR sky130_fd_sc_hd__decap_3
XFILLER_21_206 VGND VGND VPWR VPWR sky130_fd_sc_hd__decap_3
XFILLER_34_589 VGND VGND VPWR VPWR sky130_fd_sc_hd__decap_3
X_5780_ _5780_/A0 _5930_/A0 _5780_/S VGND VGND VPWR VPWR _6815_/D sky130_fd_sc_hd__mux2_1
XFILLER_72_1323 VGND VGND VPWR VPWR sky130_fd_sc_hd__decap_3
XFILLER_37_1443 VGND VGND VPWR VPWR sky130_fd_sc_hd__decap_3
XFILLER_9_30 VGND VGND VPWR VPWR sky130_fd_sc_hd__decap_3
X_4731_ _4738_/A _4369_/X _4723_/X _6569_/Q VGND VGND VPWR VPWR _4731_/X sky130_fd_sc_hd__a2bb2o_2
XFILLER_72_1356 VGND VGND VPWR VPWR sky130_fd_sc_hd__decap_3
XFILLER_33_1307 VGND VGND VPWR VPWR sky130_fd_sc_hd__decap_3
XFILLER_30_784 VGND VGND VPWR VPWR sky130_fd_sc_hd__decap_3
X_4662_ _6263_/Q wire507/A _3384_/X _4875_/B2 VGND VGND VPWR VPWR _4662_/X sky130_fd_sc_hd__a22o_2
X_6401_ _6772_/CLK _6401_/D load_slew831/X VGND VGND VPWR VPWR _6401_/Q sky130_fd_sc_hd__dfrtp_2
X_3613_ _3673_/A _3649_/B _3665_/A _3665_/B VGND VGND VPWR VPWR _3613_/Y sky130_fd_sc_hd__o211ai_2
X_4593_ _6301_/Q _4593_/A2 _4590_/X _4592_/X VGND VGND VPWR VPWR _6301_/D sky130_fd_sc_hd__o22a_2
Xhold903 _7049_/Q VGND VGND VPWR VPWR hold903/X sky130_fd_sc_hd__dlygate4sd3_1
X_6332_ _6918_/CLK _6332_/D fanout743/X VGND VGND VPWR VPWR _6332_/Q sky130_fd_sc_hd__dfrtp_2
Xhold914 _6726_/Q VGND VGND VPWR VPWR hold914/X sky130_fd_sc_hd__dlygate4sd3_1
XTAP_TAPCELL_ROW_77_2198 VGND VPWR sky130_fd_sc_hd__tapvpwrvgnd_1
X_3544_ _6315_/Q _5594_/A1 _5603_/A1 _6307_/Q VGND VGND VPWR VPWR _3544_/X sky130_fd_sc_hd__a22o_2
Xhold925 _5967_/X VGND VGND VPWR VPWR _6971_/D sky130_fd_sc_hd__dlygate4sd3_1
Xhold936 _6641_/Q VGND VGND VPWR VPWR hold936/X sky130_fd_sc_hd__dlygate4sd3_1
Xhold947 _6977_/Q VGND VGND VPWR VPWR hold947/X sky130_fd_sc_hd__dlygate4sd3_1
Xhold958 _6951_/Q VGND VGND VPWR VPWR hold958/X sky130_fd_sc_hd__dlygate4sd3_1
X_6263_ _6889_/CLK _6263_/D fanout709/X VGND VGND VPWR VPWR _6263_/Q sky130_fd_sc_hd__dfrtp_2
Xhold969 _5991_/X VGND VGND VPWR VPWR _6995_/D sky130_fd_sc_hd__dlygate4sd3_1
X_3475_ _6058_/A0 _3474_/X _3477_/S VGND VGND VPWR VPWR _6211_/D sky130_fd_sc_hd__mux2_1
XFILLER_66_1149 VGND VGND VPWR VPWR sky130_fd_sc_hd__fill_2
XFILLER_44_1403 VGND VGND VPWR VPWR sky130_fd_sc_hd__decap_3
X_5214_ _6751_/Q _5298_/S _5305_/S _5213_/Y VGND VGND VPWR VPWR _5214_/X sky130_fd_sc_hd__o211a_2
X_6194_ clkload7/A _6194_/D load_slew637/X VGND VGND VPWR VPWR _6194_/Q sky130_fd_sc_hd__dfrtp_2
XFILLER_69_431 VGND VGND VPWR VPWR sky130_fd_sc_hd__decap_3
XFILLER_9_1065 VGND VGND VPWR VPWR sky130_fd_sc_hd__fill_1
XFILLER_44_1447 VGND VGND VPWR VPWR sky130_fd_sc_hd__decap_3
XTAP_TAPCELL_ROW_32_1025 VGND VPWR sky130_fd_sc_hd__tapvpwrvgnd_1
X_5145_ _6381_/Q _5215_/A2 _4943_/S _5144_/X VGND VGND VPWR VPWR _6381_/D sky130_fd_sc_hd__a22o_2
XFILLER_57_604 VGND VGND VPWR VPWR sky130_fd_sc_hd__fill_1
XFILLER_29_317 VGND VGND VPWR VPWR sky130_fd_sc_hd__decap_3
XTAP_TAPCELL_ROW_32_1036 VGND VPWR sky130_fd_sc_hd__tapvpwrvgnd_1
XFILLER_56_114 VGND VGND VPWR VPWR sky130_fd_sc_hd__decap_3
X_5076_ _6368_/Q _5075_/X _5075_/A _6706_/Q VGND VGND VPWR VPWR _5076_/X sky130_fd_sc_hd__a2bb2o_2
XFILLER_77_1201 VGND VGND VPWR VPWR sky130_fd_sc_hd__decap_3
X_4027_ _6234_/Q _4069_/A2 _4025_/X _4026_/X VGND VGND VPWR VPWR _6234_/D sky130_fd_sc_hd__o22a_2
XFILLER_25_501 VGND VGND VPWR VPWR sky130_fd_sc_hd__decap_3
XFILLER_38_884 VGND VGND VPWR VPWR sky130_fd_sc_hd__decap_3
XFILLER_37_372 VGND VGND VPWR VPWR sky130_fd_sc_hd__decap_3
XFILLER_71_128 VGND VGND VPWR VPWR sky130_fd_sc_hd__fill_2
XFILLER_77_1245 VGND VGND VPWR VPWR sky130_fd_sc_hd__decap_3
XFILLER_77_1278 VGND VGND VPWR VPWR sky130_fd_sc_hd__decap_3
XFILLER_52_342 VGND VGND VPWR VPWR sky130_fd_sc_hd__decap_3
XFILLER_25_567 VGND VGND VPWR VPWR sky130_fd_sc_hd__decap_3
XFILLER_80_673 VGND VGND VPWR VPWR sky130_fd_sc_hd__decap_3
XFILLER_77_1289 VGND VGND VPWR VPWR sky130_fd_sc_hd__decap_3
XFILLER_40_504 VGND VGND VPWR VPWR sky130_fd_sc_hd__decap_3
X_5978_ hold952/X _6982_/Q _5989_/S VGND VGND VPWR VPWR _5978_/X sky130_fd_sc_hd__mux2_1
XFILLER_12_217 VGND VGND VPWR VPWR sky130_fd_sc_hd__decap_3
X_4929_ _6347_/Q _4928_/X _4929_/S VGND VGND VPWR VPWR _6347_/D sky130_fd_sc_hd__mux2_1
XFILLER_51_1407 VGND VGND VPWR VPWR sky130_fd_sc_hd__decap_3
XFILLER_20_283 VGND VGND VPWR VPWR sky130_fd_sc_hd__decap_3
XFILLER_5_906 VGND VGND VPWR VPWR sky130_fd_sc_hd__decap_3
XFILLER_14_1273 VGND VGND VPWR VPWR sky130_fd_sc_hd__decap_3
XFILLER_4_427 VGND VGND VPWR VPWR sky130_fd_sc_hd__fill_2
XFILLER_4_449 VGND VGND VPWR VPWR sky130_fd_sc_hd__decap_3
XFILLER_49_1325 VGND VGND VPWR VPWR sky130_fd_sc_hd__decap_3
XFILLER_69_24 VGND VGND VPWR VPWR sky130_fd_sc_hd__decap_3
XFILLER_69_57 VGND VGND VPWR VPWR sky130_fd_sc_hd__decap_3
XFILLER_49_1369 VGND VGND VPWR VPWR sky130_fd_sc_hd__decap_3
XFILLER_79_228 VGND VGND VPWR VPWR sky130_fd_sc_hd__fill_2
XFILLER_0_666 VGND VGND VPWR VPWR sky130_fd_sc_hd__decap_3
XFILLER_0_688 VGND VGND VPWR VPWR sky130_fd_sc_hd__decap_3
XFILLER_5_1452 VGND VGND VPWR VPWR sky130_fd_sc_hd__decap_3
XFILLER_5_1463 VGND VGND VPWR VPWR sky130_fd_sc_hd__decap_3
XFILLER_21_1233 VGND VGND VPWR VPWR sky130_fd_sc_hd__decap_3
XFILLER_47_158 VGND VGND VPWR VPWR sky130_fd_sc_hd__fill_2
XFILLER_60_1282 VGND VGND VPWR VPWR sky130_fd_sc_hd__decap_3
XFILLER_75_478 VGND VGND VPWR VPWR sky130_fd_sc_hd__decap_3
XFILLER_35_309 VGND VGND VPWR VPWR sky130_fd_sc_hd__decap_3
XFILLER_47_169 VGND VGND VPWR VPWR sky130_fd_sc_hd__decap_3
XFILLER_1_1316 VGND VGND VPWR VPWR sky130_fd_sc_hd__decap_3
XFILLER_28_361 VGND VGND VPWR VPWR sky130_fd_sc_hd__decap_3
XFILLER_16_512 VGND VGND VPWR VPWR sky130_fd_sc_hd__decap_3
XFILLER_21_1266 VGND VGND VPWR VPWR sky130_fd_sc_hd__decap_3
XFILLER_29_895 VGND VGND VPWR VPWR sky130_fd_sc_hd__fill_1
XFILLER_44_821 VGND VGND VPWR VPWR sky130_fd_sc_hd__decap_3
XFILLER_18_94 VGND VGND VPWR VPWR sky130_fd_sc_hd__decap_3
XFILLER_62_139 VGND VGND VPWR VPWR sky130_fd_sc_hd__fill_1
XFILLER_28_394 VGND VGND VPWR VPWR sky130_fd_sc_hd__decap_3
XFILLER_55_180 VGND VGND VPWR VPWR sky130_fd_sc_hd__decap_3
XFILLER_44_865 VGND VGND VPWR VPWR sky130_fd_sc_hd__decap_3
XFILLER_56_1329 VGND VGND VPWR VPWR sky130_fd_sc_hd__decap_3
XFILLER_71_673 VGND VGND VPWR VPWR sky130_fd_sc_hd__decap_3
XFILLER_43_375 VGND VGND VPWR VPWR sky130_fd_sc_hd__decap_3
XFILLER_12_740 VGND VGND VPWR VPWR sky130_fd_sc_hd__decap_3
XFILLER_31_559 VGND VGND VPWR VPWR sky130_fd_sc_hd__fill_1
XFILLER_12_751 VGND VGND VPWR VPWR sky130_fd_sc_hd__decap_3
XFILLER_34_93 VGND VGND VPWR VPWR sky130_fd_sc_hd__fill_2
XFILLER_8_722 VGND VGND VPWR VPWR sky130_fd_sc_hd__fill_1
XFILLER_15_1037 VGND VGND VPWR VPWR sky130_fd_sc_hd__decap_3
XFILLER_54_1086 VGND VGND VPWR VPWR sky130_fd_sc_hd__decap_3
Xwire141 _4271_/A VGND VGND VPWR VPWR _4280_/A sky130_fd_sc_hd__buf_2
Xwire152 _3739_/A VGND VGND VPWR VPWR _4281_/A sky130_fd_sc_hd__buf_2
XFILLER_32_1362 VGND VGND VPWR VPWR sky130_fd_sc_hd__decap_3
XFILLER_32_1373 VGND VGND VPWR VPWR sky130_fd_sc_hd__decap_3
XFILLER_7_287 VGND VGND VPWR VPWR sky130_fd_sc_hd__decap_3
XFILLER_67_1425 VGND VGND VPWR VPWR sky130_fd_sc_hd__decap_3
XFILLER_28_1409 VGND VGND VPWR VPWR sky130_fd_sc_hd__decap_3
XTAP_TAPCELL_ROW_72_2062 VGND VPWR sky130_fd_sc_hd__tapvpwrvgnd_1
Xload_slew102 _5151_/A2 VGND VGND VPWR VPWR _5257_/A2 sky130_fd_sc_hd__buf_4
XTAP_TAPCELL_ROW_72_2073 VGND VPWR sky130_fd_sc_hd__tapvpwrvgnd_1
XTAP_TAPCELL_ROW_72_2084 VGND VPWR sky130_fd_sc_hd__tapvpwrvgnd_1
X_3260_ _6265_/Q _6361_/Q VGND VGND VPWR VPWR _3260_/X sky130_fd_sc_hd__xor2_2
Xload_slew135 _5286_/B1 VGND VGND VPWR VPWR _5305_/S sky130_fd_sc_hd__clkbuf_4
XFILLER_79_762 VGND VGND VPWR VPWR sky130_fd_sc_hd__fill_1
XFILLER_6_1205 VGND VGND VPWR VPWR sky130_fd_sc_hd__decap_3
X_3191_ _7047_/Q _7055_/Q _3191_/S VGND VGND VPWR VPWR _3191_/X sky130_fd_sc_hd__mux2_1
XFILLER_65_1193 VGND VGND VPWR VPWR sky130_fd_sc_hd__fill_1
XFILLER_61_1035 VGND VGND VPWR VPWR sky130_fd_sc_hd__decap_3
XFILLER_67_924 VGND VGND VPWR VPWR sky130_fd_sc_hd__decap_3
XFILLER_6_1238 VGND VGND VPWR VPWR sky130_fd_sc_hd__decap_3
Xload_slew179 _3355_/S VGND VGND VPWR VPWR _7087_/D sky130_fd_sc_hd__buf_4
XFILLER_22_1008 VGND VGND VPWR VPWR sky130_fd_sc_hd__decap_3
XFILLER_39_648 VGND VGND VPWR VPWR sky130_fd_sc_hd__decap_3
XFILLER_15_3 VGND VGND VPWR VPWR sky130_fd_sc_hd__decap_3
XFILLER_38_147 VGND VGND VPWR VPWR sky130_fd_sc_hd__fill_1
XFILLER_26_309 VGND VGND VPWR VPWR sky130_fd_sc_hd__fill_1
X_6950_ _6990_/CLK _6950_/D fanout752/X VGND VGND VPWR VPWR _6950_/Q sky130_fd_sc_hd__dfrtp_2
XFILLER_66_489 VGND VGND VPWR VPWR sky130_fd_sc_hd__decap_3
XFILLER_53_128 VGND VGND VPWR VPWR sky130_fd_sc_hd__decap_3
X_5901_ _5901_/A0 _5901_/A1 _5905_/S VGND VGND VPWR VPWR _6909_/D sky130_fd_sc_hd__mux2_1
X_6881_ _6913_/CLK _6881_/D fanout727/X VGND VGND VPWR VPWR _6881_/Q sky130_fd_sc_hd__dfrtp_2
XFILLER_74_1418 VGND VGND VPWR VPWR sky130_fd_sc_hd__decap_3
XFILLER_35_876 VGND VGND VPWR VPWR sky130_fd_sc_hd__decap_3
XFILLER_62_651 VGND VGND VPWR VPWR sky130_fd_sc_hd__decap_3
XFILLER_74_1429 VGND VGND VPWR VPWR sky130_fd_sc_hd__decap_3
XFILLER_34_353 VGND VGND VPWR VPWR sky130_fd_sc_hd__decap_3
X_5832_ _5915_/D _5850_/B _5906_/B _5879_/A VGND VGND VPWR VPWR _5839_/S sky130_fd_sc_hd__or4b_2
XFILLER_50_824 VGND VGND VPWR VPWR sky130_fd_sc_hd__decap_3
XFILLER_72_1120 VGND VGND VPWR VPWR sky130_fd_sc_hd__decap_3
XFILLER_61_183 VGND VGND VPWR VPWR sky130_fd_sc_hd__decap_3
XFILLER_37_1251 VGND VGND VPWR VPWR sky130_fd_sc_hd__decap_3
X_5763_ _5929_/A0 _5763_/A1 _5766_/S VGND VGND VPWR VPWR _6806_/D sky130_fd_sc_hd__mux2_1
XFILLER_72_1164 VGND VGND VPWR VPWR sky130_fd_sc_hd__decap_3
XFILLER_37_1284 VGND VGND VPWR VPWR sky130_fd_sc_hd__decap_3
X_4714_ _6896_/Q _4833_/A2 _4833_/B1 _4713_/X VGND VGND VPWR VPWR _4714_/X sky130_fd_sc_hd__a211o_2
XFILLER_37_1295 VGND VGND VPWR VPWR sky130_fd_sc_hd__decap_3
XTAP_TAPCELL_ROW_20_716 VGND VPWR sky130_fd_sc_hd__tapvpwrvgnd_1
XTAP_TAPCELL_ROW_79_2249 VGND VPWR sky130_fd_sc_hd__tapvpwrvgnd_1
XFILLER_72_1197 VGND VGND VPWR VPWR sky130_fd_sc_hd__decap_3
XTAP_TAPCELL_ROW_20_727 VGND VPWR sky130_fd_sc_hd__tapvpwrvgnd_1
X_5694_ _7069_/Q _5703_/A _5694_/C VGND VGND VPWR VPWR _5701_/S sky130_fd_sc_hd__and3b_2
X_4645_ _4645_/A wire31/X VGND VGND VPWR VPWR _4645_/Y sky130_fd_sc_hd__nor2_2
XFILLER_11_1413 VGND VGND VPWR VPWR sky130_fd_sc_hd__decap_3
XFILLER_50_1462 VGND VGND VPWR VPWR sky130_fd_sc_hd__decap_3
XFILLER_11_1446 VGND VGND VPWR VPWR sky130_fd_sc_hd__decap_3
XFILLER_11_1457 VGND VGND VPWR VPWR sky130_fd_sc_hd__decap_3
X_4576_ _6877_/Q _4774_/A2 _4574_/X _4575_/X VGND VGND VPWR VPWR _4576_/X sky130_fd_sc_hd__a211o_2
XTAP_TAPCELL_ROW_38_1201 VGND VPWR sky130_fd_sc_hd__tapvpwrvgnd_1
X_6315_ clkload9/A _6315_/D fanout656/X VGND VGND VPWR VPWR _6315_/Q sky130_fd_sc_hd__dfrtp_2
XFILLER_1_408 VGND VGND VPWR VPWR sky130_fd_sc_hd__decap_3
X_3527_ _6246_/Q _5591_/A2 _5606_/A2 _6334_/Q VGND VGND VPWR VPWR _3527_/X sky130_fd_sc_hd__a22o_2
X_6246_ _7064_/CLK _6246_/D fanout719/X VGND VGND VPWR VPWR _6246_/Q sky130_fd_sc_hd__dfrtp_2
X_3458_ _6340_/Q _6460_/Q VGND VGND VPWR VPWR _3458_/X sky130_fd_sc_hd__xor2_2
XFILLER_48_1391 VGND VGND VPWR VPWR sky130_fd_sc_hd__decap_3
XFILLER_69_250 VGND VGND VPWR VPWR sky130_fd_sc_hd__decap_3
X_6177_ _6900_/CLK _6177_/D fanout844/X VGND VGND VPWR VPWR _6177_/Q sky130_fd_sc_hd__dfrtp_2
Xhold1400 _6516_/Q VGND VGND VPWR VPWR _5404_/A1 sky130_fd_sc_hd__dlygate4sd3_1
X_3389_ _6015_/A0 _3388_/X _3389_/S VGND VGND VPWR VPWR _6168_/D sky130_fd_sc_hd__mux2_1
XFILLER_44_1255 VGND VGND VPWR VPWR sky130_fd_sc_hd__decap_3
Xhold1411 _6502_/Q VGND VGND VPWR VPWR _5390_/A1 sky130_fd_sc_hd__dlygate4sd3_1
Xhold1422 _6529_/Q VGND VGND VPWR VPWR _5417_/A1 sky130_fd_sc_hd__dlygate4sd3_1
X_5128_ _6439_/Q _5128_/B VGND VGND VPWR VPWR _5291_/B sky130_fd_sc_hd__xnor2_2
Xhold1433 _6557_/Q VGND VGND VPWR VPWR _5445_/A1 sky130_fd_sc_hd__dlygate4sd3_1
XFILLER_44_1288 VGND VGND VPWR VPWR sky130_fd_sc_hd__decap_3
XFILLER_79_1307 VGND VGND VPWR VPWR sky130_fd_sc_hd__decap_3
Xhold1444 _6518_/Q VGND VGND VPWR VPWR _5406_/A1 sky130_fd_sc_hd__dlygate4sd3_1
Xhold1455 _6535_/Q VGND VGND VPWR VPWR _5423_/A1 sky130_fd_sc_hd__dlygate4sd3_1
Xhold1466 _6741_/Q VGND VGND VPWR VPWR _5689_/A0 sky130_fd_sc_hd__dlygate4sd3_1
XFILLER_55_15 VGND VGND VPWR VPWR sky130_fd_sc_hd__decap_3
Xhold1477 _6553_/Q VGND VGND VPWR VPWR _5441_/A1 sky130_fd_sc_hd__dlygate4sd3_1
Xhold1488 _6598_/Q VGND VGND VPWR VPWR _5486_/A1 sky130_fd_sc_hd__dlygate4sd3_1
X_5059_ _6398_/Q _5264_/B _5123_/A VGND VGND VPWR VPWR _5059_/Y sky130_fd_sc_hd__a21oi_2
XFILLER_45_629 VGND VGND VPWR VPWR sky130_fd_sc_hd__fill_2
XFILLER_55_48 VGND VGND VPWR VPWR sky130_fd_sc_hd__decap_3
Xhold1499 _6500_/Q VGND VGND VPWR VPWR _5388_/A1 sky130_fd_sc_hd__dlygate4sd3_1
XFILLER_66_990 VGND VGND VPWR VPWR sky130_fd_sc_hd__decap_3
XFILLER_77_1020 VGND VGND VPWR VPWR sky130_fd_sc_hd__decap_3
XFILLER_38_692 VGND VGND VPWR VPWR sky130_fd_sc_hd__decap_3
XTAP_TAPCELL_ROW_68_1964 VGND VPWR sky130_fd_sc_hd__tapvpwrvgnd_1
XTAP_TAPCELL_ROW_68_1975 VGND VPWR sky130_fd_sc_hd__tapvpwrvgnd_1
XFILLER_53_651 VGND VGND VPWR VPWR sky130_fd_sc_hd__fill_2
XFILLER_0_1360 VGND VGND VPWR VPWR sky130_fd_sc_hd__decap_3
XFILLER_25_364 VGND VGND VPWR VPWR sky130_fd_sc_hd__decap_3
XFILLER_41_813 VGND VGND VPWR VPWR sky130_fd_sc_hd__decap_3
XFILLER_77_1086 VGND VGND VPWR VPWR sky130_fd_sc_hd__decap_3
XFILLER_38_1037 VGND VGND VPWR VPWR sky130_fd_sc_hd__decap_3
XFILLER_0_1382 VGND VGND VPWR VPWR sky130_fd_sc_hd__decap_3
XFILLER_40_312 VGND VGND VPWR VPWR sky130_fd_sc_hd__decap_3
XFILLER_71_36 VGND VGND VPWR VPWR sky130_fd_sc_hd__decap_3
XFILLER_13_548 VGND VGND VPWR VPWR sky130_fd_sc_hd__decap_3
XFILLER_55_1340 VGND VGND VPWR VPWR sky130_fd_sc_hd__decap_3
XFILLER_9_508 VGND VGND VPWR VPWR sky130_fd_sc_hd__decap_3
XFILLER_55_1351 VGND VGND VPWR VPWR sky130_fd_sc_hd__decap_3
XFILLER_16_1335 VGND VGND VPWR VPWR sky130_fd_sc_hd__decap_3
XFILLER_55_1384 VGND VGND VPWR VPWR sky130_fd_sc_hd__decap_3
XFILLER_16_1368 VGND VGND VPWR VPWR sky130_fd_sc_hd__decap_3
XFILLER_51_1248 VGND VGND VPWR VPWR sky130_fd_sc_hd__decap_3
XFILLER_16_1379 VGND VGND VPWR VPWR sky130_fd_sc_hd__decap_3
XFILLER_5_714 VGND VGND VPWR VPWR sky130_fd_sc_hd__fill_2
XFILLER_5_725 VGND VGND VPWR VPWR sky130_fd_sc_hd__decap_3
XFILLER_49_1155 VGND VGND VPWR VPWR sky130_fd_sc_hd__decap_3
XFILLER_1_942 VGND VGND VPWR VPWR sky130_fd_sc_hd__decap_3
XFILLER_62_1300 VGND VGND VPWR VPWR sky130_fd_sc_hd__decap_3
XFILLER_1_953 VGND VGND VPWR VPWR sky130_fd_sc_hd__decap_3
XFILLER_0_430 VGND VGND VPWR VPWR sky130_fd_sc_hd__decap_3
XFILLER_27_1431 VGND VGND VPWR VPWR sky130_fd_sc_hd__decap_3
XFILLER_0_452 VGND VGND VPWR VPWR sky130_fd_sc_hd__decap_3
XFILLER_49_913 VGND VGND VPWR VPWR sky130_fd_sc_hd__decap_3
XFILLER_1_986 VGND VGND VPWR VPWR sky130_fd_sc_hd__decap_3
XFILLER_62_1344 VGND VGND VPWR VPWR sky130_fd_sc_hd__decap_3
XFILLER_23_1328 VGND VGND VPWR VPWR sky130_fd_sc_hd__decap_3
XFILLER_76_754 VGND VGND VPWR VPWR sky130_fd_sc_hd__fill_2
XFILLER_62_1388 VGND VGND VPWR VPWR sky130_fd_sc_hd__decap_3
XFILLER_76_787 VGND VGND VPWR VPWR sky130_fd_sc_hd__decap_3
XFILLER_5_1260 VGND VGND VPWR VPWR sky130_fd_sc_hd__decap_3
XFILLER_1_1113 VGND VGND VPWR VPWR sky130_fd_sc_hd__decap_3
XFILLER_57_990 VGND VGND VPWR VPWR sky130_fd_sc_hd__decap_3
XFILLER_1_1124 VGND VGND VPWR VPWR sky130_fd_sc_hd__decap_3
XTAP_TAPCELL_ROW_3_290 VGND VPWR sky130_fd_sc_hd__tapvpwrvgnd_1
XFILLER_21_1074 VGND VGND VPWR VPWR sky130_fd_sc_hd__decap_3
XFILLER_1_1157 VGND VGND VPWR VPWR sky130_fd_sc_hd__decap_3
XFILLER_72_960 VGND VGND VPWR VPWR sky130_fd_sc_hd__decap_3
XFILLER_17_876 VGND VGND VPWR VPWR sky130_fd_sc_hd__fill_1
XFILLER_71_470 VGND VGND VPWR VPWR sky130_fd_sc_hd__fill_1
XFILLER_43_161 VGND VGND VPWR VPWR sky130_fd_sc_hd__decap_3
XFILLER_56_1137 VGND VGND VPWR VPWR sky130_fd_sc_hd__decap_3
XFILLER_16_386 VGND VGND VPWR VPWR sky130_fd_sc_hd__decap_3
XTAP_TAPCELL_ROW_27_893 VGND VPWR sky130_fd_sc_hd__tapvpwrvgnd_1
XFILLER_73_1440 VGND VGND VPWR VPWR sky130_fd_sc_hd__decap_3
XFILLER_31_334 VGND VGND VPWR VPWR sky130_fd_sc_hd__fill_2
XTAP_TAPCELL_ROW_14_554 VGND VPWR sky130_fd_sc_hd__tapvpwrvgnd_1
XFILLER_34_1424 VGND VGND VPWR VPWR sky130_fd_sc_hd__decap_3
XTAP_TAPCELL_ROW_14_565 VGND VPWR sky130_fd_sc_hd__tapvpwrvgnd_1
XFILLER_34_1435 VGND VGND VPWR VPWR sky130_fd_sc_hd__decap_3
XTAP_TAPCELL_ROW_14_576 VGND VPWR sky130_fd_sc_hd__tapvpwrvgnd_1
XFILLER_34_1468 VGND VGND VPWR VPWR sky130_fd_sc_hd__fill_1
XFILLER_12_592 VGND VGND VPWR VPWR sky130_fd_sc_hd__decap_3
XFILLER_61_80 VGND VGND VPWR VPWR sky130_fd_sc_hd__decap_3
XFILLER_8_563 VGND VGND VPWR VPWR sky130_fd_sc_hd__decap_3
XTAP_TAPCELL_ROW_74_2113 VGND VPWR sky130_fd_sc_hd__tapvpwrvgnd_1
XFILLER_32_1181 VGND VGND VPWR VPWR sky130_fd_sc_hd__decap_3
X_4430_ _6512_/Q _4480_/S _4429_/Y _4787_/C1 VGND VGND VPWR VPWR _4433_/B sky130_fd_sc_hd__a211o_2
XTAP_TAPCELL_ROW_74_2124 VGND VPWR sky130_fd_sc_hd__tapvpwrvgnd_1
XANTENNA_2 _3078_/Y VGND VGND VPWR VPWR sky130_fd_sc_hd__diode_2
XTAP_TAPCELL_ROW_74_2135 VGND VPWR sky130_fd_sc_hd__tapvpwrvgnd_1
XFILLER_67_1222 VGND VGND VPWR VPWR sky130_fd_sc_hd__decap_3
XFILLER_67_1233 VGND VGND VPWR VPWR sky130_fd_sc_hd__decap_3
X_4361_ _4008_/A _4359_/Y _4360_/X _6504_/Q VGND VGND VPWR VPWR _4361_/X sky130_fd_sc_hd__a2bb2o_2
X_6100_ _6959_/CLK _6100_/D load_slew799/X VGND VGND VPWR VPWR _6100_/Q sky130_fd_sc_hd__dfrtp_2
XFILLER_67_1266 VGND VGND VPWR VPWR sky130_fd_sc_hd__decap_3
X_3312_ _6283_/Q _6387_/Q VGND VGND VPWR VPWR _3312_/X sky130_fd_sc_hd__xor2_2
XFILLER_28_1228 VGND VGND VPWR VPWR sky130_fd_sc_hd__decap_3
X_7080_ _7096_/CLK _7080_/D load_slew677/X VGND VGND VPWR VPWR _7111_/A sky130_fd_sc_hd__dfrtp_2
Xfanout509 wire515/X VGND VGND VPWR VPWR _4882_/A2 sky130_fd_sc_hd__clkdlybuf4s25_1
X_4292_ _4292_/A _4292_/B VGND VGND VPWR VPWR _4293_/B sky130_fd_sc_hd__xor2_2
XFILLER_80_1422 VGND VGND VPWR VPWR sky130_fd_sc_hd__decap_3
X_6031_ _6031_/A0 _6031_/A1 _6031_/S VGND VGND VPWR VPWR _7035_/D sky130_fd_sc_hd__mux2_1
X_3243_ hold937/X _3242_/X _3243_/S VGND VGND VPWR VPWR _6095_/D sky130_fd_sc_hd__mux2_1
XFILLER_80_1444 VGND VGND VPWR VPWR sky130_fd_sc_hd__decap_3
XFILLER_80_1466 VGND VGND VPWR VPWR sky130_fd_sc_hd__decap_3
XFILLER_41_1428 VGND VGND VPWR VPWR sky130_fd_sc_hd__decap_3
XFILLER_67_743 VGND VGND VPWR VPWR sky130_fd_sc_hd__fill_2
XFILLER_39_445 VGND VGND VPWR VPWR sky130_fd_sc_hd__decap_3
X_3174_ _6998_/Q wire419/X _3223_/C1 _3173_/X VGND VGND VPWR VPWR _3175_/C sky130_fd_sc_hd__a211o_2
XFILLER_55_916 VGND VGND VPWR VPWR sky130_fd_sc_hd__decap_3
XTAP_TAPCELL_ROW_1_216 VGND VPWR sky130_fd_sc_hd__tapvpwrvgnd_1
XFILLER_66_253 VGND VGND VPWR VPWR sky130_fd_sc_hd__decap_3
XTAP_TAPCELL_ROW_1_227 VGND VPWR sky130_fd_sc_hd__tapvpwrvgnd_1
XFILLER_26_106 VGND VGND VPWR VPWR sky130_fd_sc_hd__fill_2
XTAP_TAPCELL_ROW_1_238 VGND VPWR sky130_fd_sc_hd__tapvpwrvgnd_1
XFILLER_48_990 VGND VGND VPWR VPWR sky130_fd_sc_hd__decap_3
X_6933_ _7095_/CLK _6933_/D load_slew696/X VGND VGND VPWR VPWR _6933_/Q sky130_fd_sc_hd__dfrtp_2
XFILLER_78_1362 VGND VGND VPWR VPWR sky130_fd_sc_hd__decap_3
XFILLER_25_18 VGND VGND VPWR VPWR sky130_fd_sc_hd__decap_3
XFILLER_35_651 VGND VGND VPWR VPWR sky130_fd_sc_hd__decap_3
XFILLER_39_1313 VGND VGND VPWR VPWR sky130_fd_sc_hd__decap_3
XFILLER_78_1373 VGND VGND VPWR VPWR sky130_fd_sc_hd__decap_3
XFILLER_35_673 VGND VGND VPWR VPWR sky130_fd_sc_hd__decap_3
XFILLER_74_1226 VGND VGND VPWR VPWR sky130_fd_sc_hd__decap_3
X_6864_ _7024_/CLK _6864_/D fanout699/A VGND VGND VPWR VPWR _6864_/Q sky130_fd_sc_hd__dfrtp_2
XFILLER_23_824 VGND VGND VPWR VPWR sky130_fd_sc_hd__decap_3
XFILLER_39_1357 VGND VGND VPWR VPWR sky130_fd_sc_hd__decap_3
XFILLER_74_1259 VGND VGND VPWR VPWR sky130_fd_sc_hd__fill_1
XFILLER_50_643 VGND VGND VPWR VPWR sky130_fd_sc_hd__fill_1
X_5815_ _5815_/A0 _5889_/A0 _5822_/S VGND VGND VPWR VPWR _6834_/D sky130_fd_sc_hd__mux2_1
XFILLER_23_868 VGND VGND VPWR VPWR sky130_fd_sc_hd__decap_3
XTAP_TAPCELL_ROW_63_1850 VGND VPWR sky130_fd_sc_hd__tapvpwrvgnd_1
X_6795_ _7012_/CLK _6795_/D fanout809/X VGND VGND VPWR VPWR _6795_/Q sky130_fd_sc_hd__dfrtp_2
XFILLER_50_676 VGND VGND VPWR VPWR sky130_fd_sc_hd__decap_3
X_5746_ _5912_/A0 _5746_/A1 _5748_/S VGND VGND VPWR VPWR _6791_/D sky130_fd_sc_hd__mux2_1
X_5677_ _5677_/A0 _5907_/A0 wire90/A VGND VGND VPWR VPWR _6730_/D sky130_fd_sc_hd__mux2_1
XFILLER_11_1210 VGND VGND VPWR VPWR sky130_fd_sc_hd__decap_3
XFILLER_15_1390 VGND VGND VPWR VPWR sky130_fd_sc_hd__decap_3
XFILLER_50_1270 VGND VGND VPWR VPWR sky130_fd_sc_hd__decap_3
X_4628_ _6884_/Q _4883_/A2 _4855_/B1 _4627_/X VGND VGND VPWR VPWR _4628_/X sky130_fd_sc_hd__a211o_2
XFILLER_11_1254 VGND VGND VPWR VPWR sky130_fd_sc_hd__decap_3
XFILLER_11_1287 VGND VGND VPWR VPWR sky130_fd_sc_hd__fill_1
X_4559_ _6321_/Q _4743_/A2 _3356_/X _4735_/B2 VGND VGND VPWR VPWR _4559_/X sky130_fd_sc_hd__a22o_2
XFILLER_11_1298 VGND VGND VPWR VPWR sky130_fd_sc_hd__decap_3
XFILLER_1_205 VGND VGND VPWR VPWR sky130_fd_sc_hd__decap_3
XFILLER_2_728 VGND VGND VPWR VPWR sky130_fd_sc_hd__decap_3
XFILLER_46_1306 VGND VGND VPWR VPWR sky130_fd_sc_hd__decap_3
XFILLER_46_1317 VGND VGND VPWR VPWR sky130_fd_sc_hd__decap_3
XTAP_TAPCELL_ROW_57_1676 VGND VPWR sky130_fd_sc_hd__tapvpwrvgnd_1
XTAP_TAPCELL_ROW_57_1687 VGND VPWR sky130_fd_sc_hd__tapvpwrvgnd_1
XFILLER_1_249 VGND VGND VPWR VPWR sky130_fd_sc_hd__decap_3
X_6229_ _6999_/CLK _6229_/D wire827/X VGND VGND VPWR VPWR _6229_/Q sky130_fd_sc_hd__dfrtp_2
XFILLER_77_529 VGND VGND VPWR VPWR sky130_fd_sc_hd__decap_3
XFILLER_58_721 VGND VGND VPWR VPWR sky130_fd_sc_hd__fill_1
XFILLER_66_47 VGND VGND VPWR VPWR sky130_fd_sc_hd__decap_3
XFILLER_44_1085 VGND VGND VPWR VPWR sky130_fd_sc_hd__decap_3
Xhold1230 _6752_/Q VGND VGND VPWR VPWR _5701_/A0 sky130_fd_sc_hd__dlygate4sd3_1
Xhold1241 _6862_/Q VGND VGND VPWR VPWR _5846_/A0 sky130_fd_sc_hd__dlygate4sd3_1
Xhold1252 _6896_/Q VGND VGND VPWR VPWR _5886_/A1 sky130_fd_sc_hd__dlygate4sd3_1
XFILLER_79_1115 VGND VGND VPWR VPWR sky130_fd_sc_hd__decap_3
XFILLER_2_1400 VGND VGND VPWR VPWR sky130_fd_sc_hd__decap_3
Xhold1263 _6922_/Q VGND VGND VPWR VPWR _5916_/A0 sky130_fd_sc_hd__dlygate4sd3_1
XFILLER_57_275 VGND VGND VPWR VPWR sky130_fd_sc_hd__decap_3
Xhold1274 _6854_/Q VGND VGND VPWR VPWR _5837_/A1 sky130_fd_sc_hd__dlygate4sd3_1
XFILLER_22_1350 VGND VGND VPWR VPWR sky130_fd_sc_hd__decap_3
XFILLER_79_1148 VGND VGND VPWR VPWR sky130_fd_sc_hd__decap_3
Xhold1285 _6476_/Q VGND VGND VPWR VPWR _5364_/A1 sky130_fd_sc_hd__dlygate4sd3_1
XFILLER_2_1444 VGND VGND VPWR VPWR sky130_fd_sc_hd__decap_3
Xhold1296 _6748_/Q VGND VGND VPWR VPWR _5697_/A0 sky130_fd_sc_hd__dlygate4sd3_1
XFILLER_22_1394 VGND VGND VPWR VPWR sky130_fd_sc_hd__decap_3
XFILLER_72_256 VGND VGND VPWR VPWR sky130_fd_sc_hd__decap_3
XFILLER_26_651 VGND VGND VPWR VPWR sky130_fd_sc_hd__decap_3
XFILLER_57_1413 VGND VGND VPWR VPWR sky130_fd_sc_hd__decap_3
XFILLER_14_813 VGND VGND VPWR VPWR sky130_fd_sc_hd__decap_3
XFILLER_57_1446 VGND VGND VPWR VPWR sky130_fd_sc_hd__decap_3
XFILLER_57_1457 VGND VGND VPWR VPWR sky130_fd_sc_hd__decap_3
XFILLER_13_334 VGND VGND VPWR VPWR sky130_fd_sc_hd__fill_2
XTAP_TAPCELL_ROW_24_830 VGND VPWR sky130_fd_sc_hd__tapvpwrvgnd_1
XFILLER_13_378 VGND VGND VPWR VPWR sky130_fd_sc_hd__decap_3
XFILLER_41_687 VGND VGND VPWR VPWR sky130_fd_sc_hd__decap_3
XFILLER_51_1001 VGND VGND VPWR VPWR sky130_fd_sc_hd__decap_3
XFILLER_40_197 VGND VGND VPWR VPWR sky130_fd_sc_hd__decap_3
XFILLER_5_511 VGND VGND VPWR VPWR sky130_fd_sc_hd__decap_3
Xclkbuf_3_3_0_clk clkbuf_0_clk/X VGND VGND VPWR VPWR clkbuf_3_3_0_clk/X sky130_fd_sc_hd__clkbuf_8
XFILLER_5_588 VGND VGND VPWR VPWR sky130_fd_sc_hd__decap_3
XFILLER_64_1406 VGND VGND VPWR VPWR sky130_fd_sc_hd__decap_3
XFILLER_49_9 VGND VGND VPWR VPWR sky130_fd_sc_hd__decap_3
XFILLER_1_750 VGND VGND VPWR VPWR sky130_fd_sc_hd__decap_3
XFILLER_7_1322 VGND VGND VPWR VPWR sky130_fd_sc_hd__decap_3
XFILLER_62_1130 VGND VGND VPWR VPWR sky130_fd_sc_hd__decap_3
XFILLER_1_783 VGND VGND VPWR VPWR sky130_fd_sc_hd__fill_1
XFILLER_49_721 VGND VGND VPWR VPWR sky130_fd_sc_hd__decap_3
XFILLER_0_271 VGND VGND VPWR VPWR sky130_fd_sc_hd__decap_3
XFILLER_1_794 VGND VGND VPWR VPWR sky130_fd_sc_hd__decap_3
XFILLER_27_1272 VGND VGND VPWR VPWR sky130_fd_sc_hd__decap_3
XFILLER_49_732 VGND VGND VPWR VPWR sky130_fd_sc_hd__decap_3
XFILLER_7_1366 VGND VGND VPWR VPWR sky130_fd_sc_hd__decap_3
XFILLER_0_293 VGND VGND VPWR VPWR sky130_fd_sc_hd__decap_3
XFILLER_49_765 VGND VGND VPWR VPWR sky130_fd_sc_hd__decap_3
XFILLER_76_562 VGND VGND VPWR VPWR sky130_fd_sc_hd__decap_3
XFILLER_3_1219 VGND VGND VPWR VPWR sky130_fd_sc_hd__decap_3
XFILLER_48_253 VGND VGND VPWR VPWR sky130_fd_sc_hd__decap_3
XFILLER_7_1399 VGND VGND VPWR VPWR sky130_fd_sc_hd__fill_1
XFILLER_37_949 VGND VGND VPWR VPWR sky130_fd_sc_hd__decap_3
XFILLER_40_1450 VGND VGND VPWR VPWR sky130_fd_sc_hd__decap_3
XFILLER_48_297 VGND VGND VPWR VPWR sky130_fd_sc_hd__decap_3
XFILLER_63_223 VGND VGND VPWR VPWR sky130_fd_sc_hd__fill_1
X_3930_ _4240_/B _4327_/A VGND VGND VPWR VPWR _3931_/B sky130_fd_sc_hd__xor2_2
XFILLER_51_429 VGND VGND VPWR VPWR sky130_fd_sc_hd__decap_3
XFILLER_17_684 VGND VGND VPWR VPWR sky130_fd_sc_hd__decap_3
XFILLER_32_643 VGND VGND VPWR VPWR sky130_fd_sc_hd__fill_1
X_3861_ _4316_/A _4326_/A VGND VGND VPWR VPWR _3874_/A sky130_fd_sc_hd__xor2_2
X_5600_ _5606_/A1 _5600_/A2 _5609_/A3 _5601_/B1 _5600_/B2 VGND VGND VPWR VPWR _6672_/D
+ sky130_fd_sc_hd__a32o_2
XFILLER_31_153 VGND VGND VPWR VPWR sky130_fd_sc_hd__decap_3
XFILLER_32_687 VGND VGND VPWR VPWR sky130_fd_sc_hd__decap_3
XFILLER_73_1281 VGND VGND VPWR VPWR sky130_fd_sc_hd__decap_3
X_6580_ _6918_/CLK _6580_/D load_slew742/X VGND VGND VPWR VPWR _6580_/Q sky130_fd_sc_hd__dfrtp_2
XFILLER_73_1292 VGND VGND VPWR VPWR sky130_fd_sc_hd__decap_3
X_3792_ _3680_/Y _3792_/B VGND VGND VPWR VPWR _3793_/B sky130_fd_sc_hd__and2b_2
XFILLER_31_197 VGND VGND VPWR VPWR sky130_fd_sc_hd__decap_3
XFILLER_34_1254 VGND VGND VPWR VPWR sky130_fd_sc_hd__decap_3
XFILLER_9_850 VGND VGND VPWR VPWR sky130_fd_sc_hd__decap_3
X_5531_ _3097_/B _5529_/Y _5530_/X _5534_/B1 _6614_/Q VGND VGND VPWR VPWR _6614_/D
+ sky130_fd_sc_hd__a32o_2
XFILLER_34_1276 VGND VGND VPWR VPWR sky130_fd_sc_hd__decap_3
XFILLER_9_883 VGND VGND VPWR VPWR sky130_fd_sc_hd__decap_3
XFILLER_8_360 VGND VGND VPWR VPWR sky130_fd_sc_hd__decap_3
XFILLER_8_382 VGND VGND VPWR VPWR sky130_fd_sc_hd__decap_3
X_5462_ _5462_/A1 _5486_/A2 _4772_/X VGND VGND VPWR VPWR _6574_/D sky130_fd_sc_hd__a21o_2
XFILLER_69_1328 VGND VGND VPWR VPWR sky130_fd_sc_hd__decap_3
X_4413_ _4413_/A _4413_/B VGND VGND VPWR VPWR _4413_/Y sky130_fd_sc_hd__nor2_2
X_5393_ _5393_/A1 _5461_/A2 _4373_/X VGND VGND VPWR VPWR _6505_/D sky130_fd_sc_hd__a21o_2
XFILLER_67_1063 VGND VGND VPWR VPWR sky130_fd_sc_hd__fill_1
X_4344_ _4386_/A _4344_/B _4586_/C VGND VGND VPWR VPWR _4344_/X sky130_fd_sc_hd__and3_2
XFILLER_8_1108 VGND VGND VPWR VPWR sky130_fd_sc_hd__decap_3
Xfanout306 _3213_/A1 VGND VGND VPWR VPWR _6076_/A1 sky130_fd_sc_hd__clkdlybuf4s25_1
XFILLER_67_1085 VGND VGND VPWR VPWR sky130_fd_sc_hd__fill_2
Xfanout317 _3092_/Y VGND VGND VPWR VPWR _4261_/A2 sky130_fd_sc_hd__clkdlybuf4s25_1
X_7063_ _7063_/CLK _7063_/D fanout776/X VGND VGND VPWR VPWR _7063_/Q sky130_fd_sc_hd__dfrtp_2
X_4275_ _6826_/Q _4790_/A2 _4869_/B1 _4274_/X VGND VGND VPWR VPWR _4275_/X sky130_fd_sc_hd__a211o_2
XTAP_TAPCELL_ROW_52_1540 VGND VPWR sky130_fd_sc_hd__tapvpwrvgnd_1
XTAP_TAPCELL_ROW_52_1551 VGND VPWR sky130_fd_sc_hd__tapvpwrvgnd_1
X_6014_ hold990/X _7018_/Q _6046_/S VGND VGND VPWR VPWR _6014_/X sky130_fd_sc_hd__mux2_1
XFILLER_45_1372 VGND VGND VPWR VPWR sky130_fd_sc_hd__decap_3
XTAP_TAPCELL_ROW_52_1562 VGND VPWR sky130_fd_sc_hd__tapvpwrvgnd_1
X_3226_ _6248_/Q _6344_/Q VGND VGND VPWR VPWR _3226_/X sky130_fd_sc_hd__xor2_2
XFILLER_39_231 VGND VGND VPWR VPWR sky130_fd_sc_hd__decap_3
XFILLER_80_1285 VGND VGND VPWR VPWR sky130_fd_sc_hd__decap_3
XFILLER_41_1236 VGND VGND VPWR VPWR sky130_fd_sc_hd__decap_3
X_3157_ _7013_/Q _7021_/Q _3200_/S VGND VGND VPWR VPWR _3157_/X sky130_fd_sc_hd__mux2_1
XFILLER_41_1269 VGND VGND VPWR VPWR sky130_fd_sc_hd__decap_3
XFILLER_54_234 VGND VGND VPWR VPWR sky130_fd_sc_hd__decap_3
X_3088_ _4783_/A _4008_/B VGND VGND VPWR VPWR _3089_/B sky130_fd_sc_hd__nand2_2
XTAP_TAPCELL_ROW_65_1901 VGND VPWR sky130_fd_sc_hd__tapvpwrvgnd_1
XFILLER_70_727 VGND VGND VPWR VPWR sky130_fd_sc_hd__decap_3
XFILLER_14_109 VGND VGND VPWR VPWR sky130_fd_sc_hd__fill_2
XFILLER_78_1170 VGND VGND VPWR VPWR sky130_fd_sc_hd__decap_3
X_6916_ _7052_/CLK _6916_/D load_slew805/X VGND VGND VPWR VPWR _6916_/Q sky130_fd_sc_hd__dfrtp_2
XFILLER_74_1023 VGND VGND VPWR VPWR sky130_fd_sc_hd__decap_3
XFILLER_23_654 VGND VGND VPWR VPWR sky130_fd_sc_hd__decap_3
X_6847_ _6847_/CLK _6847_/D load_slew780/X VGND VGND VPWR VPWR _6847_/Q sky130_fd_sc_hd__dfrtp_2
XFILLER_39_1198 VGND VGND VPWR VPWR sky130_fd_sc_hd__fill_1
XTAP_TAPCELL_ROW_46_1388 VGND VPWR sky130_fd_sc_hd__tapvpwrvgnd_1
XFILLER_52_49 VGND VGND VPWR VPWR sky130_fd_sc_hd__decap_3
XTAP_TAPCELL_ROW_46_1399 VGND VPWR sky130_fd_sc_hd__tapvpwrvgnd_1
XFILLER_10_326 VGND VGND VPWR VPWR sky130_fd_sc_hd__decap_3
XFILLER_17_1452 VGND VGND VPWR VPWR sky130_fd_sc_hd__decap_3
X_6778_ _6970_/CLK _6778_/D load_slew674/X VGND VGND VPWR VPWR _6778_/Q sky130_fd_sc_hd__dfrtp_2
XFILLER_52_1332 VGND VGND VPWR VPWR sky130_fd_sc_hd__decap_3
XFILLER_17_1463 VGND VGND VPWR VPWR sky130_fd_sc_hd__decap_3
XFILLER_22_197 VGND VGND VPWR VPWR sky130_fd_sc_hd__decap_3
XFILLER_13_1316 VGND VGND VPWR VPWR sky130_fd_sc_hd__decap_3
XFILLER_52_1365 VGND VGND VPWR VPWR sky130_fd_sc_hd__decap_3
X_5729_ _5904_/A0 _5729_/A1 _5730_/S VGND VGND VPWR VPWR _6776_/D sky130_fd_sc_hd__mux2_1
XFILLER_52_1376 VGND VGND VPWR VPWR sky130_fd_sc_hd__decap_3
XTAP_TAPCELL_ROW_59_1727 VGND VPWR sky130_fd_sc_hd__tapvpwrvgnd_1
XTAP_TAPCELL_ROW_59_1738 VGND VPWR sky130_fd_sc_hd__tapvpwrvgnd_1
XFILLER_11_1062 VGND VGND VPWR VPWR sky130_fd_sc_hd__fill_2
XFILLER_11_1084 VGND VGND VPWR VPWR sky130_fd_sc_hd__decap_3
XFILLER_77_24 VGND VGND VPWR VPWR sky130_fd_sc_hd__decap_3
XFILLER_77_57 VGND VGND VPWR VPWR sky130_fd_sc_hd__decap_3
XTAP_TAPCELL_ROW_5_330 VGND VPWR sky130_fd_sc_hd__tapvpwrvgnd_1
XFILLER_24_1412 VGND VGND VPWR VPWR sky130_fd_sc_hd__decap_3
XTAP_TAPCELL_ROW_5_341 VGND VPWR sky130_fd_sc_hd__tapvpwrvgnd_1
XFILLER_77_359 VGND VGND VPWR VPWR sky130_fd_sc_hd__decap_3
XFILLER_24_1456 VGND VGND VPWR VPWR sky130_fd_sc_hd__decap_3
XFILLER_46_713 VGND VGND VPWR VPWR sky130_fd_sc_hd__decap_3
XFILLER_18_415 VGND VGND VPWR VPWR sky130_fd_sc_hd__decap_3
XFILLER_20_1309 VGND VGND VPWR VPWR sky130_fd_sc_hd__decap_3
Xhold1060 _6960_/Q VGND VGND VPWR VPWR _5956_/A1 sky130_fd_sc_hd__dlygate4sd3_1
Xhold1071 _6643_/Q VGND VGND VPWR VPWR _5560_/B1 sky130_fd_sc_hd__dlygate4sd3_1
XTAP_TAPCELL_ROW_29_944 VGND VPWR sky130_fd_sc_hd__tapvpwrvgnd_1
XFILLER_45_223 VGND VGND VPWR VPWR sky130_fd_sc_hd__fill_1
Xhold1082 _6176_/Q VGND VGND VPWR VPWR _6023_/A0 sky130_fd_sc_hd__dlygate4sd3_1
XFILLER_46_757 VGND VGND VPWR VPWR sky130_fd_sc_hd__decap_3
Xhold1093 _6194_/Q VGND VGND VPWR VPWR _6041_/A0 sky130_fd_sc_hd__dlygate4sd3_1
XFILLER_2_1241 VGND VGND VPWR VPWR sky130_fd_sc_hd__decap_3
XTAP_TAPCELL_ROW_29_955 VGND VPWR sky130_fd_sc_hd__tapvpwrvgnd_1
XFILLER_34_908 VGND VGND VPWR VPWR sky130_fd_sc_hd__fill_2
XTAP_TAPCELL_ROW_29_966 VGND VPWR sky130_fd_sc_hd__tapvpwrvgnd_1
XFILLER_34_919 VGND VGND VPWR VPWR sky130_fd_sc_hd__decap_3
XTAP_TAPCELL_ROW_16_605 VGND VPWR sky130_fd_sc_hd__tapvpwrvgnd_1
XFILLER_2_1285 VGND VGND VPWR VPWR sky130_fd_sc_hd__decap_3
XTAP_TAPCELL_ROW_16_616 VGND VPWR sky130_fd_sc_hd__tapvpwrvgnd_1
XFILLER_45_289 VGND VGND VPWR VPWR sky130_fd_sc_hd__decap_3
XFILLER_61_738 VGND VGND VPWR VPWR sky130_fd_sc_hd__decap_3
XTAP_TAPCELL_ROW_16_627 VGND VPWR sky130_fd_sc_hd__tapvpwrvgnd_1
XFILLER_60_226 VGND VGND VPWR VPWR sky130_fd_sc_hd__decap_3
XFILLER_18_1205 VGND VGND VPWR VPWR sky130_fd_sc_hd__decap_3
XFILLER_57_1254 VGND VGND VPWR VPWR sky130_fd_sc_hd__decap_3
XFILLER_14_643 VGND VGND VPWR VPWR sky130_fd_sc_hd__fill_1
XFILLER_42_952 VGND VGND VPWR VPWR sky130_fd_sc_hd__decap_3
XFILLER_14_654 VGND VGND VPWR VPWR sky130_fd_sc_hd__decap_3
XFILLER_53_1107 VGND VGND VPWR VPWR sky130_fd_sc_hd__fill_2
XFILLER_13_142 VGND VGND VPWR VPWR sky130_fd_sc_hd__decap_3
XFILLER_18_1238 VGND VGND VPWR VPWR sky130_fd_sc_hd__decap_3
XFILLER_57_1287 VGND VGND VPWR VPWR sky130_fd_sc_hd__fill_1
XFILLER_57_1298 VGND VGND VPWR VPWR sky130_fd_sc_hd__decap_3
XFILLER_14_687 VGND VGND VPWR VPWR sky130_fd_sc_hd__decap_3
XFILLER_41_473 VGND VGND VPWR VPWR sky130_fd_sc_hd__decap_3
XFILLER_70_1421 VGND VGND VPWR VPWR sky130_fd_sc_hd__decap_3
XFILLER_9_113 VGND VGND VPWR VPWR sky130_fd_sc_hd__decap_3
XFILLER_70_1432 VGND VGND VPWR VPWR sky130_fd_sc_hd__decap_3
XFILLER_70_1465 VGND VGND VPWR VPWR sky130_fd_sc_hd__decap_3
XFILLER_31_1416 VGND VGND VPWR VPWR sky130_fd_sc_hd__decap_3
XFILLER_31_1449 VGND VGND VPWR VPWR sky130_fd_sc_hd__decap_3
XFILLER_6_842 VGND VGND VPWR VPWR sky130_fd_sc_hd__decap_3
XFILLER_29_1301 VGND VGND VPWR VPWR sky130_fd_sc_hd__decap_3
XFILLER_68_1350 VGND VGND VPWR VPWR sky130_fd_sc_hd__decap_3
XFILLER_5_396 VGND VGND VPWR VPWR sky130_fd_sc_hd__decap_3
XFILLER_47_6 VGND VGND VPWR VPWR sky130_fd_sc_hd__decap_3
XFILLER_64_1203 VGND VGND VPWR VPWR sky130_fd_sc_hd__fill_1
XFILLER_29_1334 VGND VGND VPWR VPWR sky130_fd_sc_hd__decap_3
XFILLER_64_1214 VGND VGND VPWR VPWR sky130_fd_sc_hd__decap_3
XFILLER_29_1345 VGND VGND VPWR VPWR sky130_fd_sc_hd__decap_3
XFILLER_68_1394 VGND VGND VPWR VPWR sky130_fd_sc_hd__decap_3
XFILLER_9_1428 VGND VGND VPWR VPWR sky130_fd_sc_hd__decap_3
XFILLER_3_21 VGND VGND VPWR VPWR sky130_fd_sc_hd__decap_3
XFILLER_64_1247 VGND VGND VPWR VPWR sky130_fd_sc_hd__decap_3
XFILLER_29_1378 VGND VGND VPWR VPWR sky130_fd_sc_hd__decap_3
XFILLER_69_838 VGND VGND VPWR VPWR sky130_fd_sc_hd__fill_2
XFILLER_3_54 VGND VGND VPWR VPWR sky130_fd_sc_hd__fill_2
XFILLER_7_1130 VGND VGND VPWR VPWR sky130_fd_sc_hd__decap_3
XTAP_TAPCELL_ROW_69_2001 VGND VPWR sky130_fd_sc_hd__tapvpwrvgnd_1
X_4060_ _6592_/Q _4777_/A _4061_/A1 VGND VGND VPWR VPWR _4060_/X sky130_fd_sc_hd__a21bo_2
XFILLER_3_87 VGND VGND VPWR VPWR sky130_fd_sc_hd__decap_3
XFILLER_27_1080 VGND VGND VPWR VPWR sky130_fd_sc_hd__fill_2
XFILLER_77_871 VGND VGND VPWR VPWR sky130_fd_sc_hd__decap_3
XFILLER_7_1163 VGND VGND VPWR VPWR sky130_fd_sc_hd__decap_3
XFILLER_37_702 VGND VGND VPWR VPWR sky130_fd_sc_hd__decap_3
XFILLER_3_1005 VGND VGND VPWR VPWR sky130_fd_sc_hd__decap_3
XFILLER_3_1027 VGND VGND VPWR VPWR sky130_fd_sc_hd__decap_3
XFILLER_49_595 VGND VGND VPWR VPWR sky130_fd_sc_hd__decap_3
XFILLER_25_908 VGND VGND VPWR VPWR sky130_fd_sc_hd__fill_1
XFILLER_36_256 VGND VGND VPWR VPWR sky130_fd_sc_hd__decap_3
Xwire49 wire49/A VGND VGND VPWR VPWR wire49/X sky130_fd_sc_hd__clkbuf_4
XFILLER_40_1291 VGND VGND VPWR VPWR sky130_fd_sc_hd__decap_3
XFILLER_75_1310 VGND VGND VPWR VPWR sky130_fd_sc_hd__decap_3
XFILLER_36_289 VGND VGND VPWR VPWR sky130_fd_sc_hd__decap_3
XFILLER_52_738 VGND VGND VPWR VPWR sky130_fd_sc_hd__decap_3
XFILLER_17_470 VGND VGND VPWR VPWR sky130_fd_sc_hd__decap_3
X_4962_ _4960_/X _4961_/Y _5151_/A2 VGND VGND VPWR VPWR _4964_/S sky130_fd_sc_hd__a21oi_2
XFILLER_75_1343 VGND VGND VPWR VPWR sky130_fd_sc_hd__fill_1
XFILLER_75_1354 VGND VGND VPWR VPWR sky130_fd_sc_hd__decap_3
X_6701_ _7048_/CLK _6701_/D wire655/X VGND VGND VPWR VPWR _6701_/Q sky130_fd_sc_hd__dfrtp_2
X_3913_ _3913_/A _3913_/B _3913_/C VGND VGND VPWR VPWR _3915_/A sky130_fd_sc_hd__and3_2
XFILLER_71_1207 VGND VGND VPWR VPWR sky130_fd_sc_hd__decap_3
X_4893_ _4428_/A _4608_/B _4344_/X _4842_/X _6591_/Q VGND VGND VPWR VPWR _4893_/X
+ sky130_fd_sc_hd__a32o_2
XFILLER_75_1387 VGND VGND VPWR VPWR sky130_fd_sc_hd__decap_3
XFILLER_36_1338 VGND VGND VPWR VPWR sky130_fd_sc_hd__decap_3
X_6632_ _6954_/CLK _6632_/D load_slew650/X VGND VGND VPWR VPWR _6632_/Q sky130_fd_sc_hd__dfrtp_2
XFILLER_60_782 VGND VGND VPWR VPWR sky130_fd_sc_hd__decap_3
X_3844_ _3960_/A _6299_/Q VGND VGND VPWR VPWR _3844_/X sky130_fd_sc_hd__and2b_2
XFILLER_32_495 VGND VGND VPWR VPWR sky130_fd_sc_hd__decap_3
XFILLER_34_1040 VGND VGND VPWR VPWR sky130_fd_sc_hd__decap_3
X_6563_ _7000_/CLK _6563_/D fanout721/X VGND VGND VPWR VPWR _6563_/Q sky130_fd_sc_hd__dfrtp_2
XFILLER_34_1073 VGND VGND VPWR VPWR sky130_fd_sc_hd__fill_1
X_3775_ _4347_/A _4270_/A VGND VGND VPWR VPWR _3775_/Y sky130_fd_sc_hd__xnor2_2
XTAP_TAPCELL_ROW_41_1263 VGND VPWR sky130_fd_sc_hd__tapvpwrvgnd_1
XTAP_TAPCELL_ROW_41_1274 VGND VPWR sky130_fd_sc_hd__tapvpwrvgnd_1
X_5514_ _5514_/A _5514_/B VGND VGND VPWR VPWR _5514_/Y sky130_fd_sc_hd__nand2_2
X_6494_ _6929_/CLK _6494_/D load_slew705/X VGND VGND VPWR VPWR _6494_/Q sky130_fd_sc_hd__dfrtp_2
XFILLER_8_190 VGND VGND VPWR VPWR sky130_fd_sc_hd__decap_3
XFILLER_69_1147 VGND VGND VPWR VPWR sky130_fd_sc_hd__decap_3
X_5445_ _5445_/A1 _5477_/A2 _4705_/X VGND VGND VPWR VPWR _6557_/D sky130_fd_sc_hd__a21o_2
XFILLER_12_1371 VGND VGND VPWR VPWR sky130_fd_sc_hd__fill_1
XFILLER_12_1382 VGND VGND VPWR VPWR sky130_fd_sc_hd__decap_3
XFILLER_47_1401 VGND VGND VPWR VPWR sky130_fd_sc_hd__decap_3
XTAP_TAPCELL_ROW_54_1602 VGND VPWR sky130_fd_sc_hd__tapvpwrvgnd_1
XTAP_TAPCELL_ROW_54_1613 VGND VPWR sky130_fd_sc_hd__tapvpwrvgnd_1
X_5376_ _5376_/A1 _5464_/A2 _4273_/X VGND VGND VPWR VPWR _6488_/D sky130_fd_sc_hd__a21o_2
XFILLER_47_1434 VGND VGND VPWR VPWR sky130_fd_sc_hd__decap_3
Xfanout103 _5290_/A2 VGND VGND VPWR VPWR _5248_/A2 sky130_fd_sc_hd__clkdlybuf4s25_1
X_4327_ _4327_/A _4327_/B VGND VGND VPWR VPWR _4328_/B sky130_fd_sc_hd__xnor2_2
Xfanout136 _5353_/S VGND VGND VPWR VPWR wire137/A sky130_fd_sc_hd__clkdlybuf4s25_1
XFILLER_59_337 VGND VGND VPWR VPWR sky130_fd_sc_hd__decap_3
Xfanout158 _5780_/S VGND VGND VPWR VPWR wire159/A sky130_fd_sc_hd__clkdlybuf4s25_1
X_7046_ _7046_/CLK _7046_/D fanout753/X VGND VGND VPWR VPWR _7046_/Q sky130_fd_sc_hd__dfrtp_2
XFILLER_41_1000 VGND VGND VPWR VPWR sky130_fd_sc_hd__decap_3
X_4258_ _4258_/A _4258_/B VGND VGND VPWR VPWR _4259_/B sky130_fd_sc_hd__xor2_2
Xfanout169 _4760_/A VGND VGND VPWR VPWR _4738_/A sky130_fd_sc_hd__clkdlybuf4s25_1
XFILLER_45_1180 VGND VGND VPWR VPWR sky130_fd_sc_hd__decap_3
XFILLER_80_1071 VGND VGND VPWR VPWR sky130_fd_sc_hd__decap_3
XFILLER_80_1093 VGND VGND VPWR VPWR sky130_fd_sc_hd__decap_3
X_3209_ _3217_/A _3205_/X _3208_/X _3202_/X VGND VGND VPWR VPWR _3209_/X sky130_fd_sc_hd__a31o_2
X_4189_ _4428_/A _4608_/B _4783_/C VGND VGND VPWR VPWR _4257_/S sky130_fd_sc_hd__or3_2
XFILLER_16_919 VGND VGND VPWR VPWR sky130_fd_sc_hd__decap_3
XFILLER_76_1129 VGND VGND VPWR VPWR sky130_fd_sc_hd__decap_3
XFILLER_63_15 VGND VGND VPWR VPWR sky130_fd_sc_hd__decap_3
XFILLER_27_278 VGND VGND VPWR VPWR sky130_fd_sc_hd__fill_2
XTAP_TAPCELL_ROW_48_1439 VGND VPWR sky130_fd_sc_hd__tapvpwrvgnd_1
XFILLER_42_215 VGND VGND VPWR VPWR sky130_fd_sc_hd__fill_1
XFILLER_42_237 VGND VGND VPWR VPWR sky130_fd_sc_hd__decap_3
XFILLER_24_974 VGND VGND VPWR VPWR sky130_fd_sc_hd__decap_3
XFILLER_54_1427 VGND VGND VPWR VPWR sky130_fd_sc_hd__fill_1
XFILLER_54_1438 VGND VGND VPWR VPWR sky130_fd_sc_hd__decap_3
XFILLER_11_646 VGND VGND VPWR VPWR sky130_fd_sc_hd__decap_3
XFILLER_7_606 VGND VGND VPWR VPWR sky130_fd_sc_hd__decap_3
XFILLER_17_1260 VGND VGND VPWR VPWR sky130_fd_sc_hd__decap_3
Xwire515 wire515/A VGND VGND VPWR VPWR wire515/X sky130_fd_sc_hd__clkbuf_4
XFILLER_11_668 VGND VGND VPWR VPWR sky130_fd_sc_hd__decap_3
XFILLER_7_617 VGND VGND VPWR VPWR sky130_fd_sc_hd__decap_3
XFILLER_13_1124 VGND VGND VPWR VPWR sky130_fd_sc_hd__decap_3
XFILLER_10_178 VGND VGND VPWR VPWR sky130_fd_sc_hd__decap_3
XFILLER_3_812 VGND VGND VPWR VPWR sky130_fd_sc_hd__decap_3
XFILLER_2_300 VGND VGND VPWR VPWR sky130_fd_sc_hd__decap_3
XFILLER_3_856 VGND VGND VPWR VPWR sky130_fd_sc_hd__decap_3
XFILLER_3_889 VGND VGND VPWR VPWR sky130_fd_sc_hd__decap_3
XFILLER_78_624 VGND VGND VPWR VPWR sky130_fd_sc_hd__decap_3
XFILLER_2_377 VGND VGND VPWR VPWR sky130_fd_sc_hd__decap_3
XFILLER_66_808 VGND VGND VPWR VPWR sky130_fd_sc_hd__decap_3
XFILLER_8_1450 VGND VGND VPWR VPWR sky130_fd_sc_hd__decap_3
XFILLER_4_1303 VGND VGND VPWR VPWR sky130_fd_sc_hd__decap_3
Xfanout670 fanout672/X VGND VGND VPWR VPWR fanout670/X sky130_fd_sc_hd__clkdlybuf4s25_1
XFILLER_65_307 VGND VGND VPWR VPWR sky130_fd_sc_hd__fill_2
XFILLER_24_1253 VGND VGND VPWR VPWR sky130_fd_sc_hd__decap_3
XFILLER_19_724 VGND VGND VPWR VPWR sky130_fd_sc_hd__decap_3
XFILLER_24_1264 VGND VGND VPWR VPWR sky130_fd_sc_hd__decap_3
XFILLER_4_1347 VGND VGND VPWR VPWR sky130_fd_sc_hd__decap_3
XFILLER_24_1297 VGND VGND VPWR VPWR sky130_fd_sc_hd__decap_3
XFILLER_46_554 VGND VGND VPWR VPWR sky130_fd_sc_hd__decap_3
XFILLER_59_1316 VGND VGND VPWR VPWR sky130_fd_sc_hd__decap_3
XFILLER_73_340 VGND VGND VPWR VPWR sky130_fd_sc_hd__decap_3
XPHY_EDGE_ROW_16_Right_16 VGND VGND VPWR VPWR sky130_fd_sc_hd__decap_3
XFILLER_73_362 VGND VGND VPWR VPWR sky130_fd_sc_hd__decap_3
XFILLER_46_587 VGND VGND VPWR VPWR sky130_fd_sc_hd__fill_1
XFILLER_2_1082 VGND VGND VPWR VPWR sky130_fd_sc_hd__decap_3
XFILLER_2_1093 VGND VGND VPWR VPWR sky130_fd_sc_hd__decap_3
XFILLER_33_237 VGND VGND VPWR VPWR sky130_fd_sc_hd__decap_3
XFILLER_30_911 VGND VGND VPWR VPWR sky130_fd_sc_hd__decap_3
XFILLER_14_473 VGND VGND VPWR VPWR sky130_fd_sc_hd__decap_3
XFILLER_18_1046 VGND VGND VPWR VPWR sky130_fd_sc_hd__decap_3
XFILLER_30_944 VGND VGND VPWR VPWR sky130_fd_sc_hd__decap_3
XFILLER_41_281 VGND VGND VPWR VPWR sky130_fd_sc_hd__decap_3
XFILLER_35_1360 VGND VGND VPWR VPWR sky130_fd_sc_hd__decap_3
XFILLER_31_1202 VGND VGND VPWR VPWR sky130_fd_sc_hd__fill_1
XFILLER_70_1273 VGND VGND VPWR VPWR sky130_fd_sc_hd__decap_3
XFILLER_35_1393 VGND VGND VPWR VPWR sky130_fd_sc_hd__decap_3
XPHY_EDGE_ROW_25_Right_25 VGND VGND VPWR VPWR sky130_fd_sc_hd__decap_3
X_3560_ _5514_/A _3555_/X _3557_/X _3559_/X VGND VGND VPWR VPWR _3560_/X sky130_fd_sc_hd__a22o_2
XFILLER_31_1257 VGND VGND VPWR VPWR sky130_fd_sc_hd__decap_3
XFILLER_6_650 VGND VGND VPWR VPWR sky130_fd_sc_hd__decap_3
X_3491_ _3496_/B _3566_/A VGND VGND VPWR VPWR _3491_/X sky130_fd_sc_hd__and2b_2
XFILLER_66_1309 VGND VGND VPWR VPWR sky130_fd_sc_hd__decap_3
X_5230_ _6418_/Q _5254_/A2 _5229_/X VGND VGND VPWR VPWR _6418_/D sky130_fd_sc_hd__a21o_2
XFILLER_45_3 VGND VGND VPWR VPWR sky130_fd_sc_hd__decap_3
XFILLER_29_1142 VGND VGND VPWR VPWR sky130_fd_sc_hd__decap_3
XFILLER_9_1225 VGND VGND VPWR VPWR sky130_fd_sc_hd__decap_3
X_5161_ _6389_/Q _5263_/A2 _4999_/S _5160_/X VGND VGND VPWR VPWR _6389_/D sky130_fd_sc_hd__a22o_2
XFILLER_9_1236 VGND VGND VPWR VPWR sky130_fd_sc_hd__decap_3
XFILLER_68_123 VGND VGND VPWR VPWR sky130_fd_sc_hd__decap_3
XFILLER_9_1269 VGND VGND VPWR VPWR sky130_fd_sc_hd__decap_3
X_4112_ _4112_/A _4193_/A VGND VGND VPWR VPWR _4725_/B sky130_fd_sc_hd__xor2_2
XFILLER_57_808 VGND VGND VPWR VPWR sky130_fd_sc_hd__decap_3
X_5092_ _6370_/Q _5091_/X _5502_/C _6708_/Q VGND VGND VPWR VPWR _5092_/X sky130_fd_sc_hd__a2bb2o_2
XFILLER_42_1320 VGND VGND VPWR VPWR sky130_fd_sc_hd__decap_3
XFILLER_69_679 VGND VGND VPWR VPWR sky130_fd_sc_hd__decap_3
XFILLER_42_1353 VGND VGND VPWR VPWR sky130_fd_sc_hd__decap_3
X_4043_ _4091_/A1 _4040_/X _4041_/Y _4042_/X _4382_/C1 VGND VGND VPWR VPWR _4043_/X
+ sky130_fd_sc_hd__o221a_2
XPHY_EDGE_ROW_34_Right_34 VGND VGND VPWR VPWR sky130_fd_sc_hd__decap_3
XFILLER_65_852 VGND VGND VPWR VPWR sky130_fd_sc_hd__decap_3
XFILLER_42_1397 VGND VGND VPWR VPWR sky130_fd_sc_hd__decap_3
XFILLER_77_1416 VGND VGND VPWR VPWR sky130_fd_sc_hd__decap_3
XFILLER_37_554 VGND VGND VPWR VPWR sky130_fd_sc_hd__decap_3
XFILLER_80_811 VGND VGND VPWR VPWR sky130_fd_sc_hd__fill_1
XFILLER_77_1449 VGND VGND VPWR VPWR sky130_fd_sc_hd__decap_3
XFILLER_25_749 VGND VGND VPWR VPWR sky130_fd_sc_hd__decap_3
XFILLER_64_384 VGND VGND VPWR VPWR sky130_fd_sc_hd__decap_3
XFILLER_80_844 VGND VGND VPWR VPWR sky130_fd_sc_hd__decap_3
X_5994_ _5994_/A0 _5994_/A1 _6058_/S VGND VGND VPWR VPWR _6998_/D sky130_fd_sc_hd__mux2_1
XFILLER_80_877 VGND VGND VPWR VPWR sky130_fd_sc_hd__decap_3
XFILLER_75_1151 VGND VGND VPWR VPWR sky130_fd_sc_hd__decap_3
X_4945_ _6414_/Q _4945_/B VGND VGND VPWR VPWR _5216_/B sky130_fd_sc_hd__xnor2_2
XTAP_TAPCELL_ROW_43_1314 VGND VPWR sky130_fd_sc_hd__tapvpwrvgnd_1
XFILLER_33_782 VGND VGND VPWR VPWR sky130_fd_sc_hd__fill_2
XTAP_TAPCELL_ROW_43_1325 VGND VPWR sky130_fd_sc_hd__tapvpwrvgnd_1
XFILLER_75_1195 VGND VGND VPWR VPWR sky130_fd_sc_hd__decap_3
XFILLER_33_793 VGND VGND VPWR VPWR sky130_fd_sc_hd__decap_3
X_4876_ _6926_/Q wire295/X _4876_/B1 _4875_/X VGND VGND VPWR VPWR _4876_/X sky130_fd_sc_hd__a211o_2
XFILLER_20_421 VGND VGND VPWR VPWR sky130_fd_sc_hd__decap_3
XFILLER_14_1400 VGND VGND VPWR VPWR sky130_fd_sc_hd__decap_3
XFILLER_53_1460 VGND VGND VPWR VPWR sky130_fd_sc_hd__decap_3
X_6615_ _6617_/CLK _6615_/D load_slew732/X VGND VGND VPWR VPWR _6615_/Q sky130_fd_sc_hd__dfrtp_2
X_3827_ _3827_/A _3827_/B _3827_/C VGND VGND VPWR VPWR _3855_/C sky130_fd_sc_hd__nand3_2
XPHY_EDGE_ROW_43_Right_43 VGND VGND VPWR VPWR sky130_fd_sc_hd__decap_3
XFILLER_14_1444 VGND VGND VPWR VPWR sky130_fd_sc_hd__decap_3
XFILLER_20_487 VGND VGND VPWR VPWR sky130_fd_sc_hd__decap_3
X_6546_ _7015_/CLK _6546_/D load_slew799/X VGND VGND VPWR VPWR _6546_/Q sky130_fd_sc_hd__dfrtp_2
XTAP_TAPCELL_ROW_31_994 VGND VPWR sky130_fd_sc_hd__tapvpwrvgnd_1
X_3758_ _3758_/A _3758_/B VGND VGND VPWR VPWR _3760_/C sky130_fd_sc_hd__and2_2
XFILLER_3_108 VGND VGND VPWR VPWR sky130_fd_sc_hd__decap_3
XFILLER_3_119 VGND VGND VPWR VPWR sky130_fd_sc_hd__decap_3
X_6477_ _6847_/CLK _6477_/D load_slew778/X VGND VGND VPWR VPWR _6477_/Q sky130_fd_sc_hd__dfrtp_2
X_3689_ _3689_/A _3881_/B _3880_/A VGND VGND VPWR VPWR _3757_/A sky130_fd_sc_hd__nand3_2
X_5428_ _5428_/A1 _5484_/A2 _4582_/X VGND VGND VPWR VPWR _6540_/D sky130_fd_sc_hd__a21o_2
XFILLER_47_1242 VGND VGND VPWR VPWR sky130_fd_sc_hd__decap_3
XFILLER_0_837 VGND VGND VPWR VPWR sky130_fd_sc_hd__decap_3
X_5359_ _5506_/A _5359_/B _5359_/C VGND VGND VPWR VPWR _5359_/X sky130_fd_sc_hd__and3b_2
XFILLER_47_1275 VGND VGND VPWR VPWR sky130_fd_sc_hd__decap_3
XFILLER_43_1117 VGND VGND VPWR VPWR sky130_fd_sc_hd__decap_3
XFILLER_0_859 VGND VGND VPWR VPWR sky130_fd_sc_hd__decap_3
XFILLER_58_59 VGND VGND VPWR VPWR sky130_fd_sc_hd__decap_3
XPHY_EDGE_ROW_52_Right_52 VGND VGND VPWR VPWR sky130_fd_sc_hd__decap_3
XFILLER_59_167 VGND VGND VPWR VPWR sky130_fd_sc_hd__fill_1
XFILLER_59_178 VGND VGND VPWR VPWR sky130_fd_sc_hd__fill_1
X_7029_ _7077_/CLK _7029_/D load_slew692/X VGND VGND VPWR VPWR _7029_/Q sky130_fd_sc_hd__dfrtp_2
XFILLER_21_1404 VGND VGND VPWR VPWR sky130_fd_sc_hd__decap_3
XFILLER_60_1453 VGND VGND VPWR VPWR sky130_fd_sc_hd__decap_3
XFILLER_56_830 VGND VGND VPWR VPWR sky130_fd_sc_hd__fill_1
XFILLER_74_148 VGND VGND VPWR VPWR sky130_fd_sc_hd__fill_2
XFILLER_21_1437 VGND VGND VPWR VPWR sky130_fd_sc_hd__decap_3
XFILLER_55_340 VGND VGND VPWR VPWR sky130_fd_sc_hd__fill_2
XFILLER_74_47 VGND VGND VPWR VPWR sky130_fd_sc_hd__decap_3
XFILLER_28_576 VGND VGND VPWR VPWR sky130_fd_sc_hd__decap_3
XFILLER_16_727 VGND VGND VPWR VPWR sky130_fd_sc_hd__decap_3
XFILLER_28_587 VGND VGND VPWR VPWR sky130_fd_sc_hd__fill_1
XFILLER_70_343 VGND VGND VPWR VPWR sky130_fd_sc_hd__decap_3
XFILLER_70_354 VGND VGND VPWR VPWR sky130_fd_sc_hd__fill_1
XFILLER_19_1322 VGND VGND VPWR VPWR sky130_fd_sc_hd__decap_3
XFILLER_58_1371 VGND VGND VPWR VPWR sky130_fd_sc_hd__fill_1
XFILLER_58_1382 VGND VGND VPWR VPWR sky130_fd_sc_hd__decap_3
XFILLER_70_376 VGND VGND VPWR VPWR sky130_fd_sc_hd__decap_3
XFILLER_54_1235 VGND VGND VPWR VPWR sky130_fd_sc_hd__decap_3
XFILLER_19_1366 VGND VGND VPWR VPWR sky130_fd_sc_hd__decap_3
XFILLER_12_955 VGND VGND VPWR VPWR sky130_fd_sc_hd__decap_3
XFILLER_23_281 VGND VGND VPWR VPWR sky130_fd_sc_hd__fill_1
XPHY_EDGE_ROW_61_Right_61 VGND VGND VPWR VPWR sky130_fd_sc_hd__decap_3
XFILLER_8_904 VGND VGND VPWR VPWR sky130_fd_sc_hd__decap_3
XFILLER_15_1219 VGND VGND VPWR VPWR sky130_fd_sc_hd__decap_3
XFILLER_11_443 VGND VGND VPWR VPWR sky130_fd_sc_hd__decap_3
XFILLER_19_1399 VGND VGND VPWR VPWR sky130_fd_sc_hd__fill_1
XFILLER_54_1279 VGND VGND VPWR VPWR sky130_fd_sc_hd__decap_3
XFILLER_11_465 VGND VGND VPWR VPWR sky130_fd_sc_hd__decap_3
XFILLER_7_414 VGND VGND VPWR VPWR sky130_fd_sc_hd__decap_3
XFILLER_7_447 VGND VGND VPWR VPWR sky130_fd_sc_hd__fill_1
XFILLER_7_458 VGND VGND VPWR VPWR sky130_fd_sc_hd__decap_3
XFILLER_3_620 VGND VGND VPWR VPWR sky130_fd_sc_hd__decap_3
XFILLER_48_1028 VGND VGND VPWR VPWR sky130_fd_sc_hd__decap_3
XFILLER_79_900 VGND VGND VPWR VPWR sky130_fd_sc_hd__decap_3
XFILLER_2_130 VGND VGND VPWR VPWR sky130_fd_sc_hd__decap_3
XFILLER_3_664 VGND VGND VPWR VPWR sky130_fd_sc_hd__decap_3
XFILLER_65_1331 VGND VGND VPWR VPWR sky130_fd_sc_hd__decap_3
XFILLER_2_141 VGND VGND VPWR VPWR sky130_fd_sc_hd__decap_3
XFILLER_78_421 VGND VGND VPWR VPWR sky130_fd_sc_hd__fill_1
XPHY_EDGE_ROW_70_Right_70 VGND VGND VPWR VPWR sky130_fd_sc_hd__decap_3
XFILLER_3_697 VGND VGND VPWR VPWR sky130_fd_sc_hd__decap_3
XFILLER_2_174 VGND VGND VPWR VPWR sky130_fd_sc_hd__decap_3
XFILLER_26_1315 VGND VGND VPWR VPWR sky130_fd_sc_hd__fill_1
XFILLER_31_9 VGND VGND VPWR VPWR sky130_fd_sc_hd__decap_3
Xload_slew328 _5552_/B2 VGND VGND VPWR VPWR _5564_/B2 sky130_fd_sc_hd__buf_2
XFILLER_26_1326 VGND VGND VPWR VPWR sky130_fd_sc_hd__decap_3
XFILLER_65_1375 VGND VGND VPWR VPWR sky130_fd_sc_hd__decap_3
XFILLER_6_1409 VGND VGND VPWR VPWR sky130_fd_sc_hd__decap_3
XFILLER_78_454 VGND VGND VPWR VPWR sky130_fd_sc_hd__decap_3
XFILLER_61_1228 VGND VGND VPWR VPWR sky130_fd_sc_hd__decap_3
XFILLER_26_1359 VGND VGND VPWR VPWR sky130_fd_sc_hd__decap_3
XFILLER_61_1239 VGND VGND VPWR VPWR sky130_fd_sc_hd__decap_3
XFILLER_38_307 VGND VGND VPWR VPWR sky130_fd_sc_hd__fill_1
XFILLER_4_1111 VGND VGND VPWR VPWR sky130_fd_sc_hd__decap_3
XFILLER_8_1291 VGND VGND VPWR VPWR sky130_fd_sc_hd__decap_3
XFILLER_47_830 VGND VGND VPWR VPWR sky130_fd_sc_hd__decap_3
XFILLER_59_690 VGND VGND VPWR VPWR sky130_fd_sc_hd__decap_3
XFILLER_4_1144 VGND VGND VPWR VPWR sky130_fd_sc_hd__decap_3
XFILLER_47_841 VGND VGND VPWR VPWR sky130_fd_sc_hd__fill_2
XFILLER_4_1155 VGND VGND VPWR VPWR sky130_fd_sc_hd__decap_3
XFILLER_19_554 VGND VGND VPWR VPWR sky130_fd_sc_hd__decap_3
XFILLER_0_44 VGND VGND VPWR VPWR sky130_fd_sc_hd__decap_3
XFILLER_46_351 VGND VGND VPWR VPWR sky130_fd_sc_hd__fill_2
XFILLER_4_1188 VGND VGND VPWR VPWR sky130_fd_sc_hd__decap_3
XFILLER_0_66 VGND VGND VPWR VPWR sky130_fd_sc_hd__decap_3
XFILLER_0_88 VGND VGND VPWR VPWR sky130_fd_sc_hd__decap_3
XFILLER_34_557 VGND VGND VPWR VPWR sky130_fd_sc_hd__decap_3
XFILLER_62_866 VGND VGND VPWR VPWR sky130_fd_sc_hd__fill_2
XFILLER_37_1422 VGND VGND VPWR VPWR sky130_fd_sc_hd__decap_3
XFILLER_62_899 VGND VGND VPWR VPWR sky130_fd_sc_hd__decap_3
XFILLER_15_771 VGND VGND VPWR VPWR sky130_fd_sc_hd__decap_3
XFILLER_72_1335 VGND VGND VPWR VPWR sky130_fd_sc_hd__decap_3
XFILLER_15_793 VGND VGND VPWR VPWR sky130_fd_sc_hd__decap_3
XFILLER_37_1455 VGND VGND VPWR VPWR sky130_fd_sc_hd__fill_1
X_4730_ _6320_/Q wire54/X _4727_/X _4729_/X VGND VGND VPWR VPWR _6320_/D sky130_fd_sc_hd__o22a_2
XFILLER_14_270 VGND VGND VPWR VPWR sky130_fd_sc_hd__decap_3
XFILLER_9_42 VGND VGND VPWR VPWR sky130_fd_sc_hd__decap_3
XFILLER_37_1466 VGND VGND VPWR VPWR sky130_fd_sc_hd__decap_3
XFILLER_72_1368 VGND VGND VPWR VPWR sky130_fd_sc_hd__decap_3
XFILLER_9_64 VGND VGND VPWR VPWR sky130_fd_sc_hd__decap_3
XFILLER_33_1319 VGND VGND VPWR VPWR sky130_fd_sc_hd__decap_3
XFILLER_72_1379 VGND VGND VPWR VPWR sky130_fd_sc_hd__decap_3
XFILLER_30_763 VGND VGND VPWR VPWR sky130_fd_sc_hd__fill_2
X_4661_ _4838_/A1 _4658_/X _4659_/Y _4660_/X _4896_/C1 VGND VGND VPWR VPWR _4661_/X
+ sky130_fd_sc_hd__o221a_2
XFILLER_30_796 VGND VGND VPWR VPWR sky130_fd_sc_hd__decap_3
X_6400_ _7077_/CLK _6400_/D load_slew692/X VGND VGND VPWR VPWR _6400_/Q sky130_fd_sc_hd__dfrtp_2
X_3612_ _3615_/C VGND VGND VPWR VPWR _3753_/A sky130_fd_sc_hd__inv_2
X_4592_ _6879_/Q _4766_/A2 _4592_/B1 _4591_/X VGND VGND VPWR VPWR _4592_/X sky130_fd_sc_hd__a211o_2
X_6331_ clkload7/A _6331_/D load_slew643/X VGND VGND VPWR VPWR _6331_/Q sky130_fd_sc_hd__dfrtp_2
Xhold904 _6100_/Q VGND VGND VPWR VPWR hold904/X sky130_fd_sc_hd__dlygate4sd3_1
X_3543_ _6227_/Q _3631_/A2 _3630_/C1 _6275_/Q _3542_/X VGND VGND VPWR VPWR _3543_/X
+ sky130_fd_sc_hd__a221o_2
Xhold915 _6737_/Q VGND VGND VPWR VPWR hold915/X sky130_fd_sc_hd__dlygate4sd3_1
XTAP_TAPCELL_ROW_77_2199 VGND VPWR sky130_fd_sc_hd__tapvpwrvgnd_1
Xhold926 _6121_/Q VGND VGND VPWR VPWR hold926/X sky130_fd_sc_hd__dlygate4sd3_1
Xhold937 _6095_/Q VGND VGND VPWR VPWR hold937/X sky130_fd_sc_hd__dlygate4sd3_1
Xhold948 _6185_/Q VGND VGND VPWR VPWR hold948/X sky130_fd_sc_hd__dlygate4sd3_1
Xhold959 _6208_/Q VGND VGND VPWR VPWR hold959/X sky130_fd_sc_hd__dlygate4sd3_1
X_6262_ _6882_/CLK _6262_/D load_slew664/X VGND VGND VPWR VPWR _6262_/Q sky130_fd_sc_hd__dfrtp_2
XFILLER_66_1128 VGND VGND VPWR VPWR sky130_fd_sc_hd__decap_3
X_3474_ _6244_/Q _6468_/Q VGND VGND VPWR VPWR _3474_/X sky130_fd_sc_hd__xor2_2
X_5213_ _5213_/A _5213_/B VGND VGND VPWR VPWR _5213_/Y sky130_fd_sc_hd__nand2_2
X_6193_ _7020_/CLK _6193_/D load_slew805/X VGND VGND VPWR VPWR _6193_/Q sky130_fd_sc_hd__dfrtp_2
XTAP_TAPCELL_ROW_36_1140 VGND VPWR sky130_fd_sc_hd__tapvpwrvgnd_1
XFILLER_44_1415 VGND VGND VPWR VPWR sky130_fd_sc_hd__decap_3
Xload_slew840 fanout839/X VGND VGND VPWR VPWR load_slew840/X sky130_fd_sc_hd__buf_2
XFILLER_9_1055 VGND VGND VPWR VPWR sky130_fd_sc_hd__decap_3
X_5144_ _6719_/Q _5213_/A VGND VGND VPWR VPWR _5144_/X sky130_fd_sc_hd__or2_2
XTAP_TAPCELL_ROW_32_1026 VGND VPWR sky130_fd_sc_hd__tapvpwrvgnd_1
XFILLER_44_1459 VGND VGND VPWR VPWR sky130_fd_sc_hd__decap_3
XTAP_TAPCELL_ROW_32_1037 VGND VPWR sky130_fd_sc_hd__tapvpwrvgnd_1
XFILLER_28_29 VGND VGND VPWR VPWR sky130_fd_sc_hd__decap_3
XFILLER_29_329 VGND VGND VPWR VPWR sky130_fd_sc_hd__decap_3
X_5075_ _5075_/A _5075_/B VGND VGND VPWR VPWR _5075_/X sky130_fd_sc_hd__or2_2
XFILLER_56_137 VGND VGND VPWR VPWR sky130_fd_sc_hd__decap_3
X_4026_ _3406_/X _4765_/B2 _4766_/A2 _6900_/Q _4068_/C1 VGND VGND VPWR VPWR _4026_/X
+ sky130_fd_sc_hd__a221o_2
XFILLER_77_1213 VGND VGND VPWR VPWR sky130_fd_sc_hd__decap_3
XFILLER_53_822 VGND VGND VPWR VPWR sky130_fd_sc_hd__decap_3
XFILLER_77_1257 VGND VGND VPWR VPWR sky130_fd_sc_hd__decap_3
XFILLER_64_192 VGND VGND VPWR VPWR sky130_fd_sc_hd__decap_3
XFILLER_25_579 VGND VGND VPWR VPWR sky130_fd_sc_hd__decap_3
XFILLER_52_365 VGND VGND VPWR VPWR sky130_fd_sc_hd__decap_3
X_5977_ _5977_/A0 _6981_/Q _6049_/S VGND VGND VPWR VPWR _5977_/X sky130_fd_sc_hd__mux2_1
XFILLER_52_398 VGND VGND VPWR VPWR sky130_fd_sc_hd__decap_3
X_4928_ _6685_/Q _3051_/Y _5216_/A VGND VGND VPWR VPWR _4928_/X sky130_fd_sc_hd__mux2_1
XFILLER_21_741 VGND VGND VPWR VPWR sky130_fd_sc_hd__decap_3
XFILLER_51_1419 VGND VGND VPWR VPWR sky130_fd_sc_hd__decap_3
XFILLER_21_763 VGND VGND VPWR VPWR sky130_fd_sc_hd__decap_3
XFILLER_60_27 VGND VGND VPWR VPWR sky130_fd_sc_hd__fill_1
X_4859_ _4879_/B _4294_/Y _4858_/Y _4859_/C1 VGND VGND VPWR VPWR _4860_/C sky130_fd_sc_hd__o211ai_2
XFILLER_21_785 VGND VGND VPWR VPWR sky130_fd_sc_hd__decap_3
XFILLER_21_796 VGND VGND VPWR VPWR sky130_fd_sc_hd__fill_1
XFILLER_14_1241 VGND VGND VPWR VPWR sky130_fd_sc_hd__decap_3
XFILLER_10_1105 VGND VGND VPWR VPWR sky130_fd_sc_hd__decap_3
XFILLER_14_1285 VGND VGND VPWR VPWR sky130_fd_sc_hd__decap_3
XFILLER_4_406 VGND VGND VPWR VPWR sky130_fd_sc_hd__decap_3
XFILLER_49_1304 VGND VGND VPWR VPWR sky130_fd_sc_hd__decap_3
X_6529_ _6999_/CLK _6529_/D load_slew786/X VGND VGND VPWR VPWR _6529_/Q sky130_fd_sc_hd__dfrtp_2
XFILLER_10_1138 VGND VGND VPWR VPWR sky130_fd_sc_hd__decap_3
XFILLER_10_1149 VGND VGND VPWR VPWR sky130_fd_sc_hd__decap_3
XFILLER_49_1337 VGND VGND VPWR VPWR sky130_fd_sc_hd__decap_3
XFILLER_49_1348 VGND VGND VPWR VPWR sky130_fd_sc_hd__decap_3
XFILLER_69_36 VGND VGND VPWR VPWR sky130_fd_sc_hd__decap_3
XFILLER_0_601 VGND VGND VPWR VPWR sky130_fd_sc_hd__decap_3
XFILLER_0_634 VGND VGND VPWR VPWR sky130_fd_sc_hd__decap_3
XFILLER_47_1061 VGND VGND VPWR VPWR sky130_fd_sc_hd__decap_3
XPHY_EDGE_ROW_8_Left_89 VGND VGND VPWR VPWR sky130_fd_sc_hd__decap_3
XFILLER_0_645 VGND VGND VPWR VPWR sky130_fd_sc_hd__decap_3
XFILLER_76_903 VGND VGND VPWR VPWR sky130_fd_sc_hd__decap_3
XFILLER_76_925 VGND VGND VPWR VPWR sky130_fd_sc_hd__decap_3
XFILLER_75_402 VGND VGND VPWR VPWR sky130_fd_sc_hd__decap_3
XFILLER_5_1431 VGND VGND VPWR VPWR sky130_fd_sc_hd__decap_3
XFILLER_60_1250 VGND VGND VPWR VPWR sky130_fd_sc_hd__decap_3
XFILLER_76_969 VGND VGND VPWR VPWR sky130_fd_sc_hd__decap_3
XFILLER_75_446 VGND VGND VPWR VPWR sky130_fd_sc_hd__fill_2
XFILLER_29_841 VGND VGND VPWR VPWR sky130_fd_sc_hd__decap_3
XFILLER_47_137 VGND VGND VPWR VPWR sky130_fd_sc_hd__decap_3
XFILLER_60_1261 VGND VGND VPWR VPWR sky130_fd_sc_hd__decap_3
XFILLER_25_1381 VGND VGND VPWR VPWR sky130_fd_sc_hd__decap_3
XFILLER_21_1223 VGND VGND VPWR VPWR sky130_fd_sc_hd__decap_3
XFILLER_21_1245 VGND VGND VPWR VPWR sky130_fd_sc_hd__decap_3
XFILLER_60_1294 VGND VGND VPWR VPWR sky130_fd_sc_hd__decap_3
XFILLER_1_1328 VGND VGND VPWR VPWR sky130_fd_sc_hd__decap_3
XFILLER_16_524 VGND VGND VPWR VPWR sky130_fd_sc_hd__decap_3
XFILLER_21_1278 VGND VGND VPWR VPWR sky130_fd_sc_hd__decap_3
XFILLER_44_833 VGND VGND VPWR VPWR sky130_fd_sc_hd__decap_3
XFILLER_21_1289 VGND VGND VPWR VPWR sky130_fd_sc_hd__decap_3
Xclkbuf_leaf_82_clk clkbuf_leaf_3_clk/A VGND VGND VPWR VPWR _7056_/CLK sky130_fd_sc_hd__clkbuf_8
XFILLER_43_332 VGND VGND VPWR VPWR sky130_fd_sc_hd__decap_3
XFILLER_43_343 VGND VGND VPWR VPWR sky130_fd_sc_hd__decap_3
XFILLER_71_685 VGND VGND VPWR VPWR sky130_fd_sc_hd__decap_3
XFILLER_19_1130 VGND VGND VPWR VPWR sky130_fd_sc_hd__decap_3
XFILLER_58_1190 VGND VGND VPWR VPWR sky130_fd_sc_hd__decap_3
XFILLER_70_184 VGND VGND VPWR VPWR sky130_fd_sc_hd__fill_1
XFILLER_54_1032 VGND VGND VPWR VPWR sky130_fd_sc_hd__decap_3
XFILLER_70_195 VGND VGND VPWR VPWR sky130_fd_sc_hd__fill_1
XFILLER_34_83 VGND VGND VPWR VPWR sky130_fd_sc_hd__fill_1
XFILLER_12_763 VGND VGND VPWR VPWR sky130_fd_sc_hd__decap_3
XFILLER_19_1185 VGND VGND VPWR VPWR sky130_fd_sc_hd__fill_2
XFILLER_7_211 VGND VGND VPWR VPWR sky130_fd_sc_hd__fill_1
XFILLER_79_9 VGND VGND VPWR VPWR sky130_fd_sc_hd__decap_3
XFILLER_7_222 VGND VGND VPWR VPWR sky130_fd_sc_hd__fill_2
XFILLER_71_1390 VGND VGND VPWR VPWR sky130_fd_sc_hd__decap_3
XFILLER_11_284 VGND VGND VPWR VPWR sky130_fd_sc_hd__fill_1
XTAP_TAPCELL_ROW_22_780 VGND VPWR sky130_fd_sc_hd__tapvpwrvgnd_1
XFILLER_32_1341 VGND VGND VPWR VPWR sky130_fd_sc_hd__decap_3
XFILLER_32_1385 VGND VGND VPWR VPWR sky130_fd_sc_hd__decap_3
XFILLER_67_1404 VGND VGND VPWR VPWR sky130_fd_sc_hd__decap_3
XFILLER_67_1437 VGND VGND VPWR VPWR sky130_fd_sc_hd__decap_3
XFILLER_4_962 VGND VGND VPWR VPWR sky130_fd_sc_hd__decap_3
XTAP_TAPCELL_ROW_72_2063 VGND VPWR sky130_fd_sc_hd__tapvpwrvgnd_1
XTAP_TAPCELL_ROW_72_2074 VGND VPWR sky130_fd_sc_hd__tapvpwrvgnd_1
XFILLER_3_483 VGND VGND VPWR VPWR sky130_fd_sc_hd__decap_3
Xload_slew114 _5284_/A2 VGND VGND VPWR VPWR _5260_/A2 sky130_fd_sc_hd__buf_2
XTAP_TAPCELL_ROW_72_2085 VGND VPWR sky130_fd_sc_hd__tapvpwrvgnd_1
Xload_slew125 _5327_/S VGND VGND VPWR VPWR _5333_/S sky130_fd_sc_hd__buf_4
XFILLER_79_741 VGND VGND VPWR VPWR sky130_fd_sc_hd__decap_3
XFILLER_59_80 VGND VGND VPWR VPWR sky130_fd_sc_hd__fill_1
XFILLER_26_1134 VGND VGND VPWR VPWR sky130_fd_sc_hd__decap_3
XFILLER_65_1183 VGND VGND VPWR VPWR sky130_fd_sc_hd__fill_1
XFILLER_67_903 VGND VGND VPWR VPWR sky130_fd_sc_hd__decap_3
X_3190_ _6999_/Q wire419/X _3189_/X VGND VGND VPWR VPWR _3194_/B sky130_fd_sc_hd__a21o_2
XFILLER_6_1217 VGND VGND VPWR VPWR sky130_fd_sc_hd__decap_3
XFILLER_61_1047 VGND VGND VPWR VPWR sky130_fd_sc_hd__decap_3
XFILLER_66_435 VGND VGND VPWR VPWR sky130_fd_sc_hd__decap_3
XFILLER_35_800 VGND VGND VPWR VPWR sky130_fd_sc_hd__decap_3
XFILLER_19_373 VGND VGND VPWR VPWR sky130_fd_sc_hd__decap_3
XFILLER_47_682 VGND VGND VPWR VPWR sky130_fd_sc_hd__decap_3
X_5900_ _5900_/A0 _5900_/A1 _5905_/S VGND VGND VPWR VPWR _6908_/D sky130_fd_sc_hd__mux2_1
Xclkbuf_leaf_73_clk clkbuf_4_8__f_clk/X VGND VGND VPWR VPWR _6982_/CLK sky130_fd_sc_hd__clkbuf_8
X_6880_ _6912_/CLK _6880_/D wire715/X VGND VGND VPWR VPWR _6880_/Q sky130_fd_sc_hd__dfrtp_2
XFILLER_34_332 VGND VGND VPWR VPWR sky130_fd_sc_hd__decap_3
XFILLER_50_803 VGND VGND VPWR VPWR sky130_fd_sc_hd__fill_1
X_5831_ _5858_/A1 _5831_/A1 _5831_/S VGND VGND VPWR VPWR _6849_/D sky130_fd_sc_hd__mux2_1
XFILLER_34_365 VGND VGND VPWR VPWR sky130_fd_sc_hd__decap_3
XFILLER_62_685 VGND VGND VPWR VPWR sky130_fd_sc_hd__fill_2
XFILLER_34_398 VGND VGND VPWR VPWR sky130_fd_sc_hd__decap_3
X_5762_ _5901_/A0 _5762_/A1 _5766_/S VGND VGND VPWR VPWR _6805_/D sky130_fd_sc_hd__mux2_1
XFILLER_72_1132 VGND VGND VPWR VPWR sky130_fd_sc_hd__decap_3
XFILLER_50_869 VGND VGND VPWR VPWR sky130_fd_sc_hd__decap_3
XFILLER_61_195 VGND VGND VPWR VPWR sky130_fd_sc_hd__decap_3
XFILLER_37_1263 VGND VGND VPWR VPWR sky130_fd_sc_hd__decap_3
XFILLER_72_1176 VGND VGND VPWR VPWR sky130_fd_sc_hd__decap_3
X_4713_ _6294_/Q _4832_/A2 _3398_/X _4713_/B2 VGND VGND VPWR VPWR _4713_/X sky130_fd_sc_hd__a22o_2
X_5693_ _5693_/A0 _5932_/A0 _5693_/S VGND VGND VPWR VPWR _6745_/D sky130_fd_sc_hd__mux2_1
XTAP_TAPCELL_ROW_20_717 VGND VPWR sky130_fd_sc_hd__tapvpwrvgnd_1
XTAP_TAPCELL_ROW_20_728 VGND VPWR sky130_fd_sc_hd__tapvpwrvgnd_1
X_4644_ _4586_/B _6549_/Q _4658_/S VGND VGND VPWR VPWR _4644_/X sky130_fd_sc_hd__mux2_1
XFILLER_50_1441 VGND VGND VPWR VPWR sky130_fd_sc_hd__decap_3
XFILLER_11_1425 VGND VGND VPWR VPWR sky130_fd_sc_hd__decap_3
X_4575_ _6323_/Q _4750_/A2 _3360_/X _4773_/B2 VGND VGND VPWR VPWR _4575_/X sky130_fd_sc_hd__a22o_2
X_6314_ _7015_/CLK _6314_/D fanout804/X VGND VGND VPWR VPWR _6314_/Q sky130_fd_sc_hd__dfrtp_2
X_3526_ _6302_/Q _3533_/B1 _5606_/A2 _6310_/Q _3525_/X VGND VGND VPWR VPWR _3526_/X
+ sky130_fd_sc_hd__a221o_2
X_6245_ _7060_/CLK _6245_/D load_slew782/X VGND VGND VPWR VPWR _6245_/Q sky130_fd_sc_hd__dfrtp_2
X_3457_ _6049_/A0 _3456_/X _3457_/S VGND VGND VPWR VPWR _6202_/D sky130_fd_sc_hd__mux2_1
X_6176_ _7027_/CLK _6176_/D load_slew845/X VGND VGND VPWR VPWR _6176_/Q sky130_fd_sc_hd__dfrtp_2
XFILLER_44_1234 VGND VGND VPWR VPWR sky130_fd_sc_hd__decap_3
X_3388_ _6313_/Q _6425_/Q VGND VGND VPWR VPWR _3388_/X sky130_fd_sc_hd__xor2_2
XFILLER_58_925 VGND VGND VPWR VPWR sky130_fd_sc_hd__fill_1
Xhold1401 _6568_/Q VGND VGND VPWR VPWR _5456_/A1 sky130_fd_sc_hd__dlygate4sd3_1
XFILLER_57_402 VGND VGND VPWR VPWR sky130_fd_sc_hd__decap_3
XFILLER_44_1267 VGND VGND VPWR VPWR sky130_fd_sc_hd__decap_3
X_5127_ _6471_/Q _5127_/B VGND VGND VPWR VPWR _5128_/B sky130_fd_sc_hd__xnor2_2
Xhold1412 _6767_/Q VGND VGND VPWR VPWR _5719_/A1 sky130_fd_sc_hd__dlygate4sd3_1
Xload_slew681 fanout680/X VGND VGND VPWR VPWR load_slew681/X sky130_fd_sc_hd__clkbuf_4
Xhold1423 _6849_/Q VGND VGND VPWR VPWR _5831_/A1 sky130_fd_sc_hd__dlygate4sd3_1
Xhold1434 _6886_/Q VGND VGND VPWR VPWR _5875_/A1 sky130_fd_sc_hd__dlygate4sd3_1
Xload_slew692 fanout691/X VGND VGND VPWR VPWR load_slew692/X sky130_fd_sc_hd__clkbuf_4
XFILLER_69_295 VGND VGND VPWR VPWR sky130_fd_sc_hd__decap_3
Xhold1445 _6596_/Q VGND VGND VPWR VPWR _5484_/A1 sky130_fd_sc_hd__dlygate4sd3_1
XFILLER_73_906 VGND VGND VPWR VPWR sky130_fd_sc_hd__decap_3
XPHY_EDGE_ROW_2_Right_2 VGND VGND VPWR VPWR sky130_fd_sc_hd__decap_3
Xhold1456 _6514_/Q VGND VGND VPWR VPWR _5402_/A1 sky130_fd_sc_hd__dlygate4sd3_1
XFILLER_79_1319 VGND VGND VPWR VPWR sky130_fd_sc_hd__decap_3
XFILLER_73_928 VGND VGND VPWR VPWR sky130_fd_sc_hd__fill_1
Xhold1467 _6593_/Q VGND VGND VPWR VPWR _5481_/A1 sky130_fd_sc_hd__dlygate4sd3_1
X_5058_ _6398_/Q _5264_/B VGND VGND VPWR VPWR _5058_/X sky130_fd_sc_hd__or2_2
Xhold1478 _6743_/Q VGND VGND VPWR VPWR _5691_/A0 sky130_fd_sc_hd__dlygate4sd3_1
Xhold1489 _6585_/Q VGND VGND VPWR VPWR _5473_/A1 sky130_fd_sc_hd__dlygate4sd3_1
XFILLER_72_427 VGND VGND VPWR VPWR sky130_fd_sc_hd__decap_3
X_4009_ _3711_/Y _3717_/A _4008_/Y _6560_/Q _4061_/A1 VGND VGND VPWR VPWR _4013_/B
+ sky130_fd_sc_hd__a221o_2
XFILLER_25_310 VGND VGND VPWR VPWR sky130_fd_sc_hd__fill_2
XFILLER_26_844 VGND VGND VPWR VPWR sky130_fd_sc_hd__decap_3
XTAP_TAPCELL_ROW_68_1965 VGND VPWR sky130_fd_sc_hd__tapvpwrvgnd_1
Xclkbuf_leaf_64_clk clkbuf_leaf_67_clk/A VGND VGND VPWR VPWR _7015_/CLK sky130_fd_sc_hd__clkbuf_8
XFILLER_37_192 VGND VGND VPWR VPWR sky130_fd_sc_hd__fill_2
XTAP_TAPCELL_ROW_68_1976 VGND VPWR sky130_fd_sc_hd__tapvpwrvgnd_1
XFILLER_77_1065 VGND VGND VPWR VPWR sky130_fd_sc_hd__decap_3
XFILLER_26_877 VGND VGND VPWR VPWR sky130_fd_sc_hd__decap_3
XFILLER_80_460 VGND VGND VPWR VPWR sky130_fd_sc_hd__decap_3
XFILLER_13_505 VGND VGND VPWR VPWR sky130_fd_sc_hd__decap_3
XFILLER_25_376 VGND VGND VPWR VPWR sky130_fd_sc_hd__decap_3
XFILLER_41_825 VGND VGND VPWR VPWR sky130_fd_sc_hd__fill_2
XFILLER_77_1098 VGND VGND VPWR VPWR sky130_fd_sc_hd__decap_3
XFILLER_71_15 VGND VGND VPWR VPWR sky130_fd_sc_hd__decap_3
XFILLER_38_1049 VGND VGND VPWR VPWR sky130_fd_sc_hd__decap_3
XFILLER_53_696 VGND VGND VPWR VPWR sky130_fd_sc_hd__decap_3
XFILLER_0_1394 VGND VGND VPWR VPWR sky130_fd_sc_hd__decap_3
XFILLER_40_324 VGND VGND VPWR VPWR sky130_fd_sc_hd__decap_3
XFILLER_52_184 VGND VGND VPWR VPWR sky130_fd_sc_hd__decap_3
XFILLER_41_858 VGND VGND VPWR VPWR sky130_fd_sc_hd__decap_3
XFILLER_71_48 VGND VGND VPWR VPWR sky130_fd_sc_hd__decap_3
XFILLER_16_1303 VGND VGND VPWR VPWR sky130_fd_sc_hd__decap_3
XFILLER_55_1363 VGND VGND VPWR VPWR sky130_fd_sc_hd__decap_3
XFILLER_51_1205 VGND VGND VPWR VPWR sky130_fd_sc_hd__decap_3
XFILLER_16_1347 VGND VGND VPWR VPWR sky130_fd_sc_hd__decap_3
XFILLER_55_1396 VGND VGND VPWR VPWR sky130_fd_sc_hd__decap_3
XFILLER_5_748 VGND VGND VPWR VPWR sky130_fd_sc_hd__decap_3
XFILLER_20_52 VGND VGND VPWR VPWR sky130_fd_sc_hd__decap_3
XFILLER_1_921 VGND VGND VPWR VPWR sky130_fd_sc_hd__decap_3
XFILLER_45_1009 VGND VGND VPWR VPWR sky130_fd_sc_hd__decap_3
XFILLER_27_1410 VGND VGND VPWR VPWR sky130_fd_sc_hd__decap_3
XFILLER_62_1312 VGND VGND VPWR VPWR sky130_fd_sc_hd__decap_3
XFILLER_1_965 VGND VGND VPWR VPWR sky130_fd_sc_hd__decap_3
XFILLER_62_1323 VGND VGND VPWR VPWR sky130_fd_sc_hd__decap_3
XFILLER_0_442 VGND VGND VPWR VPWR sky130_fd_sc_hd__decap_3
XFILLER_27_1443 VGND VGND VPWR VPWR sky130_fd_sc_hd__decap_3
XFILLER_0_464 VGND VGND VPWR VPWR sky130_fd_sc_hd__decap_3
XFILLER_48_402 VGND VGND VPWR VPWR sky130_fd_sc_hd__decap_3
XFILLER_1_998 VGND VGND VPWR VPWR sky130_fd_sc_hd__decap_3
XFILLER_23_1307 VGND VGND VPWR VPWR sky130_fd_sc_hd__decap_3
XFILLER_62_1356 VGND VGND VPWR VPWR sky130_fd_sc_hd__decap_3
XFILLER_0_486 VGND VGND VPWR VPWR sky130_fd_sc_hd__decap_3
XFILLER_48_424 VGND VGND VPWR VPWR sky130_fd_sc_hd__decap_3
XFILLER_48_468 VGND VGND VPWR VPWR sky130_fd_sc_hd__decap_3
XFILLER_17_800 VGND VGND VPWR VPWR sky130_fd_sc_hd__decap_3
XFILLER_21_1031 VGND VGND VPWR VPWR sky130_fd_sc_hd__fill_1
XFILLER_5_1272 VGND VGND VPWR VPWR sky130_fd_sc_hd__decap_3
XTAP_TAPCELL_ROW_3_280 VGND VPWR sky130_fd_sc_hd__tapvpwrvgnd_1
XTAP_TAPCELL_ROW_3_291 VGND VPWR sky130_fd_sc_hd__tapvpwrvgnd_1
XFILLER_1_1136 VGND VGND VPWR VPWR sky130_fd_sc_hd__decap_3
XFILLER_16_321 VGND VGND VPWR VPWR sky130_fd_sc_hd__decap_3
XFILLER_63_449 VGND VGND VPWR VPWR sky130_fd_sc_hd__fill_2
XFILLER_28_181 VGND VGND VPWR VPWR sky130_fd_sc_hd__decap_3
Xclkbuf_leaf_55_clk clkbuf_leaf_56_clk/A VGND VGND VPWR VPWR _6847_/CLK sky130_fd_sc_hd__clkbuf_8
XFILLER_28_192 VGND VGND VPWR VPWR sky130_fd_sc_hd__decap_3
XTAP_TAPCELL_ROW_80_2310 VGND VPWR sky130_fd_sc_hd__tapvpwrvgnd_1
XFILLER_1_1169 VGND VGND VPWR VPWR sky130_fd_sc_hd__decap_3
XFILLER_56_1105 VGND VGND VPWR VPWR sky130_fd_sc_hd__fill_2
XFILLER_16_354 VGND VGND VPWR VPWR sky130_fd_sc_hd__decap_3
XFILLER_17_888 VGND VGND VPWR VPWR sky130_fd_sc_hd__decap_3
XFILLER_31_313 VGND VGND VPWR VPWR sky130_fd_sc_hd__decap_3
XTAP_TAPCELL_ROW_27_894 VGND VPWR sky130_fd_sc_hd__tapvpwrvgnd_1
XFILLER_73_1452 VGND VGND VPWR VPWR sky130_fd_sc_hd__decap_3
XFILLER_32_869 VGND VGND VPWR VPWR sky130_fd_sc_hd__decap_3
XFILLER_34_1403 VGND VGND VPWR VPWR sky130_fd_sc_hd__decap_3
XFILLER_73_1463 VGND VGND VPWR VPWR sky130_fd_sc_hd__decap_3
XTAP_TAPCELL_ROW_14_555 VGND VPWR sky130_fd_sc_hd__tapvpwrvgnd_1
XTAP_TAPCELL_ROW_14_566 VGND VPWR sky130_fd_sc_hd__tapvpwrvgnd_1
XTAP_TAPCELL_ROW_14_577 VGND VPWR sky130_fd_sc_hd__tapvpwrvgnd_1
XFILLER_34_1447 VGND VGND VPWR VPWR sky130_fd_sc_hd__decap_3
XFILLER_8_542 VGND VGND VPWR VPWR sky130_fd_sc_hd__decap_3
XFILLER_77_6 VGND VGND VPWR VPWR sky130_fd_sc_hd__decap_3
XFILLER_8_575 VGND VGND VPWR VPWR sky130_fd_sc_hd__decap_3
XFILLER_6_21 VGND VGND VPWR VPWR sky130_fd_sc_hd__decap_3
XTAP_TAPCELL_ROW_74_2114 VGND VPWR sky130_fd_sc_hd__tapvpwrvgnd_1
XFILLER_6_32 VGND VGND VPWR VPWR sky130_fd_sc_hd__decap_3
XANTENNA_3 _3085_/Y VGND VGND VPWR VPWR sky130_fd_sc_hd__diode_2
XTAP_TAPCELL_ROW_74_2125 VGND VPWR sky130_fd_sc_hd__tapvpwrvgnd_1
XFILLER_32_1193 VGND VGND VPWR VPWR sky130_fd_sc_hd__decap_3
XFILLER_67_1201 VGND VGND VPWR VPWR sky130_fd_sc_hd__decap_3
XTAP_TAPCELL_ROW_74_2136 VGND VPWR sky130_fd_sc_hd__tapvpwrvgnd_1
X_4360_ _4403_/A _4420_/C _4723_/C VGND VGND VPWR VPWR _4360_/X sky130_fd_sc_hd__or3_2
XFILLER_67_1245 VGND VGND VPWR VPWR sky130_fd_sc_hd__decap_3
X_3311_ _3311_/A0 _3310_/X _3455_/S VGND VGND VPWR VPWR _6129_/D sky130_fd_sc_hd__mux2_1
XFILLER_4_781 VGND VGND VPWR VPWR sky130_fd_sc_hd__decap_3
X_4291_ _4291_/A _4291_/B VGND VGND VPWR VPWR _4294_/A sky130_fd_sc_hd__xnor2_2
XFILLER_67_1278 VGND VGND VPWR VPWR sky130_fd_sc_hd__decap_3
XFILLER_67_1289 VGND VGND VPWR VPWR sky130_fd_sc_hd__decap_3
XFILLER_80_1401 VGND VGND VPWR VPWR sky130_fd_sc_hd__decap_3
X_6030_ hold907/X _7034_/Q _6033_/S VGND VGND VPWR VPWR _6030_/X sky130_fd_sc_hd__mux2_1
X_3242_ _6256_/Q _6352_/Q VGND VGND VPWR VPWR _3242_/X sky130_fd_sc_hd__xor2_2
XFILLER_6_1014 VGND VGND VPWR VPWR sky130_fd_sc_hd__fill_1
XFILLER_41_1407 VGND VGND VPWR VPWR sky130_fd_sc_hd__decap_3
X_3173_ _7006_/Q _3219_/B2 _3180_/A1 _3172_/X VGND VGND VPWR VPWR _3173_/X sky130_fd_sc_hd__a22o_2
XFILLER_66_232 VGND VGND VPWR VPWR sky130_fd_sc_hd__decap_3
XTAP_TAPCELL_ROW_1_217 VGND VPWR sky130_fd_sc_hd__tapvpwrvgnd_1
XFILLER_54_405 VGND VGND VPWR VPWR sky130_fd_sc_hd__fill_1
XFILLER_67_788 VGND VGND VPWR VPWR sky130_fd_sc_hd__decap_3
XTAP_TAPCELL_ROW_1_228 VGND VPWR sky130_fd_sc_hd__tapvpwrvgnd_1
XTAP_TAPCELL_ROW_1_239 VGND VPWR sky130_fd_sc_hd__tapvpwrvgnd_1
XTAP_TAPCELL_ROW_50_1490 VGND VPWR sky130_fd_sc_hd__tapvpwrvgnd_1
XFILLER_54_427 VGND VGND VPWR VPWR sky130_fd_sc_hd__decap_3
XFILLER_78_1341 VGND VGND VPWR VPWR sky130_fd_sc_hd__decap_3
X_6932_ _7060_/CLK _6932_/D load_slew782/X VGND VGND VPWR VPWR _6932_/Q sky130_fd_sc_hd__dfrtp_2
Xclkbuf_leaf_46_clk clkbuf_leaf_47_clk/A VGND VGND VPWR VPWR _7027_/CLK sky130_fd_sc_hd__clkbuf_8
XFILLER_74_1205 VGND VGND VPWR VPWR sky130_fd_sc_hd__decap_3
XFILLER_39_1325 VGND VGND VPWR VPWR sky130_fd_sc_hd__decap_3
XFILLER_78_1385 VGND VGND VPWR VPWR sky130_fd_sc_hd__decap_3
X_6863_ _6863_/CLK _6863_/D fanout791/A VGND VGND VPWR VPWR _6863_/Q sky130_fd_sc_hd__dfrtp_2
XFILLER_50_600 VGND VGND VPWR VPWR sky130_fd_sc_hd__decap_3
XFILLER_63_983 VGND VGND VPWR VPWR sky130_fd_sc_hd__fill_2
XFILLER_74_1238 VGND VGND VPWR VPWR sky130_fd_sc_hd__decap_3
XFILLER_35_685 VGND VGND VPWR VPWR sky130_fd_sc_hd__decap_3
XFILLER_62_471 VGND VGND VPWR VPWR sky130_fd_sc_hd__decap_3
XFILLER_39_1369 VGND VGND VPWR VPWR sky130_fd_sc_hd__decap_3
XFILLER_34_184 VGND VGND VPWR VPWR sky130_fd_sc_hd__decap_3
X_5814_ _6069_/S _5879_/A _5841_/C _5906_/B VGND VGND VPWR VPWR _5822_/S sky130_fd_sc_hd__and4bb_2
XTAP_TAPCELL_ROW_63_1840 VGND VPWR sky130_fd_sc_hd__tapvpwrvgnd_1
X_6794_ _6858_/CLK _6794_/D wire652/X VGND VGND VPWR VPWR _6794_/Q sky130_fd_sc_hd__dfrtp_2
XTAP_TAPCELL_ROW_63_1851 VGND VPWR sky130_fd_sc_hd__tapvpwrvgnd_1
XFILLER_10_519 VGND VGND VPWR VPWR sky130_fd_sc_hd__decap_3
X_5745_ _5911_/A0 _5745_/A1 _5748_/S VGND VGND VPWR VPWR _6790_/D sky130_fd_sc_hd__mux2_1
XFILLER_41_18 VGND VGND VPWR VPWR sky130_fd_sc_hd__fill_1
X_5676_ _7066_/Q _5722_/A _5740_/C _5685_/C VGND VGND VPWR VPWR wire90/A sky130_fd_sc_hd__and4_2
XFILLER_11_1222 VGND VGND VPWR VPWR sky130_fd_sc_hd__decap_3
XFILLER_11_1233 VGND VGND VPWR VPWR sky130_fd_sc_hd__decap_3
X_4627_ _6258_/Q _4861_/A2 _3374_/X _4861_/B2 VGND VGND VPWR VPWR _4627_/X sky130_fd_sc_hd__a22o_2
XFILLER_50_1282 VGND VGND VPWR VPWR sky130_fd_sc_hd__decap_3
XFILLER_11_1266 VGND VGND VPWR VPWR sky130_fd_sc_hd__decap_3
XFILLER_2_707 VGND VGND VPWR VPWR sky130_fd_sc_hd__decap_3
X_4558_ _4558_/A _4558_/B _4558_/C VGND VGND VPWR VPWR _4558_/X sky130_fd_sc_hd__and3_2
XFILLER_9_9 VGND VGND VPWR VPWR sky130_fd_sc_hd__decap_3
XFILLER_1_217 VGND VGND VPWR VPWR sky130_fd_sc_hd__decap_3
XFILLER_1_228 VGND VGND VPWR VPWR sky130_fd_sc_hd__decap_3
X_3509_ _6324_/Q _6332_/Q _6340_/Q _6244_/Q _4394_/B _4420_/A VGND VGND VPWR VPWR
+ _3509_/X sky130_fd_sc_hd__mux4_2
XTAP_TAPCELL_ROW_57_1677 VGND VPWR sky130_fd_sc_hd__tapvpwrvgnd_1
X_4489_ _4541_/A _4844_/B VGND VGND VPWR VPWR _4489_/Y sky130_fd_sc_hd__nor2_2
XFILLER_46_1329 VGND VGND VPWR VPWR sky130_fd_sc_hd__decap_3
XTAP_TAPCELL_ROW_57_1688 VGND VPWR sky130_fd_sc_hd__tapvpwrvgnd_1
XFILLER_44_1020 VGND VGND VPWR VPWR sky130_fd_sc_hd__decap_3
X_6228_ _7001_/CLK _6228_/D fanout772/X VGND VGND VPWR VPWR _6228_/Q sky130_fd_sc_hd__dfrtp_2
XFILLER_66_15 VGND VGND VPWR VPWR sky130_fd_sc_hd__decap_3
X_6159_ _6986_/CLK _6159_/D fanout647/X VGND VGND VPWR VPWR _6159_/Q sky130_fd_sc_hd__dfrtp_2
XFILLER_44_1064 VGND VGND VPWR VPWR sky130_fd_sc_hd__fill_1
XFILLER_57_210 VGND VGND VPWR VPWR sky130_fd_sc_hd__decap_3
Xhold1220 _6876_/Q VGND VGND VPWR VPWR _5862_/A0 sky130_fd_sc_hd__dlygate4sd3_1
XFILLER_57_221 VGND VGND VPWR VPWR sky130_fd_sc_hd__decap_3
Xhold1231 _6806_/Q VGND VGND VPWR VPWR _5763_/A1 sky130_fd_sc_hd__dlygate4sd3_1
XFILLER_66_59 VGND VGND VPWR VPWR sky130_fd_sc_hd__decap_3
Xhold1242 _6794_/Q VGND VGND VPWR VPWR _5750_/A1 sky130_fd_sc_hd__dlygate4sd3_1
XFILLER_58_777 VGND VGND VPWR VPWR sky130_fd_sc_hd__fill_1
Xhold1253 _6859_/Q VGND VGND VPWR VPWR _5843_/A0 sky130_fd_sc_hd__dlygate4sd3_1
XFILLER_45_405 VGND VGND VPWR VPWR sky130_fd_sc_hd__fill_1
XFILLER_79_1127 VGND VGND VPWR VPWR sky130_fd_sc_hd__decap_3
Xhold1264 _7055_/Q VGND VGND VPWR VPWR _6051_/A1 sky130_fd_sc_hd__dlygate4sd3_1
XFILLER_2_1412 VGND VGND VPWR VPWR sky130_fd_sc_hd__decap_3
Xhold1275 _6807_/Q VGND VGND VPWR VPWR _5764_/A1 sky130_fd_sc_hd__dlygate4sd3_1
XFILLER_22_1362 VGND VGND VPWR VPWR sky130_fd_sc_hd__decap_3
XFILLER_45_427 VGND VGND VPWR VPWR sky130_fd_sc_hd__decap_3
Xhold1286 _6592_/Q VGND VGND VPWR VPWR _5480_/A1 sky130_fd_sc_hd__dlygate4sd3_1
XFILLER_73_758 VGND VGND VPWR VPWR sky130_fd_sc_hd__decap_3
Xhold1297 _6900_/Q VGND VGND VPWR VPWR _5891_/A1 sky130_fd_sc_hd__dlygate4sd3_1
XFILLER_22_1373 VGND VGND VPWR VPWR sky130_fd_sc_hd__decap_3
XFILLER_45_449 VGND VGND VPWR VPWR sky130_fd_sc_hd__fill_1
XFILLER_2_1456 VGND VGND VPWR VPWR sky130_fd_sc_hd__decap_3
XFILLER_61_909 VGND VGND VPWR VPWR sky130_fd_sc_hd__fill_1
XFILLER_54_950 VGND VGND VPWR VPWR sky130_fd_sc_hd__decap_3
Xclkbuf_leaf_37_clk clkbuf_leaf_56_clk/A VGND VGND VPWR VPWR _6910_/CLK sky130_fd_sc_hd__clkbuf_8
XFILLER_57_1425 VGND VGND VPWR VPWR sky130_fd_sc_hd__decap_3
XFILLER_18_1409 VGND VGND VPWR VPWR sky130_fd_sc_hd__decap_3
XTAP_TAPCELL_ROW_24_820 VGND VPWR sky130_fd_sc_hd__tapvpwrvgnd_1
XFILLER_0_1180 VGND VGND VPWR VPWR sky130_fd_sc_hd__decap_3
XTAP_TAPCELL_ROW_24_831 VGND VPWR sky130_fd_sc_hd__tapvpwrvgnd_1
XFILLER_41_644 VGND VGND VPWR VPWR sky130_fd_sc_hd__decap_3
XFILLER_15_74 VGND VGND VPWR VPWR sky130_fd_sc_hd__decap_3
XFILLER_16_1166 VGND VGND VPWR VPWR sky130_fd_sc_hd__fill_1
XFILLER_5_523 VGND VGND VPWR VPWR sky130_fd_sc_hd__decap_3
XFILLER_5_567 VGND VGND VPWR VPWR sky130_fd_sc_hd__decap_3
XFILLER_64_1418 VGND VGND VPWR VPWR sky130_fd_sc_hd__decap_3
XFILLER_64_1429 VGND VGND VPWR VPWR sky130_fd_sc_hd__decap_3
XFILLER_7_1301 VGND VGND VPWR VPWR sky130_fd_sc_hd__decap_3
XFILLER_1_762 VGND VGND VPWR VPWR sky130_fd_sc_hd__decap_3
XFILLER_27_1251 VGND VGND VPWR VPWR sky130_fd_sc_hd__decap_3
XFILLER_7_1334 VGND VGND VPWR VPWR sky130_fd_sc_hd__decap_3
XFILLER_7_1345 VGND VGND VPWR VPWR sky130_fd_sc_hd__decap_3
XFILLER_27_1284 VGND VGND VPWR VPWR sky130_fd_sc_hd__decap_3
XFILLER_49_744 VGND VGND VPWR VPWR sky130_fd_sc_hd__decap_3
XFILLER_27_1295 VGND VGND VPWR VPWR sky130_fd_sc_hd__decap_3
XFILLER_48_232 VGND VGND VPWR VPWR sky130_fd_sc_hd__decap_3
XFILLER_62_1175 VGND VGND VPWR VPWR sky130_fd_sc_hd__fill_2
XFILLER_37_906 VGND VGND VPWR VPWR sky130_fd_sc_hd__decap_3
XFILLER_7_1378 VGND VGND VPWR VPWR sky130_fd_sc_hd__decap_3
XFILLER_76_585 VGND VGND VPWR VPWR sky130_fd_sc_hd__decap_3
XFILLER_49_799 VGND VGND VPWR VPWR sky130_fd_sc_hd__decap_3
XFILLER_40_1462 VGND VGND VPWR VPWR sky130_fd_sc_hd__decap_3
XFILLER_5_1080 VGND VGND VPWR VPWR sky130_fd_sc_hd__decap_3
XFILLER_36_449 VGND VGND VPWR VPWR sky130_fd_sc_hd__fill_1
Xclkbuf_leaf_28_clk clkload3/A VGND VGND VPWR VPWR _7065_/CLK sky130_fd_sc_hd__clkbuf_8
XFILLER_17_641 VGND VGND VPWR VPWR sky130_fd_sc_hd__decap_3
XFILLER_45_950 VGND VGND VPWR VPWR sky130_fd_sc_hd__fill_2
XFILLER_44_471 VGND VGND VPWR VPWR sky130_fd_sc_hd__decap_3
XFILLER_16_184 VGND VGND VPWR VPWR sky130_fd_sc_hd__decap_3
X_3860_ _6340_/Q _4872_/A _3858_/X _3859_/X VGND VGND VPWR VPWR _4326_/A sky130_fd_sc_hd__o22a_2
XFILLER_31_143 VGND VGND VPWR VPWR sky130_fd_sc_hd__fill_1
XFILLER_73_1260 VGND VGND VPWR VPWR sky130_fd_sc_hd__decap_3
XFILLER_60_997 VGND VGND VPWR VPWR sky130_fd_sc_hd__fill_2
X_3791_ _3791_/A _3791_/B VGND VGND VPWR VPWR _3793_/A sky130_fd_sc_hd__nor2_2
XFILLER_38_1391 VGND VGND VPWR VPWR sky130_fd_sc_hd__decap_3
XFILLER_34_1233 VGND VGND VPWR VPWR sky130_fd_sc_hd__decap_3
XFILLER_13_891 VGND VGND VPWR VPWR sky130_fd_sc_hd__decap_3
X_5530_ _6613_/Q _6617_/Q VGND VGND VPWR VPWR _5530_/X sky130_fd_sc_hd__or2_2
XFILLER_75_3 VGND VGND VPWR VPWR sky130_fd_sc_hd__decap_3
XFILLER_34_1288 VGND VGND VPWR VPWR sky130_fd_sc_hd__decap_3
XFILLER_9_895 VGND VGND VPWR VPWR sky130_fd_sc_hd__fill_1
XFILLER_69_1307 VGND VGND VPWR VPWR sky130_fd_sc_hd__decap_3
X_5461_ _5461_/A1 _5461_/A2 _4764_/X VGND VGND VPWR VPWR _6573_/D sky130_fd_sc_hd__a21o_2
X_4412_ _4783_/A _4768_/B _4768_/C _4360_/X _6510_/Q VGND VGND VPWR VPWR _4412_/X
+ sky130_fd_sc_hd__a32o_2
X_5392_ _5392_/A1 _5456_/A2 _4364_/X VGND VGND VPWR VPWR _6504_/D sky130_fd_sc_hd__a21o_2
XFILLER_67_1042 VGND VGND VPWR VPWR sky130_fd_sc_hd__decap_3
X_4343_ _6270_/Q wire52/X _4340_/X _4342_/X VGND VGND VPWR VPWR _6270_/D sky130_fd_sc_hd__o22a_2
XFILLER_28_1037 VGND VGND VPWR VPWR sky130_fd_sc_hd__fill_2
Xfanout307 _3108_/Y VGND VGND VPWR VPWR _3213_/A1 sky130_fd_sc_hd__clkdlybuf4s25_1
X_7062_ _7063_/CLK _7062_/D fanout776/X VGND VGND VPWR VPWR _7062_/Q sky130_fd_sc_hd__dfrtp_2
Xfanout318 _4319_/A2 VGND VGND VPWR VPWR _4330_/A2 sky130_fd_sc_hd__clkdlybuf4s25_1
X_4274_ _6336_/Q _4868_/A2 _3258_/X _4789_/B2 VGND VGND VPWR VPWR _4274_/X sky130_fd_sc_hd__a22o_2
Xfanout329 wire331/X VGND VGND VPWR VPWR _5566_/B2 sky130_fd_sc_hd__clkdlybuf4s25_1
XFILLER_80_1220 VGND VGND VPWR VPWR sky130_fd_sc_hd__decap_3
XFILLER_45_1340 VGND VGND VPWR VPWR sky130_fd_sc_hd__decap_3
XFILLER_45_1351 VGND VGND VPWR VPWR sky130_fd_sc_hd__decap_3
XFILLER_80_1242 VGND VGND VPWR VPWR sky130_fd_sc_hd__decap_3
X_6013_ hold887/X hold933/X _6021_/S VGND VGND VPWR VPWR _7017_/D sky130_fd_sc_hd__mux2_1
XTAP_TAPCELL_ROW_52_1541 VGND VPWR sky130_fd_sc_hd__tapvpwrvgnd_1
X_3225_ _7065_/Q _3224_/X _3225_/S VGND VGND VPWR VPWR wire28/A sky130_fd_sc_hd__mux2_1
XFILLER_39_210 VGND VGND VPWR VPWR sky130_fd_sc_hd__decap_3
XTAP_TAPCELL_ROW_52_1552 VGND VPWR sky130_fd_sc_hd__tapvpwrvgnd_1
XTAP_TAPCELL_ROW_52_1563 VGND VPWR sky130_fd_sc_hd__tapvpwrvgnd_1
XFILLER_80_1264 VGND VGND VPWR VPWR sky130_fd_sc_hd__decap_3
XFILLER_45_1384 VGND VGND VPWR VPWR sky130_fd_sc_hd__decap_3
XFILLER_67_541 VGND VGND VPWR VPWR sky130_fd_sc_hd__decap_3
XFILLER_39_243 VGND VGND VPWR VPWR sky130_fd_sc_hd__decap_3
XFILLER_41_1248 VGND VGND VPWR VPWR sky130_fd_sc_hd__decap_3
XFILLER_55_703 VGND VGND VPWR VPWR sky130_fd_sc_hd__decap_3
XFILLER_27_405 VGND VGND VPWR VPWR sky130_fd_sc_hd__decap_3
X_3156_ _6076_/A1 _3154_/X _3155_/X _3213_/C1 VGND VGND VPWR VPWR _3160_/B sky130_fd_sc_hd__a211o_2
XFILLER_36_29 VGND VGND VPWR VPWR sky130_fd_sc_hd__fill_1
XFILLER_39_287 VGND VGND VPWR VPWR sky130_fd_sc_hd__decap_3
XFILLER_27_449 VGND VGND VPWR VPWR sky130_fd_sc_hd__decap_3
X_3087_ _4608_/B _3957_/B VGND VGND VPWR VPWR _3087_/Y sky130_fd_sc_hd__nor2_2
Xclkbuf_leaf_19_clk clkload2/A VGND VGND VPWR VPWR _7077_/CLK sky130_fd_sc_hd__clkbuf_8
XTAP_TAPCELL_ROW_65_1902 VGND VPWR sky130_fd_sc_hd__tapvpwrvgnd_1
X_6915_ _7011_/CLK _6915_/D fanout811/X VGND VGND VPWR VPWR _6915_/Q sky130_fd_sc_hd__dfrtp_2
XFILLER_78_1182 VGND VGND VPWR VPWR sky130_fd_sc_hd__decap_3
XFILLER_63_780 VGND VGND VPWR VPWR sky130_fd_sc_hd__decap_3
XFILLER_63_791 VGND VGND VPWR VPWR sky130_fd_sc_hd__decap_3
XTAP_TAPCELL_ROW_18_680 VGND VPWR sky130_fd_sc_hd__tapvpwrvgnd_1
XFILLER_74_1046 VGND VGND VPWR VPWR sky130_fd_sc_hd__fill_1
X_6846_ _6974_/CLK _6846_/D fanout779/A VGND VGND VPWR VPWR _6846_/Q sky130_fd_sc_hd__dfrtp_2
XFILLER_39_1177 VGND VGND VPWR VPWR sky130_fd_sc_hd__decap_3
XFILLER_74_1079 VGND VGND VPWR VPWR sky130_fd_sc_hd__decap_3
XTAP_TAPCELL_ROW_46_1389 VGND VPWR sky130_fd_sc_hd__tapvpwrvgnd_1
XFILLER_51_986 VGND VGND VPWR VPWR sky130_fd_sc_hd__decap_3
XFILLER_52_1300 VGND VGND VPWR VPWR sky130_fd_sc_hd__decap_3
XFILLER_11_828 VGND VGND VPWR VPWR sky130_fd_sc_hd__decap_3
XFILLER_17_1431 VGND VGND VPWR VPWR sky130_fd_sc_hd__decap_3
XFILLER_10_305 VGND VGND VPWR VPWR sky130_fd_sc_hd__decap_3
X_6777_ _7065_/CLK _6777_/D load_slew736/X VGND VGND VPWR VPWR _6777_/Q sky130_fd_sc_hd__dfrtp_2
XFILLER_23_699 VGND VGND VPWR VPWR sky130_fd_sc_hd__fill_1
X_3989_ _6228_/Q wire77/A _3987_/X _3988_/X VGND VGND VPWR VPWR _6228_/D sky130_fd_sc_hd__o22a_2
XFILLER_10_338 VGND VGND VPWR VPWR sky130_fd_sc_hd__decap_3
XFILLER_52_1344 VGND VGND VPWR VPWR sky130_fd_sc_hd__decap_3
X_5728_ _5903_/A0 _5728_/A1 _5730_/S VGND VGND VPWR VPWR _6775_/D sky130_fd_sc_hd__mux2_1
XFILLER_13_1328 VGND VGND VPWR VPWR sky130_fd_sc_hd__decap_3
XFILLER_6_309 VGND VGND VPWR VPWR sky130_fd_sc_hd__fill_1
XFILLER_52_1388 VGND VGND VPWR VPWR sky130_fd_sc_hd__decap_3
X_5659_ _5784_/C _5659_/A1 _5665_/S VGND VGND VPWR VPWR _6714_/D sky130_fd_sc_hd__mux2_1
XTAP_TAPCELL_ROW_59_1728 VGND VPWR sky130_fd_sc_hd__tapvpwrvgnd_1
XTAP_TAPCELL_ROW_59_1739 VGND VPWR sky130_fd_sc_hd__tapvpwrvgnd_1
XFILLER_2_515 VGND VGND VPWR VPWR sky130_fd_sc_hd__decap_3
XFILLER_11_1096 VGND VGND VPWR VPWR sky130_fd_sc_hd__decap_3
XFILLER_7_6 VGND VGND VPWR VPWR sky130_fd_sc_hd__decap_3
XFILLER_2_559 VGND VGND VPWR VPWR sky130_fd_sc_hd__decap_3
XFILLER_77_36 VGND VGND VPWR VPWR sky130_fd_sc_hd__decap_3
Xfanout830 fanout832/X VGND VGND VPWR VPWR fanout830/X sky130_fd_sc_hd__clkdlybuf4s25_1
XFILLER_63_1440 VGND VGND VPWR VPWR sky130_fd_sc_hd__decap_3
XTAP_TAPCELL_ROW_5_320 VGND VPWR sky130_fd_sc_hd__tapvpwrvgnd_1
Xfanout841 fanout846/X VGND VGND VPWR VPWR fanout841/X sky130_fd_sc_hd__clkdlybuf4s25_1
XFILLER_77_69 VGND VGND VPWR VPWR sky130_fd_sc_hd__decap_3
XTAP_TAPCELL_ROW_5_331 VGND VPWR sky130_fd_sc_hd__tapvpwrvgnd_1
XFILLER_24_1424 VGND VGND VPWR VPWR sky130_fd_sc_hd__decap_3
XTAP_TAPCELL_ROW_5_342 VGND VPWR sky130_fd_sc_hd__tapvpwrvgnd_1
XFILLER_24_1435 VGND VGND VPWR VPWR sky130_fd_sc_hd__decap_3
XFILLER_19_906 VGND VGND VPWR VPWR sky130_fd_sc_hd__decap_3
XFILLER_24_1468 VGND VGND VPWR VPWR sky130_fd_sc_hd__fill_1
XFILLER_19_939 VGND VGND VPWR VPWR sky130_fd_sc_hd__fill_2
Xhold1050 _6164_/Q VGND VGND VPWR VPWR _6011_/A0 sky130_fd_sc_hd__dlygate4sd3_1
XFILLER_46_725 VGND VGND VPWR VPWR sky130_fd_sc_hd__decap_3
Xhold1061 _6130_/Q VGND VGND VPWR VPWR _5977_/A0 sky130_fd_sc_hd__dlygate4sd3_1
XFILLER_2_1220 VGND VGND VPWR VPWR sky130_fd_sc_hd__decap_3
Xhold1072 _6986_/Q VGND VGND VPWR VPWR _5982_/A1 sky130_fd_sc_hd__dlygate4sd3_1
Xhold1083 _7023_/Q VGND VGND VPWR VPWR _6019_/A1 sky130_fd_sc_hd__dlygate4sd3_1
XFILLER_18_449 VGND VGND VPWR VPWR sky130_fd_sc_hd__fill_2
XTAP_TAPCELL_ROW_29_945 VGND VPWR sky130_fd_sc_hd__tapvpwrvgnd_1
Xhold1094 _6041_/X VGND VGND VPWR VPWR _7045_/D sky130_fd_sc_hd__dlygate4sd3_1
XTAP_TAPCELL_ROW_29_956 VGND VPWR sky130_fd_sc_hd__tapvpwrvgnd_1
XFILLER_46_769 VGND VGND VPWR VPWR sky130_fd_sc_hd__decap_3
XFILLER_2_1253 VGND VGND VPWR VPWR sky130_fd_sc_hd__decap_3
XTAP_TAPCELL_ROW_29_967 VGND VPWR sky130_fd_sc_hd__tapvpwrvgnd_1
XFILLER_2_1264 VGND VGND VPWR VPWR sky130_fd_sc_hd__decap_3
XFILLER_33_408 VGND VGND VPWR VPWR sky130_fd_sc_hd__decap_3
XTAP_TAPCELL_ROW_16_606 VGND VPWR sky130_fd_sc_hd__tapvpwrvgnd_1
XFILLER_73_588 VGND VGND VPWR VPWR sky130_fd_sc_hd__decap_3
XTAP_TAPCELL_ROW_16_617 VGND VPWR sky130_fd_sc_hd__tapvpwrvgnd_1
XFILLER_14_611 VGND VGND VPWR VPWR sky130_fd_sc_hd__decap_3
XFILLER_26_62 VGND VGND VPWR VPWR sky130_fd_sc_hd__decap_3
XFILLER_2_1297 VGND VGND VPWR VPWR sky130_fd_sc_hd__decap_3
XTAP_TAPCELL_ROW_16_628 VGND VPWR sky130_fd_sc_hd__tapvpwrvgnd_1
XFILLER_57_1233 VGND VGND VPWR VPWR sky130_fd_sc_hd__decap_3
XFILLER_18_1217 VGND VGND VPWR VPWR sky130_fd_sc_hd__decap_3
XFILLER_57_1266 VGND VGND VPWR VPWR sky130_fd_sc_hd__decap_3
XFILLER_42_964 VGND VGND VPWR VPWR sky130_fd_sc_hd__decap_3
XFILLER_14_666 VGND VGND VPWR VPWR sky130_fd_sc_hd__decap_3
XFILLER_41_452 VGND VGND VPWR VPWR sky130_fd_sc_hd__fill_2
XFILLER_70_1400 VGND VGND VPWR VPWR sky130_fd_sc_hd__decap_3
XFILLER_13_154 VGND VGND VPWR VPWR sky130_fd_sc_hd__fill_1
XFILLER_14_699 VGND VGND VPWR VPWR sky130_fd_sc_hd__fill_1
XFILLER_70_1444 VGND VGND VPWR VPWR sky130_fd_sc_hd__decap_3
XFILLER_9_147 VGND VGND VPWR VPWR sky130_fd_sc_hd__decap_3
XFILLER_42_61 VGND VGND VPWR VPWR sky130_fd_sc_hd__decap_3
XFILLER_9_169 VGND VGND VPWR VPWR sky130_fd_sc_hd__decap_3
XFILLER_31_1428 VGND VGND VPWR VPWR sky130_fd_sc_hd__decap_3
XFILLER_42_83 VGND VGND VPWR VPWR sky130_fd_sc_hd__fill_1
XFILLER_42_94 VGND VGND VPWR VPWR sky130_fd_sc_hd__fill_1
XFILLER_10_872 VGND VGND VPWR VPWR sky130_fd_sc_hd__decap_3
XFILLER_61_9 VGND VGND VPWR VPWR sky130_fd_sc_hd__decap_3
XPHY_EDGE_ROW_39_Left_120 VGND VGND VPWR VPWR sky130_fd_sc_hd__decap_3
XFILLER_5_353 VGND VGND VPWR VPWR sky130_fd_sc_hd__decap_3
XFILLER_29_1313 VGND VGND VPWR VPWR sky130_fd_sc_hd__decap_3
XFILLER_68_1362 VGND VGND VPWR VPWR sky130_fd_sc_hd__decap_3
XFILLER_68_1373 VGND VGND VPWR VPWR sky130_fd_sc_hd__decap_3
XFILLER_9_1407 VGND VGND VPWR VPWR sky130_fd_sc_hd__decap_3
XFILLER_64_1226 VGND VGND VPWR VPWR sky130_fd_sc_hd__decap_3
XFILLER_29_1357 VGND VGND VPWR VPWR sky130_fd_sc_hd__decap_3
XFILLER_3_33 VGND VGND VPWR VPWR sky130_fd_sc_hd__decap_3
XFILLER_64_1259 VGND VGND VPWR VPWR sky130_fd_sc_hd__fill_1
XFILLER_1_570 VGND VGND VPWR VPWR sky130_fd_sc_hd__decap_3
XFILLER_3_66 VGND VGND VPWR VPWR sky130_fd_sc_hd__decap_3
XTAP_TAPCELL_ROW_69_2002 VGND VPWR sky130_fd_sc_hd__tapvpwrvgnd_1
XFILLER_7_1142 VGND VGND VPWR VPWR sky130_fd_sc_hd__decap_3
XFILLER_3_99 VGND VGND VPWR VPWR sky130_fd_sc_hd__decap_3
XFILLER_7_1175 VGND VGND VPWR VPWR sky130_fd_sc_hd__fill_1
XFILLER_37_714 VGND VGND VPWR VPWR sky130_fd_sc_hd__fill_1
XFILLER_7_1186 VGND VGND VPWR VPWR sky130_fd_sc_hd__decap_3
XFILLER_3_1039 VGND VGND VPWR VPWR sky130_fd_sc_hd__decap_3
XFILLER_36_235 VGND VGND VPWR VPWR sky130_fd_sc_hd__decap_3
Xwire28 wire28/A VGND VGND VPWR VPWR uo_out[7] sky130_fd_sc_hd__buf_4
XFILLER_40_1270 VGND VGND VPWR VPWR sky130_fd_sc_hd__decap_3
XFILLER_64_566 VGND VGND VPWR VPWR sky130_fd_sc_hd__decap_3
XFILLER_18_972 VGND VGND VPWR VPWR sky130_fd_sc_hd__decap_3
XFILLER_36_268 VGND VGND VPWR VPWR sky130_fd_sc_hd__fill_2
XFILLER_75_1322 VGND VGND VPWR VPWR sky130_fd_sc_hd__decap_3
X_4961_ _6384_/Q _5222_/B wire434/X VGND VGND VPWR VPWR _4961_/Y sky130_fd_sc_hd__a21oi_2
XFILLER_17_482 VGND VGND VPWR VPWR sky130_fd_sc_hd__fill_1
XFILLER_45_791 VGND VGND VPWR VPWR sky130_fd_sc_hd__decap_3
X_6700_ _7020_/CLK _6700_/D load_slew808/X VGND VGND VPWR VPWR _6700_/Q sky130_fd_sc_hd__dfrtp_2
XFILLER_36_1306 VGND VGND VPWR VPWR sky130_fd_sc_hd__decap_3
X_3912_ _6221_/Q wire77/X _3910_/X _3911_/X VGND VGND VPWR VPWR _6221_/D sky130_fd_sc_hd__o22a_2
XFILLER_75_1366 VGND VGND VPWR VPWR sky130_fd_sc_hd__decap_3
XFILLER_33_964 VGND VGND VPWR VPWR sky130_fd_sc_hd__decap_3
XFILLER_36_1317 VGND VGND VPWR VPWR sky130_fd_sc_hd__decap_3
X_4892_ _6342_/Q _4899_/S _4889_/X _4891_/X VGND VGND VPWR VPWR _6342_/D sky130_fd_sc_hd__o22a_2
XFILLER_71_1219 VGND VGND VPWR VPWR sky130_fd_sc_hd__decap_3
XFILLER_32_452 VGND VGND VPWR VPWR sky130_fd_sc_hd__fill_1
XFILLER_75_1399 VGND VGND VPWR VPWR sky130_fd_sc_hd__fill_1
X_6631_ _6943_/CLK _6631_/D fanout818/X VGND VGND VPWR VPWR _6631_/Q sky130_fd_sc_hd__dfrtp_2
X_3843_ _4303_/A _4140_/A VGND VGND VPWR VPWR _3848_/A sky130_fd_sc_hd__xnor2_2
XFILLER_73_1090 VGND VGND VPWR VPWR sky130_fd_sc_hd__decap_3
XFILLER_20_658 VGND VGND VPWR VPWR sky130_fd_sc_hd__fill_2
XFILLER_34_1052 VGND VGND VPWR VPWR sky130_fd_sc_hd__decap_3
X_6562_ _6900_/CLK _6562_/D load_slew825/X VGND VGND VPWR VPWR _6562_/Q sky130_fd_sc_hd__dfrtp_2
X_3774_ _6240_/Q _4770_/B _3772_/X _3773_/X VGND VGND VPWR VPWR _4270_/A sky130_fd_sc_hd__o22a_2
XFILLER_9_670 VGND VGND VPWR VPWR sky130_fd_sc_hd__fill_2
XTAP_TAPCELL_ROW_41_1264 VGND VPWR sky130_fd_sc_hd__tapvpwrvgnd_1
XFILLER_34_1085 VGND VGND VPWR VPWR sky130_fd_sc_hd__decap_3
XTAP_TAPCELL_ROW_41_1275 VGND VPWR sky130_fd_sc_hd__tapvpwrvgnd_1
XFILLER_34_1096 VGND VGND VPWR VPWR sky130_fd_sc_hd__fill_2
X_5513_ _5513_/A _5513_/B _5513_/C _5514_/B VGND VGND VPWR VPWR _6606_/D sky130_fd_sc_hd__and4_2
X_6493_ _6926_/CLK _6493_/D fanout759/A VGND VGND VPWR VPWR _6493_/Q sky130_fd_sc_hd__dfrtp_2
XFILLER_12_1350 VGND VGND VPWR VPWR sky130_fd_sc_hd__decap_3
X_5444_ _5444_/A1 _5476_/A2 _4698_/X VGND VGND VPWR VPWR _6556_/D sky130_fd_sc_hd__a21o_2
Xclkbuf_leaf_8_clk clkload1/A VGND VGND VPWR VPWR _6882_/CLK sky130_fd_sc_hd__clkbuf_8
XFILLER_69_1159 VGND VGND VPWR VPWR sky130_fd_sc_hd__decap_3
XFILLER_12_1394 VGND VGND VPWR VPWR sky130_fd_sc_hd__decap_3
XFILLER_47_1413 VGND VGND VPWR VPWR sky130_fd_sc_hd__decap_3
XTAP_TAPCELL_ROW_54_1603 VGND VPWR sky130_fd_sc_hd__tapvpwrvgnd_1
X_5375_ _5375_/A1 _5479_/A2 _4261_/X VGND VGND VPWR VPWR _6487_/D sky130_fd_sc_hd__a21o_2
XTAP_TAPCELL_ROW_54_1614 VGND VPWR sky130_fd_sc_hd__tapvpwrvgnd_1
XFILLER_47_1446 VGND VGND VPWR VPWR sky130_fd_sc_hd__decap_3
XFILLER_47_1457 VGND VGND VPWR VPWR sky130_fd_sc_hd__decap_3
Xfanout104 _5290_/A2 VGND VGND VPWR VPWR wire105/A sky130_fd_sc_hd__clkdlybuf4s25_1
X_4326_ _4326_/A _4326_/B VGND VGND VPWR VPWR _4327_/B sky130_fd_sc_hd__xor2_2
Xfanout115 _5263_/A2 VGND VGND VPWR VPWR _5153_/A2 sky130_fd_sc_hd__clkdlybuf4s25_1
Xfanout126 _5357_/S VGND VGND VPWR VPWR wire127/A sky130_fd_sc_hd__clkdlybuf4s25_1
X_7045_ clkload7/A _7045_/D wire639/X VGND VGND VPWR VPWR _7045_/Q sky130_fd_sc_hd__dfrtp_2
X_4257_ _4344_/B _6487_/Q _4257_/S VGND VGND VPWR VPWR _4257_/X sky130_fd_sc_hd__mux2_1
XFILLER_80_1061 VGND VGND VPWR VPWR sky130_fd_sc_hd__decap_3
XFILLER_41_1023 VGND VGND VPWR VPWR sky130_fd_sc_hd__decap_3
X_3208_ _3213_/A1 _3206_/X _3207_/X _3213_/C1 VGND VGND VPWR VPWR _3208_/X sky130_fd_sc_hd__a211o_2
XFILLER_80_1083 VGND VGND VPWR VPWR sky130_fd_sc_hd__decap_3
X_4188_ _6255_/Q _4427_/S _4185_/X _4187_/X VGND VGND VPWR VPWR _6255_/D sky130_fd_sc_hd__o22a_2
XFILLER_67_382 VGND VGND VPWR VPWR sky130_fd_sc_hd__decap_3
X_3139_ _7059_/Q _3138_/X _3225_/S VGND VGND VPWR VPWR wire81/A sky130_fd_sc_hd__mux2_1
XFILLER_76_1108 VGND VGND VPWR VPWR sky130_fd_sc_hd__decap_3
XFILLER_70_503 VGND VGND VPWR VPWR sky130_fd_sc_hd__decap_3
Xclkbuf_3_2_0_clk clkbuf_0_clk/X VGND VGND VPWR VPWR clkbuf_3_2_0_clk/X sky130_fd_sc_hd__clkbuf_8
XFILLER_42_249 VGND VGND VPWR VPWR sky130_fd_sc_hd__decap_3
XFILLER_70_569 VGND VGND VPWR VPWR sky130_fd_sc_hd__decap_3
XFILLER_23_430 VGND VGND VPWR VPWR sky130_fd_sc_hd__decap_3
XFILLER_54_1406 VGND VGND VPWR VPWR sky130_fd_sc_hd__decap_3
XFILLER_23_441 VGND VGND VPWR VPWR sky130_fd_sc_hd__decap_3
XFILLER_23_452 VGND VGND VPWR VPWR sky130_fd_sc_hd__decap_3
XFILLER_11_614 VGND VGND VPWR VPWR sky130_fd_sc_hd__fill_2
X_6829_ clkload9/A _6829_/D fanout656/X VGND VGND VPWR VPWR _6829_/Q sky130_fd_sc_hd__dfrtp_2
XFILLER_51_794 VGND VGND VPWR VPWR sky130_fd_sc_hd__decap_3
XFILLER_17_1272 VGND VGND VPWR VPWR sky130_fd_sc_hd__decap_3
Xwire527 _5182_/B VGND VGND VPWR VPWR _5306_/S sky130_fd_sc_hd__clkbuf_4
XFILLER_13_1136 VGND VGND VPWR VPWR sky130_fd_sc_hd__decap_3
XFILLER_12_75 VGND VGND VPWR VPWR sky130_fd_sc_hd__decap_3
XFILLER_30_1450 VGND VGND VPWR VPWR sky130_fd_sc_hd__decap_3
XFILLER_3_824 VGND VGND VPWR VPWR sky130_fd_sc_hd__decap_3
XFILLER_2_312 VGND VGND VPWR VPWR sky130_fd_sc_hd__decap_3
XFILLER_5_3 VGND VGND VPWR VPWR sky130_fd_sc_hd__decap_3
XFILLER_3_868 VGND VGND VPWR VPWR sky130_fd_sc_hd__decap_3
XFILLER_2_345 VGND VGND VPWR VPWR sky130_fd_sc_hd__decap_3
XFILLER_2_389 VGND VGND VPWR VPWR sky130_fd_sc_hd__decap_3
XFILLER_77_113 VGND VGND VPWR VPWR sky130_fd_sc_hd__decap_3
XFILLER_77_124 VGND VGND VPWR VPWR sky130_fd_sc_hd__decap_3
XFILLER_77_157 VGND VGND VPWR VPWR sky130_fd_sc_hd__fill_2
XFILLER_8_1462 VGND VGND VPWR VPWR sky130_fd_sc_hd__decap_3
XFILLER_24_1232 VGND VGND VPWR VPWR sky130_fd_sc_hd__decap_3
XFILLER_63_1281 VGND VGND VPWR VPWR sky130_fd_sc_hd__decap_3
XFILLER_59_872 VGND VGND VPWR VPWR sky130_fd_sc_hd__decap_3
XFILLER_63_1292 VGND VGND VPWR VPWR sky130_fd_sc_hd__decap_3
Xfanout682 fanout848/X VGND VGND VPWR VPWR fanout682/X sky130_fd_sc_hd__clkdlybuf4s25_1
XFILLER_4_1315 VGND VGND VPWR VPWR sky130_fd_sc_hd__fill_1
XFILLER_4_1326 VGND VGND VPWR VPWR sky130_fd_sc_hd__decap_3
XFILLER_58_360 VGND VGND VPWR VPWR sky130_fd_sc_hd__decap_3
Xfanout693 fanout697/X VGND VGND VPWR VPWR fanout693/X sky130_fd_sc_hd__clkdlybuf4s25_1
XFILLER_46_511 VGND VGND VPWR VPWR sky130_fd_sc_hd__fill_2
XFILLER_24_1276 VGND VGND VPWR VPWR sky130_fd_sc_hd__decap_3
XFILLER_46_533 VGND VGND VPWR VPWR sky130_fd_sc_hd__decap_3
XFILLER_4_1359 VGND VGND VPWR VPWR sky130_fd_sc_hd__decap_3
XFILLER_19_758 VGND VGND VPWR VPWR sky130_fd_sc_hd__decap_3
XFILLER_74_875 VGND VGND VPWR VPWR sky130_fd_sc_hd__decap_3
XFILLER_59_1328 VGND VGND VPWR VPWR sky130_fd_sc_hd__decap_3
XFILLER_34_717 VGND VGND VPWR VPWR sky130_fd_sc_hd__decap_3
XFILLER_18_279 VGND VGND VPWR VPWR sky130_fd_sc_hd__decap_3
XFILLER_34_728 VGND VGND VPWR VPWR sky130_fd_sc_hd__fill_1
XFILLER_2_1061 VGND VGND VPWR VPWR sky130_fd_sc_hd__decap_3
XFILLER_73_396 VGND VGND VPWR VPWR sky130_fd_sc_hd__decap_3
XFILLER_27_791 VGND VGND VPWR VPWR sky130_fd_sc_hd__decap_3
XFILLER_14_430 VGND VGND VPWR VPWR sky130_fd_sc_hd__decap_3
XFILLER_61_569 VGND VGND VPWR VPWR sky130_fd_sc_hd__decap_3
XFILLER_57_1063 VGND VGND VPWR VPWR sky130_fd_sc_hd__fill_1
XFILLER_30_923 VGND VGND VPWR VPWR sky130_fd_sc_hd__fill_1
XFILLER_18_1058 VGND VGND VPWR VPWR sky130_fd_sc_hd__decap_3
XFILLER_70_1241 VGND VGND VPWR VPWR sky130_fd_sc_hd__decap_3
XFILLER_35_1372 VGND VGND VPWR VPWR sky130_fd_sc_hd__decap_3
XFILLER_70_1285 VGND VGND VPWR VPWR sky130_fd_sc_hd__decap_3
XFILLER_31_1236 VGND VGND VPWR VPWR sky130_fd_sc_hd__decap_3
XFILLER_31_1269 VGND VGND VPWR VPWR sky130_fd_sc_hd__decap_3
XFILLER_6_662 VGND VGND VPWR VPWR sky130_fd_sc_hd__decap_3
X_3490_ _5358_/D _3490_/B _3490_/C VGND VGND VPWR VPWR _3490_/X sky130_fd_sc_hd__or3_2
XFILLER_5_161 VGND VGND VPWR VPWR sky130_fd_sc_hd__decap_3
XFILLER_5_172 VGND VGND VPWR VPWR sky130_fd_sc_hd__fill_1
XFILLER_68_1181 VGND VGND VPWR VPWR sky130_fd_sc_hd__decap_3
XFILLER_9_1204 VGND VGND VPWR VPWR sky130_fd_sc_hd__decap_3
X_5160_ _6727_/Q _5261_/A VGND VGND VPWR VPWR _5160_/X sky130_fd_sc_hd__or2_2
XFILLER_29_1154 VGND VGND VPWR VPWR sky130_fd_sc_hd__fill_1
XFILLER_69_614 VGND VGND VPWR VPWR sky130_fd_sc_hd__fill_2
XFILLER_38_3 VGND VGND VPWR VPWR sky130_fd_sc_hd__decap_3
XFILLER_25_1007 VGND VGND VPWR VPWR sky130_fd_sc_hd__fill_1
XFILLER_9_1248 VGND VGND VPWR VPWR sky130_fd_sc_hd__decap_3
XFILLER_25_1018 VGND VGND VPWR VPWR sky130_fd_sc_hd__fill_1
X_4111_ _4111_/A _4111_/B VGND VGND VPWR VPWR _4193_/A sky130_fd_sc_hd__xnor2_2
XFILLER_2_890 VGND VGND VPWR VPWR sky130_fd_sc_hd__decap_3
X_5091_ _5502_/C _5091_/B VGND VGND VPWR VPWR _5091_/X sky130_fd_sc_hd__or2_2
XFILLER_29_1198 VGND VGND VPWR VPWR sky130_fd_sc_hd__fill_2
XFILLER_68_135 VGND VGND VPWR VPWR sky130_fd_sc_hd__decap_3
XFILLER_42_1332 VGND VGND VPWR VPWR sky130_fd_sc_hd__decap_3
X_4042_ _6565_/Q _4645_/A _4091_/A1 VGND VGND VPWR VPWR _4042_/X sky130_fd_sc_hd__a21bo_2
XTAP_TAPCELL_ROW_34_1090 VGND VPWR sky130_fd_sc_hd__tapvpwrvgnd_1
XFILLER_37_511 VGND VGND VPWR VPWR sky130_fd_sc_hd__decap_3
XFILLER_42_1365 VGND VGND VPWR VPWR sky130_fd_sc_hd__decap_3
XFILLER_42_1376 VGND VGND VPWR VPWR sky130_fd_sc_hd__decap_3
XFILLER_49_393 VGND VGND VPWR VPWR sky130_fd_sc_hd__decap_3
XFILLER_76_190 VGND VGND VPWR VPWR sky130_fd_sc_hd__decap_3
XFILLER_77_1428 VGND VGND VPWR VPWR sky130_fd_sc_hd__decap_3
XFILLER_64_374 VGND VGND VPWR VPWR sky130_fd_sc_hd__decap_3
XFILLER_65_897 VGND VGND VPWR VPWR sky130_fd_sc_hd__decap_3
X_5993_ hold963/X _6997_/Q _5993_/S VGND VGND VPWR VPWR _5993_/X sky130_fd_sc_hd__mux2_1
XFILLER_75_1130 VGND VGND VPWR VPWR sky130_fd_sc_hd__decap_3
X_4944_ _6446_/Q _6664_/Q VGND VGND VPWR VPWR _4945_/B sky130_fd_sc_hd__xor2_2
XFILLER_75_1163 VGND VGND VPWR VPWR sky130_fd_sc_hd__decap_3
XFILLER_71_1005 VGND VGND VPWR VPWR sky130_fd_sc_hd__decap_3
XFILLER_21_912 VGND VGND VPWR VPWR sky130_fd_sc_hd__decap_3
XTAP_TAPCELL_ROW_43_1315 VGND VPWR sky130_fd_sc_hd__tapvpwrvgnd_1
XTAP_TAPCELL_ROW_43_1326 VGND VPWR sky130_fd_sc_hd__tapvpwrvgnd_1
X_4875_ _6316_/Q wire507/X _3458_/X _4875_/B2 VGND VGND VPWR VPWR _4875_/X sky130_fd_sc_hd__a22o_2
XFILLER_20_411 VGND VGND VPWR VPWR sky130_fd_sc_hd__decap_3
XFILLER_32_271 VGND VGND VPWR VPWR sky130_fd_sc_hd__decap_3
XFILLER_21_956 VGND VGND VPWR VPWR sky130_fd_sc_hd__decap_3
X_6614_ _6617_/CLK _6614_/D load_slew732/X VGND VGND VPWR VPWR _6614_/Q sky130_fd_sc_hd__dfrtp_2
XFILLER_14_1412 VGND VGND VPWR VPWR sky130_fd_sc_hd__decap_3
X_3826_ _3827_/B _3827_/C _3827_/A VGND VGND VPWR VPWR _3855_/B sky130_fd_sc_hd__a21o_2
XFILLER_20_477 VGND VGND VPWR VPWR sky130_fd_sc_hd__fill_2
XFILLER_14_1456 VGND VGND VPWR VPWR sky130_fd_sc_hd__decap_3
XFILLER_20_499 VGND VGND VPWR VPWR sky130_fd_sc_hd__decap_3
XTAP_TAPCELL_ROW_31_995 VGND VPWR sky130_fd_sc_hd__tapvpwrvgnd_1
X_6545_ _6923_/CLK _6545_/D fanout803/X VGND VGND VPWR VPWR _6545_/Q sky130_fd_sc_hd__dfrtp_2
X_3757_ _3757_/A _3757_/B _3884_/A VGND VGND VPWR VPWR _3758_/B sky130_fd_sc_hd__nand3_2
XFILLER_10_1309 VGND VGND VPWR VPWR sky130_fd_sc_hd__decap_3
X_6476_ _6819_/CLK _6476_/D load_slew780/X VGND VGND VPWR VPWR _6476_/Q sky130_fd_sc_hd__dfrtp_2
X_3688_ _3678_/Y _3683_/Y _3687_/Y _3615_/A VGND VGND VPWR VPWR _3880_/A sky130_fd_sc_hd__o211ai_2
XFILLER_12_1180 VGND VGND VPWR VPWR sky130_fd_sc_hd__decap_3
X_5427_ _5427_/A1 _5456_/A2 _4574_/X VGND VGND VPWR VPWR _6539_/D sky130_fd_sc_hd__a21o_2
XFILLER_0_816 VGND VGND VPWR VPWR sky130_fd_sc_hd__decap_3
XFILLER_47_1254 VGND VGND VPWR VPWR sky130_fd_sc_hd__decap_3
X_5358_ _7081_/Q _7086_/Q _5358_/C _5358_/D VGND VGND VPWR VPWR _5359_/C sky130_fd_sc_hd__nor4_2
XFILLER_59_113 VGND VGND VPWR VPWR sky130_fd_sc_hd__decap_3
XFILLER_47_1287 VGND VGND VPWR VPWR sky130_fd_sc_hd__fill_1
X_4309_ _6339_/Q _4868_/A2 _3264_/X _4868_/B2 VGND VGND VPWR VPWR _4309_/X sky130_fd_sc_hd__a22o_2
XFILLER_47_1298 VGND VGND VPWR VPWR sky130_fd_sc_hd__decap_3
X_5289_ _6776_/Q _5354_/S wire127/A _5288_/Y VGND VGND VPWR VPWR _5289_/X sky130_fd_sc_hd__o211a_2
XFILLER_60_1421 VGND VGND VPWR VPWR sky130_fd_sc_hd__decap_3
XFILLER_60_1432 VGND VGND VPWR VPWR sky130_fd_sc_hd__decap_3
X_7028_ _7035_/CLK _7028_/D fanout842/X VGND VGND VPWR VPWR _7028_/Q sky130_fd_sc_hd__dfrtp_2
XFILLER_21_1416 VGND VGND VPWR VPWR sky130_fd_sc_hd__decap_3
XFILLER_60_1465 VGND VGND VPWR VPWR sky130_fd_sc_hd__decap_3
XFILLER_74_15 VGND VGND VPWR VPWR sky130_fd_sc_hd__decap_3
XFILLER_28_533 VGND VGND VPWR VPWR sky130_fd_sc_hd__fill_1
XFILLER_21_1449 VGND VGND VPWR VPWR sky130_fd_sc_hd__decap_3
XFILLER_74_59 VGND VGND VPWR VPWR sky130_fd_sc_hd__decap_3
XFILLER_56_875 VGND VGND VPWR VPWR sky130_fd_sc_hd__fill_1
XFILLER_15_216 VGND VGND VPWR VPWR sky130_fd_sc_hd__decap_3
XFILLER_3_1381 VGND VGND VPWR VPWR sky130_fd_sc_hd__decap_3
XFILLER_55_396 VGND VGND VPWR VPWR sky130_fd_sc_hd__fill_2
XFILLER_71_867 VGND VGND VPWR VPWR sky130_fd_sc_hd__decap_3
XFILLER_19_1301 VGND VGND VPWR VPWR sky130_fd_sc_hd__decap_3
XFILLER_58_1350 VGND VGND VPWR VPWR sky130_fd_sc_hd__decap_3
XFILLER_54_1203 VGND VGND VPWR VPWR sky130_fd_sc_hd__fill_1
XFILLER_19_1334 VGND VGND VPWR VPWR sky130_fd_sc_hd__decap_3
XFILLER_70_388 VGND VGND VPWR VPWR sky130_fd_sc_hd__decap_3
XFILLER_19_1345 VGND VGND VPWR VPWR sky130_fd_sc_hd__decap_3
XFILLER_58_1394 VGND VGND VPWR VPWR sky130_fd_sc_hd__decap_3
XFILLER_23_260 VGND VGND VPWR VPWR sky130_fd_sc_hd__decap_3
XFILLER_12_934 VGND VGND VPWR VPWR sky130_fd_sc_hd__decap_3
XFILLER_54_1247 VGND VGND VPWR VPWR sky130_fd_sc_hd__decap_3
XFILLER_11_422 VGND VGND VPWR VPWR sky130_fd_sc_hd__decap_3
XFILLER_19_1378 VGND VGND VPWR VPWR sky130_fd_sc_hd__decap_3
XFILLER_23_293 VGND VGND VPWR VPWR sky130_fd_sc_hd__decap_3
XFILLER_12_978 VGND VGND VPWR VPWR sky130_fd_sc_hd__fill_2
XFILLER_11_477 VGND VGND VPWR VPWR sky130_fd_sc_hd__decap_3
XFILLER_7_426 VGND VGND VPWR VPWR sky130_fd_sc_hd__decap_3
XFILLER_11_499 VGND VGND VPWR VPWR sky130_fd_sc_hd__decap_3
XFILLER_30_1291 VGND VGND VPWR VPWR sky130_fd_sc_hd__decap_3
XFILLER_3_643 VGND VGND VPWR VPWR sky130_fd_sc_hd__decap_3
XFILLER_65_1310 VGND VGND VPWR VPWR sky130_fd_sc_hd__decap_3
XFILLER_79_912 VGND VGND VPWR VPWR sky130_fd_sc_hd__decap_3
XFILLER_3_676 VGND VGND VPWR VPWR sky130_fd_sc_hd__decap_3
XFILLER_2_153 VGND VGND VPWR VPWR sky130_fd_sc_hd__decap_3
XFILLER_65_1343 VGND VGND VPWR VPWR sky130_fd_sc_hd__fill_1
XFILLER_65_1354 VGND VGND VPWR VPWR sky130_fd_sc_hd__decap_3
XFILLER_78_411 VGND VGND VPWR VPWR sky130_fd_sc_hd__fill_1
XFILLER_2_186 VGND VGND VPWR VPWR sky130_fd_sc_hd__decap_3
XFILLER_2_197 VGND VGND VPWR VPWR sky130_fd_sc_hd__decap_3
XFILLER_26_1338 VGND VGND VPWR VPWR sky130_fd_sc_hd__decap_3
XFILLER_65_1387 VGND VGND VPWR VPWR sky130_fd_sc_hd__decap_3
XFILLER_24_9 VGND VGND VPWR VPWR sky130_fd_sc_hd__decap_3
XFILLER_78_466 VGND VGND VPWR VPWR sky130_fd_sc_hd__decap_3
XFILLER_66_606 VGND VGND VPWR VPWR sky130_fd_sc_hd__decap_3
XFILLER_78_477 VGND VGND VPWR VPWR sky130_fd_sc_hd__decap_3
XFILLER_8_1270 VGND VGND VPWR VPWR sky130_fd_sc_hd__decap_3
XFILLER_48_60 VGND VGND VPWR VPWR sky130_fd_sc_hd__decap_3
Xfanout490 _5577_/A VGND VGND VPWR VPWR _3044_/A sky130_fd_sc_hd__clkdlybuf4s25_1
XFILLER_4_1123 VGND VGND VPWR VPWR sky130_fd_sc_hd__decap_3
XFILLER_0_12 VGND VGND VPWR VPWR sky130_fd_sc_hd__decap_3
XFILLER_47_853 VGND VGND VPWR VPWR sky130_fd_sc_hd__fill_2
XFILLER_4_1167 VGND VGND VPWR VPWR sky130_fd_sc_hd__decap_3
XFILLER_0_1009 VGND VGND VPWR VPWR sky130_fd_sc_hd__decap_3
XFILLER_47_875 VGND VGND VPWR VPWR sky130_fd_sc_hd__decap_3
XFILLER_34_503 VGND VGND VPWR VPWR sky130_fd_sc_hd__decap_3
XFILLER_59_1114 VGND VGND VPWR VPWR sky130_fd_sc_hd__decap_3
XFILLER_80_119 VGND VGND VPWR VPWR sky130_fd_sc_hd__decap_3
XFILLER_47_897 VGND VGND VPWR VPWR sky130_fd_sc_hd__fill_1
XFILLER_0_78 VGND VGND VPWR VPWR sky130_fd_sc_hd__decap_3
XFILLER_76_1450 VGND VGND VPWR VPWR sky130_fd_sc_hd__decap_3
XFILLER_22_709 VGND VGND VPWR VPWR sky130_fd_sc_hd__decap_3
XFILLER_37_1401 VGND VGND VPWR VPWR sky130_fd_sc_hd__decap_3
XFILLER_64_81 VGND VGND VPWR VPWR sky130_fd_sc_hd__decap_3
XFILLER_34_569 VGND VGND VPWR VPWR sky130_fd_sc_hd__decap_3
XFILLER_72_1303 VGND VGND VPWR VPWR sky130_fd_sc_hd__decap_3
XFILLER_37_1434 VGND VGND VPWR VPWR sky130_fd_sc_hd__decap_3
XFILLER_9_21 VGND VGND VPWR VPWR sky130_fd_sc_hd__decap_3
XFILLER_15_783 VGND VGND VPWR VPWR sky130_fd_sc_hd__fill_1
XFILLER_61_399 VGND VGND VPWR VPWR sky130_fd_sc_hd__decap_3
XFILLER_72_1347 VGND VGND VPWR VPWR sky130_fd_sc_hd__decap_3
XFILLER_30_731 VGND VGND VPWR VPWR sky130_fd_sc_hd__decap_3
XFILLER_30_753 VGND VGND VPWR VPWR sky130_fd_sc_hd__decap_3
X_4660_ _6551_/Q _4659_/A _4838_/A1 VGND VGND VPWR VPWR _4660_/X sky130_fd_sc_hd__a21bo_2
X_3611_ _3665_/A _3665_/B VGND VGND VPWR VPWR _3615_/C sky130_fd_sc_hd__nand2_2
XFILLER_31_1044 VGND VGND VPWR VPWR sky130_fd_sc_hd__decap_3
X_4591_ _6325_/Q _4765_/A2 _3364_/X _4765_/B2 VGND VGND VPWR VPWR _4591_/X sky130_fd_sc_hd__a22o_2
X_6330_ _7052_/CLK _6330_/D load_slew805/X VGND VGND VPWR VPWR _6330_/Q sky130_fd_sc_hd__dfrtp_2
Xhold905 _6203_/Q VGND VGND VPWR VPWR hold905/X sky130_fd_sc_hd__dlygate4sd3_1
X_3542_ _6291_/Q _5594_/A1 _5603_/A1 _6283_/Q VGND VGND VPWR VPWR _3542_/X sky130_fd_sc_hd__a22o_2
Xhold916 _6953_/Q VGND VGND VPWR VPWR hold916/X sky130_fd_sc_hd__dlygate4sd3_1
Xhold927 _6187_/Q VGND VGND VPWR VPWR hold927/X sky130_fd_sc_hd__dlygate4sd3_1
Xhold938 _5942_/X VGND VGND VPWR VPWR _6946_/D sky130_fd_sc_hd__dlygate4sd3_1
X_3473_ _6057_/A0 _3472_/X _3473_/S VGND VGND VPWR VPWR _6210_/D sky130_fd_sc_hd__mux2_1
XFILLER_6_492 VGND VGND VPWR VPWR sky130_fd_sc_hd__decap_3
X_6261_ _6959_/CLK _6261_/D load_slew799/X VGND VGND VPWR VPWR _6261_/Q sky130_fd_sc_hd__dfrtp_2
Xhold949 _6032_/X VGND VGND VPWR VPWR _7036_/D sky130_fd_sc_hd__dlygate4sd3_1
X_5212_ _6412_/Q _5284_/A2 _5211_/X VGND VGND VPWR VPWR _6412_/D sky130_fd_sc_hd__a21o_2
XTAP_TAPCELL_ROW_36_1130 VGND VPWR sky130_fd_sc_hd__tapvpwrvgnd_1
X_6192_ _7011_/CLK _6192_/D load_slew815/X VGND VGND VPWR VPWR _6192_/Q sky130_fd_sc_hd__dfrtp_2
XTAP_TAPCELL_ROW_36_1141 VGND VPWR sky130_fd_sc_hd__tapvpwrvgnd_1
XFILLER_44_1427 VGND VGND VPWR VPWR sky130_fd_sc_hd__fill_1
XFILLER_44_1438 VGND VGND VPWR VPWR sky130_fd_sc_hd__decap_3
X_5143_ _6380_/Q _5260_/A2 _4936_/S _5142_/X VGND VGND VPWR VPWR _6380_/D sky130_fd_sc_hd__a22o_2
XTAP_TAPCELL_ROW_32_1027 VGND VPWR sky130_fd_sc_hd__tapvpwrvgnd_1
XTAP_TAPCELL_ROW_32_1038 VGND VPWR sky130_fd_sc_hd__tapvpwrvgnd_1
X_5074_ _5342_/S _5075_/B wire105/A VGND VGND VPWR VPWR _5074_/X sky130_fd_sc_hd__a21o_2
XFILLER_38_831 VGND VGND VPWR VPWR sky130_fd_sc_hd__fill_1
X_4025_ _4091_/A1 _4022_/X _4023_/Y _4024_/X _4382_/C1 VGND VGND VPWR VPWR _4025_/X
+ sky130_fd_sc_hd__o221a_2
XFILLER_49_190 VGND VGND VPWR VPWR sky130_fd_sc_hd__decap_3
XFILLER_38_864 VGND VGND VPWR VPWR sky130_fd_sc_hd__decap_3
XFILLER_38_875 VGND VGND VPWR VPWR sky130_fd_sc_hd__decap_3
XFILLER_65_661 VGND VGND VPWR VPWR sky130_fd_sc_hd__fill_2
XFILLER_53_812 VGND VGND VPWR VPWR sky130_fd_sc_hd__decap_3
XFILLER_77_1225 VGND VGND VPWR VPWR sky130_fd_sc_hd__decap_3
XFILLER_38_897 VGND VGND VPWR VPWR sky130_fd_sc_hd__fill_1
XFILLER_80_620 VGND VGND VPWR VPWR sky130_fd_sc_hd__decap_3
XFILLER_77_1236 VGND VGND VPWR VPWR sky130_fd_sc_hd__decap_3
XFILLER_25_536 VGND VGND VPWR VPWR sky130_fd_sc_hd__decap_3
XFILLER_44_18 VGND VGND VPWR VPWR sky130_fd_sc_hd__decap_3
XFILLER_77_1269 VGND VGND VPWR VPWR sky130_fd_sc_hd__decap_3
X_5976_ _6129_/Q _5976_/A1 _6048_/S VGND VGND VPWR VPWR _5976_/X sky130_fd_sc_hd__mux2_1
XFILLER_80_697 VGND VGND VPWR VPWR sky130_fd_sc_hd__decap_3
X_4927_ _4925_/X _4926_/Y wire105/X VGND VGND VPWR VPWR _4929_/S sky130_fd_sc_hd__a21oi_2
XFILLER_33_580 VGND VGND VPWR VPWR sky130_fd_sc_hd__fill_2
XFILLER_20_241 VGND VGND VPWR VPWR sky130_fd_sc_hd__decap_3
X_4858_ _6586_/Q _4879_/B VGND VGND VPWR VPWR _4858_/Y sky130_fd_sc_hd__nand2_2
XFILLER_14_1220 VGND VGND VPWR VPWR sky130_fd_sc_hd__decap_3
XFILLER_20_274 VGND VGND VPWR VPWR sky130_fd_sc_hd__decap_3
X_3809_ _6225_/Q _3928_/A2 _3928_/B1 _6217_/Q _3928_/C1 VGND VGND VPWR VPWR _3809_/X
+ sky130_fd_sc_hd__a221o_2
XFILLER_14_1253 VGND VGND VPWR VPWR sky130_fd_sc_hd__decap_3
X_4789_ _6280_/Q _4847_/A2 _3434_/X _4789_/B2 VGND VGND VPWR VPWR _4789_/X sky130_fd_sc_hd__a22o_2
XFILLER_14_1264 VGND VGND VPWR VPWR sky130_fd_sc_hd__decap_3
XFILLER_4_418 VGND VGND VPWR VPWR sky130_fd_sc_hd__fill_2
X_6528_ _7090_/CLK _6528_/D load_slew718/X VGND VGND VPWR VPWR _6528_/Q sky130_fd_sc_hd__dfrtp_2
XFILLER_14_1297 VGND VGND VPWR VPWR sky130_fd_sc_hd__decap_3
XFILLER_49_1316 VGND VGND VPWR VPWR sky130_fd_sc_hd__decap_3
XFILLER_69_15 VGND VGND VPWR VPWR sky130_fd_sc_hd__decap_3
X_6459_ clkload7/A _6459_/D wire641/X VGND VGND VPWR VPWR _6459_/Q sky130_fd_sc_hd__dfrtp_2
XFILLER_69_48 VGND VGND VPWR VPWR sky130_fd_sc_hd__decap_3
XFILLER_0_613 VGND VGND VPWR VPWR sky130_fd_sc_hd__decap_3
XFILLER_0_657 VGND VGND VPWR VPWR sky130_fd_sc_hd__decap_3
XFILLER_76_915 VGND VGND VPWR VPWR sky130_fd_sc_hd__decap_3
XFILLER_0_679 VGND VGND VPWR VPWR sky130_fd_sc_hd__decap_3
XFILLER_75_414 VGND VGND VPWR VPWR sky130_fd_sc_hd__decap_3
XFILLER_5_1410 VGND VGND VPWR VPWR sky130_fd_sc_hd__decap_3
XFILLER_48_639 VGND VGND VPWR VPWR sky130_fd_sc_hd__decap_3
XFILLER_25_1360 VGND VGND VPWR VPWR sky130_fd_sc_hd__decap_3
XFILLER_75_436 VGND VGND VPWR VPWR sky130_fd_sc_hd__fill_2
XFILLER_5_1443 VGND VGND VPWR VPWR sky130_fd_sc_hd__decap_3
XFILLER_75_458 VGND VGND VPWR VPWR sky130_fd_sc_hd__fill_2
XFILLER_25_1393 VGND VGND VPWR VPWR sky130_fd_sc_hd__decap_3
XFILLER_47_149 VGND VGND VPWR VPWR sky130_fd_sc_hd__decap_3
XFILLER_60_1273 VGND VGND VPWR VPWR sky130_fd_sc_hd__decap_3
XFILLER_1_1307 VGND VGND VPWR VPWR sky130_fd_sc_hd__decap_3
XFILLER_16_503 VGND VGND VPWR VPWR sky130_fd_sc_hd__decap_3
XFILLER_21_1257 VGND VGND VPWR VPWR sky130_fd_sc_hd__decap_3
XFILLER_18_85 VGND VGND VPWR VPWR sky130_fd_sc_hd__fill_1
XFILLER_29_897 VGND VGND VPWR VPWR sky130_fd_sc_hd__decap_3
XFILLER_16_536 VGND VGND VPWR VPWR sky130_fd_sc_hd__fill_2
XFILLER_56_1309 VGND VGND VPWR VPWR sky130_fd_sc_hd__decap_3
XFILLER_16_558 VGND VGND VPWR VPWR sky130_fd_sc_hd__decap_3
XFILLER_70_141 VGND VGND VPWR VPWR sky130_fd_sc_hd__fill_2
XFILLER_31_517 VGND VGND VPWR VPWR sky130_fd_sc_hd__decap_3
XFILLER_43_388 VGND VGND VPWR VPWR sky130_fd_sc_hd__decap_3
XFILLER_24_580 VGND VGND VPWR VPWR sky130_fd_sc_hd__decap_3
XFILLER_19_1175 VGND VGND VPWR VPWR sky130_fd_sc_hd__fill_1
XFILLER_54_1055 VGND VGND VPWR VPWR sky130_fd_sc_hd__fill_1
XFILLER_15_1017 VGND VGND VPWR VPWR sky130_fd_sc_hd__decap_3
XFILLER_12_775 VGND VGND VPWR VPWR sky130_fd_sc_hd__decap_3
XFILLER_32_1320 VGND VGND VPWR VPWR sky130_fd_sc_hd__decap_3
XFILLER_12_797 VGND VGND VPWR VPWR sky130_fd_sc_hd__decap_3
XTAP_TAPCELL_ROW_22_770 VGND VPWR sky130_fd_sc_hd__tapvpwrvgnd_1
XFILLER_8_757 VGND VGND VPWR VPWR sky130_fd_sc_hd__decap_3
XTAP_TAPCELL_ROW_22_781 VGND VPWR sky130_fd_sc_hd__tapvpwrvgnd_1
Xwire143 _4119_/Y VGND VGND VPWR VPWR _4201_/A sky130_fd_sc_hd__buf_2
XFILLER_32_1353 VGND VGND VPWR VPWR sky130_fd_sc_hd__decap_3
Xwire154 wire154/A VGND VGND VPWR VPWR wire154/X sky130_fd_sc_hd__clkbuf_4
XFILLER_32_1397 VGND VGND VPWR VPWR sky130_fd_sc_hd__decap_3
XFILLER_67_1416 VGND VGND VPWR VPWR sky130_fd_sc_hd__decap_3
XFILLER_67_1449 VGND VGND VPWR VPWR sky130_fd_sc_hd__decap_3
XFILLER_4_974 VGND VGND VPWR VPWR sky130_fd_sc_hd__decap_3
XTAP_TAPCELL_ROW_72_2064 VGND VPWR sky130_fd_sc_hd__tapvpwrvgnd_1
XTAP_TAPCELL_ROW_72_2075 VGND VPWR sky130_fd_sc_hd__tapvpwrvgnd_1
XFILLER_3_495 VGND VGND VPWR VPWR sky130_fd_sc_hd__fill_2
XFILLER_79_753 VGND VGND VPWR VPWR sky130_fd_sc_hd__decap_3
XFILLER_65_1173 VGND VGND VPWR VPWR sky130_fd_sc_hd__decap_3
XFILLER_79_775 VGND VGND VPWR VPWR sky130_fd_sc_hd__decap_3
XFILLER_26_1146 VGND VGND VPWR VPWR sky130_fd_sc_hd__fill_2
XFILLER_67_915 VGND VGND VPWR VPWR sky130_fd_sc_hd__decap_3
XFILLER_6_1229 VGND VGND VPWR VPWR sky130_fd_sc_hd__decap_3
XFILLER_22_6 VGND VGND VPWR VPWR sky130_fd_sc_hd__decap_3
XFILLER_39_617 VGND VGND VPWR VPWR sky130_fd_sc_hd__fill_1
XFILLER_26_1179 VGND VGND VPWR VPWR sky130_fd_sc_hd__fill_1
XFILLER_43_1460 VGND VGND VPWR VPWR sky130_fd_sc_hd__decap_3
XFILLER_38_138 VGND VGND VPWR VPWR sky130_fd_sc_hd__fill_2
XFILLER_19_330 VGND VGND VPWR VPWR sky130_fd_sc_hd__decap_3
XFILLER_66_469 VGND VGND VPWR VPWR sky130_fd_sc_hd__decap_3
XFILLER_75_970 VGND VGND VPWR VPWR sky130_fd_sc_hd__decap_3
XFILLER_53_119 VGND VGND VPWR VPWR sky130_fd_sc_hd__decap_3
XFILLER_74_1409 VGND VGND VPWR VPWR sky130_fd_sc_hd__decap_3
XFILLER_34_344 VGND VGND VPWR VPWR sky130_fd_sc_hd__fill_1
X_5830_ _5904_/A0 _5830_/A1 _5831_/S VGND VGND VPWR VPWR _6848_/D sky130_fd_sc_hd__mux2_1
XFILLER_34_377 VGND VGND VPWR VPWR sky130_fd_sc_hd__fill_1
XFILLER_22_528 VGND VGND VPWR VPWR sky130_fd_sc_hd__decap_3
X_5761_ _5791_/C _5761_/A1 _5766_/S VGND VGND VPWR VPWR _6804_/D sky130_fd_sc_hd__mux2_1
XFILLER_76_1291 VGND VGND VPWR VPWR sky130_fd_sc_hd__decap_3
XFILLER_37_1242 VGND VGND VPWR VPWR sky130_fd_sc_hd__decap_3
XFILLER_50_848 VGND VGND VPWR VPWR sky130_fd_sc_hd__fill_1
XFILLER_72_1144 VGND VGND VPWR VPWR sky130_fd_sc_hd__decap_3
XFILLER_15_591 VGND VGND VPWR VPWR sky130_fd_sc_hd__fill_1
XFILLER_72_1155 VGND VGND VPWR VPWR sky130_fd_sc_hd__decap_3
X_4712_ _4888_/C1 _4709_/X _4710_/Y _4711_/X _4889_/A VGND VGND VPWR VPWR _4712_/X
+ sky130_fd_sc_hd__o221a_2
XFILLER_37_1275 VGND VGND VPWR VPWR sky130_fd_sc_hd__decap_3
XFILLER_30_550 VGND VGND VPWR VPWR sky130_fd_sc_hd__decap_3
XFILLER_33_1117 VGND VGND VPWR VPWR sky130_fd_sc_hd__decap_3
X_5692_ _5692_/A0 _5904_/A0 _5693_/S VGND VGND VPWR VPWR _6744_/D sky130_fd_sc_hd__mux2_1
XFILLER_72_1188 VGND VGND VPWR VPWR sky130_fd_sc_hd__decap_3
XTAP_TAPCELL_ROW_20_718 VGND VPWR sky130_fd_sc_hd__tapvpwrvgnd_1
XFILLER_33_1139 VGND VGND VPWR VPWR sky130_fd_sc_hd__fill_2
XTAP_TAPCELL_ROW_20_729 VGND VPWR sky130_fd_sc_hd__tapvpwrvgnd_1
X_4643_ _6308_/Q _4642_/X wire60/X VGND VGND VPWR VPWR _6308_/D sky130_fd_sc_hd__mux2_1
XTAP_TAPCELL_ROW_61_1790 VGND VPWR sky130_fd_sc_hd__tapvpwrvgnd_1
XFILLER_11_1404 VGND VGND VPWR VPWR sky130_fd_sc_hd__decap_3
XFILLER_50_1453 VGND VGND VPWR VPWR sky130_fd_sc_hd__decap_3
XFILLER_11_1437 VGND VGND VPWR VPWR sky130_fd_sc_hd__decap_3
X_4574_ _4597_/A _4574_/B _4574_/C VGND VGND VPWR VPWR _4574_/X sky130_fd_sc_hd__and3_2
X_6313_ _7051_/CLK _6313_/D load_slew810/X VGND VGND VPWR VPWR _6313_/Q sky130_fd_sc_hd__dfrtp_2
X_3525_ _6238_/Q _5591_/A2 _5600_/A2 _6318_/Q _4532_/B VGND VGND VPWR VPWR _3525_/X
+ sky130_fd_sc_hd__a221o_2
X_6244_ _7001_/CLK _6244_/D fanout768/A VGND VGND VPWR VPWR _6244_/Q sky130_fd_sc_hd__dfrtp_2
X_3456_ _6339_/Q _6459_/Q VGND VGND VPWR VPWR _3456_/X sky130_fd_sc_hd__xor2_2
XFILLER_48_1371 VGND VGND VPWR VPWR sky130_fd_sc_hd__fill_1
XFILLER_48_1382 VGND VGND VPWR VPWR sky130_fd_sc_hd__decap_3
X_3387_ hold990/X _3386_/X _3435_/S VGND VGND VPWR VPWR _6167_/D sky130_fd_sc_hd__mux2_1
X_6175_ _7077_/CLK _6175_/D load_slew692/X VGND VGND VPWR VPWR _6175_/Q sky130_fd_sc_hd__dfrtp_2
XFILLER_44_1246 VGND VGND VPWR VPWR sky130_fd_sc_hd__decap_3
Xhold1402 _6558_/Q VGND VGND VPWR VPWR _5446_/A1 sky130_fd_sc_hd__dlygate4sd3_1
Xload_slew660 fanout659/X VGND VGND VPWR VPWR fanout657/A sky130_fd_sc_hd__clkbuf_2
XFILLER_58_937 VGND VGND VPWR VPWR sky130_fd_sc_hd__decap_3
X_5126_ _6617_/Q _6657_/Q VGND VGND VPWR VPWR _5127_/B sky130_fd_sc_hd__xnor2_2
Xhold1413 _6484_/Q VGND VGND VPWR VPWR _5372_/A1 sky130_fd_sc_hd__dlygate4sd3_1
Xload_slew671 fanout670/X VGND VGND VPWR VPWR load_slew671/X sky130_fd_sc_hd__clkbuf_4
Xhold1424 _6584_/Q VGND VGND VPWR VPWR _5472_/A1 sky130_fd_sc_hd__dlygate4sd3_1
XFILLER_44_1279 VGND VGND VPWR VPWR sky130_fd_sc_hd__decap_3
Xhold1435 _6591_/Q VGND VGND VPWR VPWR _5479_/A1 sky130_fd_sc_hd__dlygate4sd3_1
Xhold1446 _6587_/Q VGND VGND VPWR VPWR _5475_/A1 sky130_fd_sc_hd__dlygate4sd3_1
Xhold1457 _6740_/Q VGND VGND VPWR VPWR _5688_/A0 sky130_fd_sc_hd__dlygate4sd3_1
XFILLER_57_458 VGND VGND VPWR VPWR sky130_fd_sc_hd__decap_3
Xhold1468 _6739_/Q VGND VGND VPWR VPWR _5687_/A0 sky130_fd_sc_hd__dlygate4sd3_1
X_5057_ _6430_/Q _5057_/B VGND VGND VPWR VPWR _5264_/B sky130_fd_sc_hd__xnor2_2
Xhold1479 _6486_/Q VGND VGND VPWR VPWR _5374_/A1 sky130_fd_sc_hd__dlygate4sd3_1
XFILLER_26_801 VGND VGND VPWR VPWR sky130_fd_sc_hd__decap_3
X_4008_ _4008_/A _4008_/B VGND VGND VPWR VPWR _4008_/Y sky130_fd_sc_hd__nand2_2
XFILLER_53_620 VGND VGND VPWR VPWR sky130_fd_sc_hd__fill_1
XTAP_TAPCELL_ROW_68_1966 VGND VPWR sky130_fd_sc_hd__tapvpwrvgnd_1
XTAP_TAPCELL_ROW_68_1977 VGND VPWR sky130_fd_sc_hd__tapvpwrvgnd_1
XFILLER_26_867 VGND VGND VPWR VPWR sky130_fd_sc_hd__fill_1
XFILLER_52_130 VGND VGND VPWR VPWR sky130_fd_sc_hd__decap_3
XFILLER_0_1351 VGND VGND VPWR VPWR sky130_fd_sc_hd__decap_3
XFILLER_38_1017 VGND VGND VPWR VPWR sky130_fd_sc_hd__decap_3
XFILLER_41_804 VGND VGND VPWR VPWR sky130_fd_sc_hd__decap_3
XFILLER_77_1077 VGND VGND VPWR VPWR sky130_fd_sc_hd__decap_3
XFILLER_26_889 VGND VGND VPWR VPWR sky130_fd_sc_hd__fill_1
XFILLER_52_141 VGND VGND VPWR VPWR sky130_fd_sc_hd__decap_3
XFILLER_13_517 VGND VGND VPWR VPWR sky130_fd_sc_hd__decap_3
XFILLER_0_1373 VGND VGND VPWR VPWR sky130_fd_sc_hd__decap_3
XFILLER_80_472 VGND VGND VPWR VPWR sky130_fd_sc_hd__decap_3
XFILLER_25_388 VGND VGND VPWR VPWR sky130_fd_sc_hd__decap_3
XFILLER_71_27 VGND VGND VPWR VPWR sky130_fd_sc_hd__decap_3
XFILLER_25_399 VGND VGND VPWR VPWR sky130_fd_sc_hd__decap_3
XFILLER_55_1331 VGND VGND VPWR VPWR sky130_fd_sc_hd__decap_3
XFILLER_80_494 VGND VGND VPWR VPWR sky130_fd_sc_hd__decap_3
X_5959_ hold884/X hold980/X _6015_/S VGND VGND VPWR VPWR _6963_/D sky130_fd_sc_hd__mux2_1
XFILLER_16_1315 VGND VGND VPWR VPWR sky130_fd_sc_hd__fill_1
XFILLER_16_1326 VGND VGND VPWR VPWR sky130_fd_sc_hd__decap_3
XFILLER_55_1375 VGND VGND VPWR VPWR sky130_fd_sc_hd__decap_3
XFILLER_21_561 VGND VGND VPWR VPWR sky130_fd_sc_hd__fill_1
XFILLER_16_1359 VGND VGND VPWR VPWR sky130_fd_sc_hd__decap_3
XFILLER_51_1239 VGND VGND VPWR VPWR sky130_fd_sc_hd__decap_3
XFILLER_21_583 VGND VGND VPWR VPWR sky130_fd_sc_hd__decap_3
XFILLER_21_594 VGND VGND VPWR VPWR sky130_fd_sc_hd__decap_3
XFILLER_14_1061 VGND VGND VPWR VPWR sky130_fd_sc_hd__decap_3
XFILLER_49_1124 VGND VGND VPWR VPWR sky130_fd_sc_hd__fill_1
XFILLER_4_248 VGND VGND VPWR VPWR sky130_fd_sc_hd__decap_3
XFILLER_49_1146 VGND VGND VPWR VPWR sky130_fd_sc_hd__decap_3
XFILLER_1_900 VGND VGND VPWR VPWR sky130_fd_sc_hd__decap_3
XFILLER_1_933 VGND VGND VPWR VPWR sky130_fd_sc_hd__decap_3
XFILLER_0_421 VGND VGND VPWR VPWR sky130_fd_sc_hd__decap_3
XFILLER_27_1422 VGND VGND VPWR VPWR sky130_fd_sc_hd__decap_3
XFILLER_49_904 VGND VGND VPWR VPWR sky130_fd_sc_hd__decap_3
XFILLER_1_977 VGND VGND VPWR VPWR sky130_fd_sc_hd__decap_3
XFILLER_27_1455 VGND VGND VPWR VPWR sky130_fd_sc_hd__fill_1
XFILLER_62_1335 VGND VGND VPWR VPWR sky130_fd_sc_hd__decap_3
XFILLER_76_701 VGND VGND VPWR VPWR sky130_fd_sc_hd__decap_3
XFILLER_27_1466 VGND VGND VPWR VPWR sky130_fd_sc_hd__decap_3
XFILLER_48_414 VGND VGND VPWR VPWR sky130_fd_sc_hd__decap_3
XFILLER_23_1319 VGND VGND VPWR VPWR sky130_fd_sc_hd__decap_3
XFILLER_49_948 VGND VGND VPWR VPWR sky130_fd_sc_hd__decap_3
XFILLER_62_1368 VGND VGND VPWR VPWR sky130_fd_sc_hd__decap_3
XFILLER_76_745 VGND VGND VPWR VPWR sky130_fd_sc_hd__decap_3
XFILLER_0_498 VGND VGND VPWR VPWR sky130_fd_sc_hd__decap_3
XFILLER_49_959 VGND VGND VPWR VPWR sky130_fd_sc_hd__decap_3
XFILLER_62_1379 VGND VGND VPWR VPWR sky130_fd_sc_hd__decap_3
XFILLER_76_778 VGND VGND VPWR VPWR sky130_fd_sc_hd__decap_3
XFILLER_5_1251 VGND VGND VPWR VPWR sky130_fd_sc_hd__decap_3
XFILLER_1_1104 VGND VGND VPWR VPWR sky130_fd_sc_hd__decap_3
XFILLER_29_661 VGND VGND VPWR VPWR sky130_fd_sc_hd__decap_3
XTAP_TAPCELL_ROW_3_270 VGND VPWR sky130_fd_sc_hd__tapvpwrvgnd_1
XFILLER_5_1284 VGND VGND VPWR VPWR sky130_fd_sc_hd__decap_3
XFILLER_5_1295 VGND VGND VPWR VPWR sky130_fd_sc_hd__decap_3
XTAP_TAPCELL_ROW_3_281 VGND VPWR sky130_fd_sc_hd__tapvpwrvgnd_1
XFILLER_17_834 VGND VGND VPWR VPWR sky130_fd_sc_hd__decap_3
XFILLER_63_439 VGND VGND VPWR VPWR sky130_fd_sc_hd__fill_1
XFILLER_21_1065 VGND VGND VPWR VPWR sky130_fd_sc_hd__fill_1
XFILLER_1_1148 VGND VGND VPWR VPWR sky130_fd_sc_hd__decap_3
XFILLER_56_491 VGND VGND VPWR VPWR sky130_fd_sc_hd__decap_3
XFILLER_44_642 VGND VGND VPWR VPWR sky130_fd_sc_hd__fill_2
XTAP_TAPCELL_ROW_80_2300 VGND VPWR sky130_fd_sc_hd__tapvpwrvgnd_1
XTAP_TAPCELL_ROW_80_2311 VGND VPWR sky130_fd_sc_hd__tapvpwrvgnd_1
XFILLER_32_804 VGND VGND VPWR VPWR sky130_fd_sc_hd__fill_1
XFILLER_44_664 VGND VGND VPWR VPWR sky130_fd_sc_hd__decap_3
XFILLER_56_1128 VGND VGND VPWR VPWR sky130_fd_sc_hd__decap_3
XFILLER_32_826 VGND VGND VPWR VPWR sky130_fd_sc_hd__decap_3
XFILLER_32_837 VGND VGND VPWR VPWR sky130_fd_sc_hd__fill_1
XFILLER_44_697 VGND VGND VPWR VPWR sky130_fd_sc_hd__decap_3
XFILLER_16_399 VGND VGND VPWR VPWR sky130_fd_sc_hd__decap_3
XTAP_TAPCELL_ROW_27_895 VGND VPWR sky130_fd_sc_hd__tapvpwrvgnd_1
XFILLER_73_1431 VGND VGND VPWR VPWR sky130_fd_sc_hd__decap_3
XFILLER_31_325 VGND VGND VPWR VPWR sky130_fd_sc_hd__decap_3
XFILLER_43_196 VGND VGND VPWR VPWR sky130_fd_sc_hd__decap_3
XFILLER_31_358 VGND VGND VPWR VPWR sky130_fd_sc_hd__decap_3
XFILLER_34_1415 VGND VGND VPWR VPWR sky130_fd_sc_hd__decap_3
XTAP_TAPCELL_ROW_14_556 VGND VPWR sky130_fd_sc_hd__tapvpwrvgnd_1
XTAP_TAPCELL_ROW_14_567 VGND VPWR sky130_fd_sc_hd__tapvpwrvgnd_1
XFILLER_8_510 VGND VGND VPWR VPWR sky130_fd_sc_hd__decap_3
XFILLER_34_1459 VGND VGND VPWR VPWR sky130_fd_sc_hd__decap_3
XTAP_TAPCELL_ROW_78_2240 VGND VPWR sky130_fd_sc_hd__tapvpwrvgnd_1
XFILLER_8_554 VGND VGND VPWR VPWR sky130_fd_sc_hd__decap_3
XPHY_EDGE_ROW_20_Left_101 VGND VGND VPWR VPWR sky130_fd_sc_hd__decap_3
XFILLER_8_587 VGND VGND VPWR VPWR sky130_fd_sc_hd__fill_1
XTAP_TAPCELL_ROW_74_2115 VGND VPWR sky130_fd_sc_hd__tapvpwrvgnd_1
XFILLER_8_598 VGND VGND VPWR VPWR sky130_fd_sc_hd__fill_2
XTAP_TAPCELL_ROW_74_2126 VGND VPWR sky130_fd_sc_hd__tapvpwrvgnd_1
XANTENNA_4 _3092_/Y VGND VGND VPWR VPWR sky130_fd_sc_hd__diode_2
XTAP_TAPCELL_ROW_74_2137 VGND VPWR sky130_fd_sc_hd__tapvpwrvgnd_1
XFILLER_6_55 VGND VGND VPWR VPWR sky130_fd_sc_hd__decap_3
XFILLER_67_1213 VGND VGND VPWR VPWR sky130_fd_sc_hd__decap_3
XFILLER_6_88 VGND VGND VPWR VPWR sky130_fd_sc_hd__fill_1
X_3310_ _6282_/Q _6386_/Q VGND VGND VPWR VPWR _3310_/X sky130_fd_sc_hd__xor2_2
XFILLER_67_1257 VGND VGND VPWR VPWR sky130_fd_sc_hd__decap_3
X_4290_ _6490_/Q _4267_/X _4289_/X wire154/X _4880_/C1 VGND VGND VPWR VPWR _4290_/X
+ sky130_fd_sc_hd__a221o_2
XFILLER_3_281 VGND VGND VPWR VPWR sky130_fd_sc_hd__decap_3
X_3241_ _5941_/A0 _3240_/X _3385_/S VGND VGND VPWR VPWR _6094_/D sky130_fd_sc_hd__mux2_1
XFILLER_80_1413 VGND VGND VPWR VPWR sky130_fd_sc_hd__decap_3
XFILLER_79_550 VGND VGND VPWR VPWR sky130_fd_sc_hd__fill_2
XFILLER_80_1435 VGND VGND VPWR VPWR sky130_fd_sc_hd__decap_3
XFILLER_20_3 VGND VGND VPWR VPWR sky130_fd_sc_hd__decap_3
XFILLER_80_1457 VGND VGND VPWR VPWR sky130_fd_sc_hd__decap_3
X_3172_ _7014_/Q _7022_/Q _3172_/S VGND VGND VPWR VPWR _3172_/X sky130_fd_sc_hd__mux2_1
XFILLER_66_200 VGND VGND VPWR VPWR sky130_fd_sc_hd__decap_3
XFILLER_39_425 VGND VGND VPWR VPWR sky130_fd_sc_hd__decap_3
XFILLER_41_1419 VGND VGND VPWR VPWR sky130_fd_sc_hd__decap_3
XFILLER_6_1048 VGND VGND VPWR VPWR sky130_fd_sc_hd__fill_1
XFILLER_66_244 VGND VGND VPWR VPWR sky130_fd_sc_hd__decap_3
XTAP_TAPCELL_ROW_1_218 VGND VPWR sky130_fd_sc_hd__tapvpwrvgnd_1
XTAP_TAPCELL_ROW_1_229 VGND VPWR sky130_fd_sc_hd__tapvpwrvgnd_1
XFILLER_48_981 VGND VGND VPWR VPWR sky130_fd_sc_hd__decap_3
XTAP_TAPCELL_ROW_50_1491 VGND VPWR sky130_fd_sc_hd__tapvpwrvgnd_1
XFILLER_78_1320 VGND VGND VPWR VPWR sky130_fd_sc_hd__decap_3
X_6931_ _7060_/CLK _6931_/D load_slew782/X VGND VGND VPWR VPWR _6931_/Q sky130_fd_sc_hd__dfrtp_2
XFILLER_19_160 VGND VGND VPWR VPWR sky130_fd_sc_hd__fill_2
XFILLER_35_620 VGND VGND VPWR VPWR sky130_fd_sc_hd__fill_2
XFILLER_66_299 VGND VGND VPWR VPWR sky130_fd_sc_hd__decap_3
XFILLER_78_1353 VGND VGND VPWR VPWR sky130_fd_sc_hd__decap_3
XFILLER_39_1304 VGND VGND VPWR VPWR sky130_fd_sc_hd__decap_3
XFILLER_63_951 VGND VGND VPWR VPWR sky130_fd_sc_hd__fill_1
X_6862_ _6982_/CLK _6862_/D fanout745/X VGND VGND VPWR VPWR _6862_/Q sky130_fd_sc_hd__dfrtp_2
XFILLER_34_141 VGND VGND VPWR VPWR sky130_fd_sc_hd__decap_3
XFILLER_35_664 VGND VGND VPWR VPWR sky130_fd_sc_hd__decap_3
XFILLER_74_1217 VGND VGND VPWR VPWR sky130_fd_sc_hd__decap_3
XFILLER_39_1337 VGND VGND VPWR VPWR sky130_fd_sc_hd__decap_3
XFILLER_78_1397 VGND VGND VPWR VPWR sky130_fd_sc_hd__decap_3
XFILLER_39_1348 VGND VGND VPWR VPWR sky130_fd_sc_hd__decap_3
X_5813_ _5923_/A1 _5813_/A1 _5813_/S VGND VGND VPWR VPWR _6833_/D sky130_fd_sc_hd__mux2_1
XFILLER_50_634 VGND VGND VPWR VPWR sky130_fd_sc_hd__decap_3
XTAP_TAPCELL_ROW_63_1830 VGND VPWR sky130_fd_sc_hd__tapvpwrvgnd_1
XFILLER_22_336 VGND VGND VPWR VPWR sky130_fd_sc_hd__decap_3
X_6793_ _6993_/CLK _6793_/D fanout708/X VGND VGND VPWR VPWR _6793_/Q sky130_fd_sc_hd__dfrtp_2
XFILLER_50_645 VGND VGND VPWR VPWR sky130_fd_sc_hd__decap_3
XTAP_TAPCELL_ROW_63_1841 VGND VPWR sky130_fd_sc_hd__tapvpwrvgnd_1
X_5744_ _5910_/A0 _5744_/A1 _5747_/S VGND VGND VPWR VPWR _6789_/D sky130_fd_sc_hd__mux2_1
XFILLER_50_689 VGND VGND VPWR VPWR sky130_fd_sc_hd__fill_2
X_5675_ _5675_/A0 _5801_/C _5675_/S VGND VGND VPWR VPWR _6729_/D sky130_fd_sc_hd__mux2_1
XFILLER_11_1201 VGND VGND VPWR VPWR sky130_fd_sc_hd__decap_3
XFILLER_15_1381 VGND VGND VPWR VPWR sky130_fd_sc_hd__decap_3
X_4626_ _4647_/A1 _4623_/X _4624_/Y _4625_/X _4683_/A VGND VGND VPWR VPWR _4626_/X
+ sky130_fd_sc_hd__o221a_2
XFILLER_50_1261 VGND VGND VPWR VPWR sky130_fd_sc_hd__decap_3
XFILLER_11_1245 VGND VGND VPWR VPWR sky130_fd_sc_hd__decap_3
XFILLER_50_1294 VGND VGND VPWR VPWR sky130_fd_sc_hd__decap_3
X_4557_ _4588_/B _4732_/B _4556_/Y _4763_/C1 VGND VGND VPWR VPWR _4558_/C sky130_fd_sc_hd__o211ai_2
XFILLER_11_1278 VGND VGND VPWR VPWR sky130_fd_sc_hd__decap_3
XFILLER_11_1289 VGND VGND VPWR VPWR sky130_fd_sc_hd__decap_3
XFILLER_2_719 VGND VGND VPWR VPWR sky130_fd_sc_hd__decap_3
X_3508_ _3044_/A _3498_/X _3499_/X _3507_/X _3486_/A VGND VGND VPWR VPWR _3663_/A
+ sky130_fd_sc_hd__a32o_2
X_4488_ _4783_/A _4608_/B _4266_/Y _4487_/X _6520_/Q VGND VGND VPWR VPWR _4488_/X
+ sky130_fd_sc_hd__a32o_2
XTAP_TAPCELL_ROW_57_1678 VGND VPWR sky130_fd_sc_hd__tapvpwrvgnd_1
XTAP_TAPCELL_ROW_57_1689 VGND VPWR sky130_fd_sc_hd__tapvpwrvgnd_1
X_6227_ _7000_/CLK _6227_/D load_slew694/X VGND VGND VPWR VPWR _6227_/Q sky130_fd_sc_hd__dfrtp_2
X_3439_ hold999/X _3438_/X _3455_/S VGND VGND VPWR VPWR _6193_/D sky130_fd_sc_hd__mux2_1
XFILLER_44_1032 VGND VGND VPWR VPWR sky130_fd_sc_hd__decap_3
XFILLER_44_1043 VGND VGND VPWR VPWR sky130_fd_sc_hd__decap_3
X_6158_ _7009_/CLK _6158_/D fanout765/X VGND VGND VPWR VPWR _6158_/Q sky130_fd_sc_hd__dfrtp_2
XFILLER_66_27 VGND VGND VPWR VPWR sky130_fd_sc_hd__fill_1
Xhold1210 _6784_/Q VGND VGND VPWR VPWR _5738_/A1 sky130_fd_sc_hd__dlygate4sd3_1
XFILLER_66_38 VGND VGND VPWR VPWR sky130_fd_sc_hd__decap_3
Xhold1221 _6863_/Q VGND VGND VPWR VPWR _5847_/A0 sky130_fd_sc_hd__dlygate4sd3_1
XFILLER_44_1076 VGND VGND VPWR VPWR sky130_fd_sc_hd__decap_3
Xhold1232 _6717_/Q VGND VGND VPWR VPWR _5662_/A1 sky130_fd_sc_hd__dlygate4sd3_1
X_5109_ _6372_/Q _5106_/X _5108_/X _5345_/S VGND VGND VPWR VPWR _6372_/D sky130_fd_sc_hd__a22o_2
Xhold1243 _6789_/Q VGND VGND VPWR VPWR _5744_/A1 sky130_fd_sc_hd__dlygate4sd3_1
XFILLER_46_918 VGND VGND VPWR VPWR sky130_fd_sc_hd__decap_3
XFILLER_79_1106 VGND VGND VPWR VPWR sky130_fd_sc_hd__decap_3
Xhold1254 _6787_/Q VGND VGND VPWR VPWR _5742_/A1 sky130_fd_sc_hd__dlygate4sd3_1
X_6089_ _6943_/CLK _6089_/D fanout833/X VGND VGND VPWR VPWR _6089_/Q sky130_fd_sc_hd__dfrtp_2
XFILLER_73_726 VGND VGND VPWR VPWR sky130_fd_sc_hd__fill_2
Xhold1265 _6051_/X VGND VGND VPWR VPWR _7055_/D sky130_fd_sc_hd__dlygate4sd3_1
XFILLER_22_1341 VGND VGND VPWR VPWR sky130_fd_sc_hd__decap_3
XFILLER_61_1390 VGND VGND VPWR VPWR sky130_fd_sc_hd__decap_3
XFILLER_79_1139 VGND VGND VPWR VPWR sky130_fd_sc_hd__decap_3
XFILLER_2_1424 VGND VGND VPWR VPWR sky130_fd_sc_hd__decap_3
Xhold1276 _7057_/Q VGND VGND VPWR VPWR _6053_/A1 sky130_fd_sc_hd__dlygate4sd3_1
XFILLER_72_214 VGND VGND VPWR VPWR sky130_fd_sc_hd__fill_1
Xhold1287 _6758_/Q VGND VGND VPWR VPWR _5709_/A1 sky130_fd_sc_hd__dlygate4sd3_1
XFILLER_2_1435 VGND VGND VPWR VPWR sky130_fd_sc_hd__decap_3
Xhold1298 _6894_/Q VGND VGND VPWR VPWR _5884_/A1 sky130_fd_sc_hd__dlygate4sd3_1
XFILLER_45_439 VGND VGND VPWR VPWR sky130_fd_sc_hd__fill_1
XFILLER_22_1385 VGND VGND VPWR VPWR sky130_fd_sc_hd__decap_3
XFILLER_38_480 VGND VGND VPWR VPWR sky130_fd_sc_hd__decap_3
XFILLER_2_1468 VGND VGND VPWR VPWR sky130_fd_sc_hd__fill_1
XFILLER_57_1404 VGND VGND VPWR VPWR sky130_fd_sc_hd__decap_3
XPHY_EDGE_ROW_11_Left_92 VGND VGND VPWR VPWR sky130_fd_sc_hd__decap_3
XFILLER_57_1437 VGND VGND VPWR VPWR sky130_fd_sc_hd__decap_3
XFILLER_53_472 VGND VGND VPWR VPWR sky130_fd_sc_hd__decap_3
XFILLER_0_1170 VGND VGND VPWR VPWR sky130_fd_sc_hd__decap_3
XFILLER_14_848 VGND VGND VPWR VPWR sky130_fd_sc_hd__decap_3
XFILLER_13_325 VGND VGND VPWR VPWR sky130_fd_sc_hd__decap_3
XTAP_TAPCELL_ROW_24_821 VGND VPWR sky130_fd_sc_hd__tapvpwrvgnd_1
XFILLER_0_1192 VGND VGND VPWR VPWR sky130_fd_sc_hd__decap_3
XTAP_TAPCELL_ROW_24_832 VGND VPWR sky130_fd_sc_hd__tapvpwrvgnd_1
XFILLER_15_53 VGND VGND VPWR VPWR sky130_fd_sc_hd__decap_3
XFILLER_40_133 VGND VGND VPWR VPWR sky130_fd_sc_hd__decap_3
XFILLER_40_144 VGND VGND VPWR VPWR sky130_fd_sc_hd__fill_1
XFILLER_55_1150 VGND VGND VPWR VPWR sky130_fd_sc_hd__decap_3
XFILLER_55_1172 VGND VGND VPWR VPWR sky130_fd_sc_hd__decap_3
XFILLER_40_166 VGND VGND VPWR VPWR sky130_fd_sc_hd__decap_3
XFILLER_40_188 VGND VGND VPWR VPWR sky130_fd_sc_hd__decap_3
XFILLER_16_1178 VGND VGND VPWR VPWR sky130_fd_sc_hd__decap_3
XFILLER_21_391 VGND VGND VPWR VPWR sky130_fd_sc_hd__fill_1
XFILLER_51_1058 VGND VGND VPWR VPWR sky130_fd_sc_hd__decap_3
XFILLER_5_535 VGND VGND VPWR VPWR sky130_fd_sc_hd__decap_3
XFILLER_5_557 VGND VGND VPWR VPWR sky130_fd_sc_hd__decap_3
XFILLER_5_579 VGND VGND VPWR VPWR sky130_fd_sc_hd__fill_1
XFILLER_1_741 VGND VGND VPWR VPWR sky130_fd_sc_hd__decap_3
XFILLER_27_1230 VGND VGND VPWR VPWR sky130_fd_sc_hd__fill_2
XFILLER_7_1313 VGND VGND VPWR VPWR sky130_fd_sc_hd__decap_3
XFILLER_0_240 VGND VGND VPWR VPWR sky130_fd_sc_hd__decap_3
XFILLER_62_1121 VGND VGND VPWR VPWR sky130_fd_sc_hd__decap_3
XFILLER_1_774 VGND VGND VPWR VPWR sky130_fd_sc_hd__decap_3
XFILLER_0_262 VGND VGND VPWR VPWR sky130_fd_sc_hd__decap_3
XFILLER_1_785 VGND VGND VPWR VPWR sky130_fd_sc_hd__decap_3
XFILLER_27_1263 VGND VGND VPWR VPWR sky130_fd_sc_hd__decap_3
XFILLER_48_200 VGND VGND VPWR VPWR sky130_fd_sc_hd__decap_3
XFILLER_76_520 VGND VGND VPWR VPWR sky130_fd_sc_hd__decap_3
XFILLER_7_1357 VGND VGND VPWR VPWR sky130_fd_sc_hd__decap_3
XFILLER_0_284 VGND VGND VPWR VPWR sky130_fd_sc_hd__decap_3
XFILLER_49_756 VGND VGND VPWR VPWR sky130_fd_sc_hd__decap_3
XFILLER_40_1441 VGND VGND VPWR VPWR sky130_fd_sc_hd__decap_3
XFILLER_36_417 VGND VGND VPWR VPWR sky130_fd_sc_hd__decap_3
XFILLER_56_82 VGND VGND VPWR VPWR sky130_fd_sc_hd__fill_2
XFILLER_5_1092 VGND VGND VPWR VPWR sky130_fd_sc_hd__decap_3
XFILLER_63_269 VGND VGND VPWR VPWR sky130_fd_sc_hd__decap_3
XFILLER_16_141 VGND VGND VPWR VPWR sky130_fd_sc_hd__fill_2
XFILLER_16_152 VGND VGND VPWR VPWR sky130_fd_sc_hd__decap_3
XFILLER_32_601 VGND VGND VPWR VPWR sky130_fd_sc_hd__decap_3
XFILLER_32_623 VGND VGND VPWR VPWR sky130_fd_sc_hd__fill_1
XFILLER_34_1201 VGND VGND VPWR VPWR sky130_fd_sc_hd__decap_3
XFILLER_72_81 VGND VGND VPWR VPWR sky130_fd_sc_hd__decap_3
XFILLER_73_1272 VGND VGND VPWR VPWR sky130_fd_sc_hd__decap_3
X_3790_ _3789_/A _3789_/B _3789_/C VGND VGND VPWR VPWR _3888_/B sky130_fd_sc_hd__o21ai_2
XFILLER_31_166 VGND VGND VPWR VPWR sky130_fd_sc_hd__fill_2
XFILLER_13_881 VGND VGND VPWR VPWR sky130_fd_sc_hd__fill_2
XFILLER_31_188 VGND VGND VPWR VPWR sky130_fd_sc_hd__decap_3
XFILLER_34_1245 VGND VGND VPWR VPWR sky130_fd_sc_hd__decap_3
XFILLER_9_841 VGND VGND VPWR VPWR sky130_fd_sc_hd__decap_3
XFILLER_34_1267 VGND VGND VPWR VPWR sky130_fd_sc_hd__decap_3
XFILLER_9_874 VGND VGND VPWR VPWR sky130_fd_sc_hd__decap_3
X_5460_ _5460_/A1 _5461_/A2 _4756_/X VGND VGND VPWR VPWR _6572_/D sky130_fd_sc_hd__a21o_2
XFILLER_68_3 VGND VGND VPWR VPWR sky130_fd_sc_hd__decap_3
XFILLER_69_1319 VGND VGND VPWR VPWR sky130_fd_sc_hd__decap_3
X_4411_ _3915_/A _3915_/B _4586_/C _5508_/A VGND VGND VPWR VPWR _4768_/C sky130_fd_sc_hd__o211a_2
X_5391_ _5391_/A1 _5487_/A2 _3954_/X VGND VGND VPWR VPWR _6503_/D sky130_fd_sc_hd__a21o_2
X_4342_ _6832_/Q _4833_/A2 _4833_/B1 _4341_/X VGND VGND VPWR VPWR _4342_/X sky130_fd_sc_hd__a211o_2
XFILLER_67_1054 VGND VGND VPWR VPWR sky130_fd_sc_hd__decap_3
XFILLER_67_1065 VGND VGND VPWR VPWR sky130_fd_sc_hd__fill_1
Xfanout308 _3180_/A1 VGND VGND VPWR VPWR _3193_/A1 sky130_fd_sc_hd__clkdlybuf4s25_1
X_7061_ _7095_/CLK _7061_/D load_slew696/X VGND VGND VPWR VPWR _7061_/Q sky130_fd_sc_hd__dfrtp_2
Xfanout319 _3092_/Y VGND VGND VPWR VPWR _4319_/A2 sky130_fd_sc_hd__clkdlybuf4s25_1
X_4273_ _6488_/Q _3483_/A _4788_/A _4272_/X VGND VGND VPWR VPWR _4273_/X sky130_fd_sc_hd__o211a_2
X_6012_ hold866/X _7016_/Q _6044_/S VGND VGND VPWR VPWR _6012_/X sky130_fd_sc_hd__mux2_1
XTAP_TAPCELL_ROW_52_1542 VGND VPWR sky130_fd_sc_hd__tapvpwrvgnd_1
XFILLER_45_1363 VGND VGND VPWR VPWR sky130_fd_sc_hd__decap_3
XTAP_TAPCELL_ROW_52_1553 VGND VPWR sky130_fd_sc_hd__tapvpwrvgnd_1
X_3224_ _3202_/A _3220_/X _3223_/X _3217_/X VGND VGND VPWR VPWR _3224_/X sky130_fd_sc_hd__a31o_2
.ends
